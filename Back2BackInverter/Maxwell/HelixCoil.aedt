# Ansys Electronics Desktop project, version 2024.2
materials:
  vacuum: permittivity=1
  copper: permeability=0.999991 conductivity=58000000

design Maxwell3DDesign1 (Maxwell 3D, Magnetostatic, model units mm)
variables:
  wire_radius = 8mm
  number_of_turns = 40
  pitch = 3*wire_radius
  helix_radius = 100mm
  boundary_height = 2*2*number_of_turns*pitch
  boundary_width = 6*helix_radius
  mesh_length = 3mm
geometry:
  Coil = user_primitive(SegmentedHelix/PolygonHelix.dll, PolygonSegments=0, PolygonRadius=wire_radius, StartHelixRadius=helix_radius, RadiusChange=0mm, Pitch=pitch, Turns=number_of_turns, SegmentsPerTurn=36, RightHanded=1)
  Boundary [vacuum] = box(corner=(-boundary_width/2, -boundary_width/2, -boundary_height/2+number_of_turns*pitch/2), size=(boundary_width, boundary_width, boundary_height))
  CoilInput1 [copper] = cylinder(axis=Y, base_centre=(helix_radius, 0mm, 0mm), radius=wire_radius, height=-6*helix_radius)
  CoilInput2 = cylinder(axis=Y, base_centre=(helix_radius, 0mm, pitch*number_of_turns), radius=wire_radius, height=6*helix_radius)
  CoilInput2.split(plane=Boundary_1.face(5 of 6), keep=PositiveOnly)
  Boundary_1 = Boundary.copy()
  Boundary_1.delete()
  CoilInput1.split(plane=Boundary_2.face(3 of 6), keep=PositiveOnly)
  Boundary_2 = Boundary.copy()
  Boundary_2.delete()
  CoilInput1.unite(CoilInput2, Coil)
boundaries and excitations:
  CurrentIn: Coil Terminal Faces=CoilInput1.face(at (100, -300, 0)) Conductor_number=number_of_turns Winding=Winding1 Point_out_of_terminal=false
  CurrentOut: Coil Terminal Faces=CoilInput1.face(at (100, 300, 960)) Conductor_number=number_of_turns Winding=Winding1 Point_out_of_terminal=true
  Winding1: Winding Group Type=Current IsSolid=false Current=300A ParallelBranchesNum=4
parameters:
  Matrix1: Matrix Winding1: NumberOfTurns=1
mesh:
  Length1: LengthBased Objects=CoilInput1 MaxLength=mesh_length
  initial mesh: GlobalCurvilinear{Apply}
setups:
  Setup1: Magnetostatic MaximumPasses=10 MinimumPasses=2 MinimumConvergedPasses=1 PercentRefinement=30 PercentError=1 NonLinearResidual=0.001
