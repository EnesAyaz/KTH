# Ansys Electronics Desktop project, version 2024.2
materials:
  vacuum: permittivity=1
  copper: permeability=0.999991 conductivity=58000000

design BB_PL_GATE_dpt (Q3D Extractor, model units mm)
options: SParamCalcMethod=EqTransLine Calculate_Lossy_Dielectrics
geometry:
  P0_DCN_L1 [copper] = polyline(z=0.17mm, xy in mm: (-28.6908, 12.9189) (-28.6689, 16.7592) (-34.5, 16.8) (-34.5, 20.101) (-34.5684, 20.1952) (-43.551, 20.2) (-43.6452, 20.1316) (-43.65, 12.999) (-43.5816, 12.9048) (-28.749, 12.9) (-28.6908, 12.9189), closed, covered)
  P0_DCN_L1.sweep_along_vector((0mm, 0mm, 0.07mm))
  P1_DCN_L1 = polyline(z=0.17mm, xy in mm: (-3.8908, 12.9189) (-3.85, 20.101) (-3.9184, 20.1952) (-12.901, 20.2) (-13, 20.101) (-13, 16.8) (-18.751, 16.8) (-18.8452, 16.7316) (-18.85, 12.999) (-18.7816, 12.9048) (-3.949, 12.9) (-3.8908, 12.9189), closed, covered)
  P1_DCN_L1.sweep_along_vector((0mm, 0mm, 0.07mm))
  P2_DCN_L1 = polyline(z=0.17mm, xy in mm: (-1.5, 0.9) (-39.651, 0.9) (-39.75, 0.801) (-39.75, -4.101) (-39.651, -4.2) (-1.5, -4.2) (-1.5, 0.9), closed, covered)
  P2_DCN_L1.sweep_along_vector((0mm, 0mm, 0.07mm))
  P3_DCN_L2 = polyline(z=0mm, xy in mm: (-1.5, 20.6) (-8.4402, 20.5495) (-11.5093, 20.6) (-11.85, 20.5444) (-13.876, 20.5945) (-14, 20.4705) (-14, 17.6) (-18.793, 17.5803) (-18.85, 17.476) (-18.85, 11.9) (-19.093, 11.8803) (-19.15, 11.776) (-19.15, 10) (-20.1348, 10) (-20.3643, 9.9318) (-20.4492, 9.828) (-20.45, 3.3) (-25.1969, 3.3) (-25.55, 3.1692) (-25.9031, 3.3) (-27.05, 3.3) (-27.05, 7.5883) (-27.1916, 7.711) (-27.6169, 7.4903) (-27.8831, 7.4903) (-28.1597, 7.7669) (-28.1597, 8.0331) (-28.0032, 8.2485) (-27.078, 8.5076) (-27.05, 9.876) (-27.174, 10) (-28.35, 10) (-28.35, 11.776) (-28.4225, 11.8888) (-28.65, 11.9) (-28.6697, 17.543) (-28.774, 17.6) (-33.5, 17.6) (-33.5, 20.4705) (-33.624, 20.5945) (-43.993, 20.5803) (-44.05, 20.476) (-44.0303, 11.957) (-43.926, 11.9) (-39.75, 11.9) (-39.75, -4.6) (-1.5, -4.6) (-1.5, 20.6), closed, covered)
  P3_DCN_L2_h0 = polyline(z=0mm, xy in mm: (-37.3503, 11.4144) (-37.6106, 11.6747) (-37.6106, 11.9253) (-37.4633, 12.1281) (-37.0997, 12.1856) (-36.897, 12.0383) (-36.8195, 11.8) (-36.897, 11.5617) (-37.225, 11.3945) (-37.3503, 11.4144), closed, covered)
  P3_DCN_L2_h1 = polyline(z=0mm, xy in mm: (-10.4003, 11.4144) (-10.6606, 11.6747) (-10.6606, 11.9253) (-10.5133, 12.1281) (-10.1497, 12.1856) (-9.9469, 12.0383) (-9.8695, 11.8) (-9.9469, 11.5617) (-10.275, 11.3945) (-10.4003, 11.4144), closed, covered)
  P3_DCN_L2_h2 = polyline(z=0mm, xy in mm: (-17.5375, 10.3334) (-17.7276, 10.4715) (-17.7816, 10.8125) (-17.6435, 11.0026) (-17.3025, 11.0566) (-17.1124, 10.9185) (-17.0584, 10.5775) (-17.1965, 10.3874) (-17.42, 10.3148) (-17.5375, 10.3334), closed, covered)
  P3_DCN_L2_h3 = polyline(z=0mm, xy in mm: (-30.1975, 10.0684) (-30.3876, 10.2065) (-30.4416, 10.5475) (-30.3035, 10.7376) (-29.9625, 10.7916) (-29.7724, 10.6535) (-29.7184, 10.3125) (-29.8565, 10.1224) (-30.08, 10.0498) (-30.1975, 10.0684), closed, covered)
  P3_DCN_L2_h4 = polyline(z=0mm, xy in mm: (-17.5375, 7.6084) (-17.7276, 7.7465) (-17.7816, 8.0875) (-17.6435, 8.2776) (-17.3025, 8.3316) (-17.1124, 8.1935) (-17.0584, 7.8525) (-17.1965, 7.6624) (-17.42, 7.5898) (-17.5375, 7.6084), closed, covered)
  P3_DCN_L2_h5 = polyline(z=0mm, xy in mm: (-30.1975, 7.3434) (-30.3876, 7.4815) (-30.4416, 7.8225) (-30.3035, 8.0126) (-29.9625, 8.0666) (-29.7724, 7.9285) (-29.7184, 7.5875) (-29.8565, 7.3974) (-30.08, 7.3248) (-30.1975, 7.3434), closed, covered)
  P3_DCN_L2_h6 = polyline(z=0mm, xy in mm: (-29.3253, 6.6644) (-29.5856, 6.9247) (-29.5856, 7.1753) (-29.4383, 7.3781) (-29.0747, 7.4356) (-28.8719, 7.2883) (-28.7945, 7.05) (-28.8719, 6.8117) (-29.2, 6.6445) (-29.3253, 6.6644), closed, covered)
  P3_DCN_L2_h7 = polyline(z=0mm, xy in mm: (-18.4253, 6.6644) (-18.6856, 6.9247) (-18.6856, 7.1753) (-18.5383, 7.3781) (-18.1747, 7.4356) (-17.9719, 7.2883) (-17.8945, 7.05) (-17.9719, 6.8117) (-18.3, 6.6445) (-18.4253, 6.6644), closed, covered)
  P3_DCN_L2_h8 = polyline(z=0mm, xy in mm: (-17.5375, 6.0334) (-17.7276, 6.1715) (-17.7816, 6.5125) (-17.6435, 6.7026) (-17.3025, 6.7566) (-17.1124, 6.6185) (-17.0584, 6.2775) (-17.1965, 6.0874) (-17.42, 6.0148) (-17.5375, 6.0334), closed, covered)
  P3_DCN_L2_h9 = polyline(z=0mm, xy in mm: (-30.1975, 5.7684) (-30.3876, 5.9065) (-30.4416, 6.2475) (-30.3035, 6.4376) (-29.9625, 6.4916) (-29.7724, 6.3535) (-29.7184, 6.0125) (-29.8565, 5.8224) (-30.08, 5.7498) (-30.1975, 5.7684), closed, covered)
  P3_DCN_L2_h10 = polyline(z=0mm, xy in mm: (-17.5375, 3.3084) (-17.7276, 3.4465) (-17.7816, 3.7875) (-17.6435, 3.9776) (-17.3025, 4.0316) (-17.1124, 3.8935) (-17.0584, 3.5525) (-17.1965, 3.3624) (-17.42, 3.2898) (-17.5375, 3.3084), closed, covered)
  P3_DCN_L2_h11 = polyline(z=0mm, xy in mm: (-35.6253, 2.1144) (-35.8281, 2.2617) (-35.9055, 2.5) (-35.8281, 2.7383) (-35.5, 2.9055) (-35.0447, 2.6482) (-34.8383, 2.8281) (-34.6, 2.9055) (-34.1447, 2.6482) (-33.9383, 2.8281) (-33.7, 2.9055) (-33.2447, 2.6482) (-33.0383, 2.8281) (-32.8, 2.9055) (-32.3447, 2.6482) (-32.1383, 2.8281) (-31.9, 2.9055) (-31.4447, 2.6482) (-31.1253, 2.8856) (-30.8747, 2.8856) (-30.5447, 2.6482) (-30.2058, 2.9769) (-30.4416, 3.2875) (-30.4416, 3.5225) (-30.3035, 3.7126) (-30.08, 3.7852) (-29.8565, 3.7126) (-29.6998, 3.405) (-29.7724, 3.1815) (-29.9574, 3.0239) (-29.9517, 2.89) (-29.6447, 2.6482) (-29.3253, 2.8856) (-29.0747, 2.8856) (-28.8719, 2.7383) (-28.7945, 2.5) (-28.8719, 2.2617) (-29.2, 2.0945) (-29.6553, 2.3518) (-29.8617, 2.1719) (-30.1, 2.0945) (-30.5553, 2.3518) (-30.7617, 2.1719) (-31, 2.0945) (-31.4553, 2.3518) (-31.6617, 2.1719) (-31.9, 2.0945) (-32.3553, 2.3517) (-32.6747, 2.1144) (-32.9253, 2.1144) (-33.2553, 2.3518) (-33.4617, 2.1719) (-33.7, 2.0945) (-34.1553, 2.3518) (-34.4747, 2.1144) (-34.7253, 2.1144) (-35.0553, 2.3518) (-35.2617, 2.1719) (-35.5, 2.0945) (-35.6253, 2.1144), closed, covered)
  P3_DCN_L2_h12 = polyline(z=0mm, xy in mm: (-18.4253, 2.1144) (-18.6281, 2.2617) (-18.7055, 2.5) (-18.6281, 2.7383) (-18.3, 2.9055) (-17.8447, 2.6482) (-17.6383, 2.8281) (-17.4, 2.9055) (-16.9447, 2.6482) (-16.7383, 2.8281) (-16.5, 2.9055) (-16.0447, 2.6482) (-15.8383, 2.8281) (-15.6, 2.9055) (-15.1447, 2.6482) (-14.9383, 2.8281) (-14.7, 2.9055) (-14.2447, 2.6482) (-14.0383, 2.8281) (-13.8, 2.9055) (-13.3447, 2.6482) (-13.0253, 2.8856) (-12.7747, 2.8856) (-12.4447, 2.6482) (-12.2383, 2.8281) (-12, 2.9055) (-11.7617, 2.8281) (-11.5945, 2.5) (-11.7617, 2.1719) (-12, 2.0945) (-12.4553, 2.3517) (-12.7747, 2.1144) (-13.0253, 2.1144) (-13.3553, 2.3518) (-13.5617, 2.1719) (-13.8, 2.0945) (-14.2553, 2.3518) (-14.4617, 2.1719) (-14.7, 2.0945) (-15.1553, 2.3518) (-15.3617, 2.1719) (-15.6, 2.0945) (-16.0553, 2.3518) (-16.2617, 2.1719) (-16.5, 2.0945) (-16.9553, 2.3518) (-17.2747, 2.1144) (-17.5253, 2.1144) (-17.8553, 2.3518) (-18.0617, 2.1719) (-18.3, 2.0945) (-18.4253, 2.1144), closed, covered)
  P3_DCN_L2.subtract(P3_DCN_L2_h0..P3_DCN_L2_h12)
  P3_DCN_L2.sweep_along_vector((0mm, 0mm, 0.07mm))
  P4_DCN_L4 = polyline(z=-1.44mm, xy in mm: (-28.4908, -1.1811) (-28.45, 0.851) (-28.5184, 0.9452) (-37.951, 0.95) (-38.0452, 0.8816) (-38.05, -1.101) (-37.9816, -1.1952) (-28.549, -1.2) (-28.4908, -1.1811), closed, covered)
  P4_DCN_L4.sweep_along_vector((0mm, 0mm, 0.07mm))
  P5_DCN_L4 = polyline(z=-1.44mm, xy in mm: (-9.4908, -1.1811) (-9.45, 0.851) (-9.5184, 0.9452) (-18.951, 0.95) (-19.0452, 0.8816) (-19.05, -1.101) (-18.9816, -1.1952) (-9.549, -1.2) (-9.4908, -1.1811), closed, covered)
  P5_DCN_L4.sweep_along_vector((0mm, 0mm, 0.07mm))
  P6_DCP_L1 [copper] = polyline(z=0.17mm, xy in mm: (-28.7908, 1.5189) (-28.7689, 3.2087) (-29.621, 3.2495) (-29.9469, 2.9953) (-30.4106, 2.8995) (-31.5175, 2.9494) (-31.6465, 3.1377) (-31.6495, 4.501) (-31.7179, 4.5952) (-32.2005, 4.6) (-32.2947, 4.5316) (-32.2995, 3.1388) (-32.3736, 2.9736) (-32.5389, 2.8995) (-33.1886, 2.9149) (-33.3351, 3.0614) (-33.3505, 4.501) (-33.4189, 4.5952) (-33.9005, 4.6) (-33.9947, 4.5316) (-33.9995, 3.1388) (-34.0736, 2.9736) (-34.2389, 2.8995) (-34.8886, 2.9149) (-35.0351, 3.0614) (-35.0505, 4.501) (-35.1189, 4.5952) (-37.651, 4.6) (-37.7452, 4.5316) (-37.75, 1.599) (-37.6816, 1.5048) (-28.849, 1.5) (-28.7908, 1.5189), closed, covered)
  P6_DCP_L1.sweep_along_vector((0mm, 0mm, 0.07mm))
  P7_DCP_L1 = polyline(z=0.17mm, xy in mm: (-9.7908, 1.5189) (-9.75, 4.501) (-9.849, 4.6) (-12.4087, 4.5811) (-12.4495, 3.1388) (-12.5236, 2.9736) (-12.6889, 2.8995) (-13.3386, 2.9149) (-13.4851, 3.0614) (-13.5005, 4.501) (-13.5995, 4.6) (-14.0505, 4.6) (-14.1447, 4.5316) (-14.1495, 3.1388) (-14.2236, 2.9736) (-14.3889, 2.8995) (-15.0386, 2.9149) (-15.2005, 3.1389) (-15.2194, 4.5592) (-15.7515, 4.6) (-15.8966, 4.38) (-15.8505, 3.1636) (-15.9825, 2.9494) (-17.0894, 2.8995) (-17.3427, 3.0439) (-17.7478, 2.8659) (-18.6827, 2.8868) (-18.75, 2.793) (-18.75, 1.599) (-18.651, 1.5) (-9.849, 1.5) (-9.7908, 1.5189), closed, covered)
  P7_DCP_L1.sweep_along_vector((0mm, 0mm, 0.07mm))
  P8_DCP_L3 = polyline(z=-1.27mm, xy in mm: (-1.5, -0.6953) (-1.5555, -0.5) (-1.5, -0.3047) (-1.5, 4.6) (-39.626, 4.6) (-39.75, 4.476) (-39.75, -0.2789) (-39.6084, -0.4016) (-39.2753, -0.1144) (-39.0247, -0.1144) (-38.822, -0.2617) (-38.7445, -0.5) (-38.822, -0.7383) (-39.0247, -0.8856) (-39.2753, -0.8856) (-39.5635, -0.614) (-39.7409, -0.6745) (-39.75, -4.6) (-1.5, -4.6) (-1.5, -0.6953), closed, covered)
  P8_DCP_L3_h0 = polyline(z=-1.27mm, xy in mm: (-17.5375, 3.3084) (-17.7276, 3.4465) (-17.7816, 3.7875) (-17.6435, 3.9776) (-17.3025, 4.0316) (-17.1124, 3.8935) (-17.0584, 3.5525) (-17.1965, 3.3624) (-17.42, 3.2898) (-17.5375, 3.3084), closed, covered)
  P8_DCP_L3_h1 = polyline(z=-1.27mm, xy in mm: (-25.6675, 3.2384) (-25.8576, 3.3765) (-25.9116, 3.7175) (-25.7735, 3.9076) (-25.4325, 3.9616) (-25.2424, 3.8235) (-25.1884, 3.4825) (-25.3265, 3.2924) (-25.55, 3.2198) (-25.6675, 3.2384), closed, covered)
  P8_DCP_L3_h2 = polyline(z=-1.27mm, xy in mm: (-30.1975, 3.0434) (-30.3876, 3.1815) (-30.4416, 3.5225) (-30.3035, 3.7126) (-29.9625, 3.7666) (-29.7724, 3.6285) (-29.7184, 3.2875) (-29.8565, 3.0974) (-30.08, 3.0248) (-30.1975, 3.0434), closed, covered)
  P8_DCP_L3_h3 = polyline(z=-1.27mm, xy in mm: (-38.0907, -0.8856) (-38.3022, -0.7211) (-38.351, -0.3747) (-38.2037, -0.1719) (-37.8401, -0.1144) (-37.5797, -0.3747) (-37.5797, -0.6253) (-37.727, -0.8281) (-37.9654, -0.9055) (-38.0907, -0.8856), closed, covered)
  P8_DCP_L3_h4 = polyline(z=-1.27mm, xy in mm: (-36.9061, -0.8856) (-37.1176, -0.7211) (-37.1664, -0.3747) (-37.0191, -0.1719) (-36.6555, -0.1144) (-36.3951, -0.3747) (-36.3951, -0.6253) (-36.5424, -0.8281) (-36.7808, -0.9055) (-36.9061, -0.8856), closed, covered)
  P8_DCP_L3_h5 = polyline(z=-1.27mm, xy in mm: (-35.7215, -0.8856) (-35.933, -0.7211) (-35.9818, -0.3747) (-35.8345, -0.1719) (-35.4708, -0.1144) (-35.2105, -0.3747) (-35.2105, -0.6253) (-35.3578, -0.8281) (-35.5962, -0.9055) (-35.7215, -0.8856), closed, covered)
  P8_DCP_L3_h6 = polyline(z=-1.27mm, xy in mm: (-34.5368, -0.8856) (-34.7484, -0.7211) (-34.7972, -0.3747) (-34.6499, -0.1719) (-34.2862, -0.1144) (-34.0835, -0.2617) (-34.006, -0.5) (-34.1732, -0.8281) (-34.4115, -0.9055) (-34.5368, -0.8856), closed, covered)
  P8_DCP_L3_h7 = polyline(z=-1.27mm, xy in mm: (-33.3522, -0.8856) (-33.5638, -0.7211) (-33.6126, -0.3747) (-33.4653, -0.1719) (-33.1016, -0.1144) (-32.8989, -0.2617) (-32.8214, -0.5) (-32.9886, -0.8281) (-33.2269, -0.9055) (-33.3522, -0.8856), closed, covered)
  P8_DCP_L3_h8 = polyline(z=-1.27mm, xy in mm: (-32.1676, -0.8856) (-32.428, -0.6253) (-32.428, -0.3747) (-32.2806, -0.1719) (-31.917, -0.1144) (-31.7143, -0.2617) (-31.6368, -0.5) (-31.804, -0.8281) (-32.0423, -0.9055) (-32.1676, -0.8856), closed, covered)
  P8_DCP_L3_h9 = polyline(z=-1.27mm, xy in mm: (-30.983, -0.8856) (-31.1945, -0.7211) (-31.2433, -0.3747) (-31.096, -0.1719) (-30.7324, -0.1144) (-30.472, -0.3747) (-30.472, -0.6253) (-30.6193, -0.8281) (-30.8577, -0.9055) (-30.983, -0.8856), closed, covered)
  P8_DCP_L3_h10 = polyline(z=-1.27mm, xy in mm: (-29.7984, -0.8856) (-30.0099, -0.7211) (-30.0587, -0.3747) (-29.9114, -0.1719) (-29.5478, -0.1144) (-29.2874, -0.3747) (-29.2874, -0.6253) (-29.4347, -0.8281) (-29.6731, -0.9055) (-29.7984, -0.8856), closed, covered)
  P8_DCP_L3_h11 = polyline(z=-1.27mm, xy in mm: (-28.6138, -0.8856) (-28.8253, -0.7211) (-28.8741, -0.3747) (-28.7268, -0.1719) (-28.3632, -0.1144) (-28.1028, -0.3747) (-28.1028, -0.6253) (-28.2501, -0.8281) (-28.4885, -0.9055) (-28.6138, -0.8856), closed, covered)
  P8_DCP_L3_h12 = polyline(z=-1.27mm, xy in mm: (-27.4291, -0.8856) (-27.6407, -0.7211) (-27.6895, -0.3747) (-27.5422, -0.1719) (-27.1785, -0.1144) (-26.9182, -0.3747) (-26.9182, -0.6253) (-27.0655, -0.8281) (-27.3038, -0.9055) (-27.4291, -0.8856), closed, covered)
  P8_DCP_L3_h13 = polyline(z=-1.27mm, xy in mm: (-26.2445, -0.8856) (-26.4561, -0.7211) (-26.5049, -0.3747) (-26.3576, -0.1719) (-25.9939, -0.1144) (-25.7912, -0.2617) (-25.7137, -0.5) (-25.8809, -0.8281) (-26.1192, -0.9055) (-26.2445, -0.8856), closed, covered)
  P8_DCP_L3_h14 = polyline(z=-1.27mm, xy in mm: (-25.0599, -0.8856) (-25.3203, -0.6253) (-25.3203, -0.3747) (-25.173, -0.1719) (-24.8093, -0.1144) (-24.6066, -0.2617) (-24.5291, -0.5) (-24.6963, -0.8281) (-24.9346, -0.9055) (-25.0599, -0.8856), closed, covered)
  P8_DCP_L3_h15 = polyline(z=-1.27mm, xy in mm: (-23.8753, -0.8856) (-24.0781, -0.7383) (-24.1356, -0.3747) (-23.9883, -0.1719) (-23.6247, -0.1144) (-23.4219, -0.2617) (-23.3445, -0.5) (-23.4219, -0.7383) (-23.75, -0.9055) (-23.8753, -0.8856), closed, covered)
  P8_DCP_L3_h16 = polyline(z=-1.27mm, xy in mm: (-22.6907, -0.8856) (-22.9022, -0.7211) (-22.951, -0.3747) (-22.8037, -0.1719) (-22.4401, -0.1144) (-22.1797, -0.3747) (-22.1797, -0.6253) (-22.327, -0.8281) (-22.5654, -0.9055) (-22.6907, -0.8856), closed, covered)
  P8_DCP_L3_h17 = polyline(z=-1.27mm, xy in mm: (-21.5061, -0.8856) (-21.7176, -0.7211) (-21.7664, -0.3747) (-21.6191, -0.1719) (-21.2555, -0.1144) (-20.9951, -0.3747) (-20.9951, -0.6253) (-21.1424, -0.8281) (-21.3808, -0.9055) (-21.5061, -0.8856), closed, covered)
  P8_DCP_L3_h18 = polyline(z=-1.27mm, xy in mm: (-20.3215, -0.8856) (-20.533, -0.7211) (-20.5818, -0.3747) (-20.4345, -0.1719) (-20.0708, -0.1144) (-19.8105, -0.3747) (-19.8105, -0.6253) (-19.9578, -0.8281) (-20.1962, -0.9055) (-20.3215, -0.8856), closed, covered)
  P8_DCP_L3_h19 = polyline(z=-1.27mm, xy in mm: (-19.1368, -0.8856) (-19.3484, -0.7211) (-19.3972, -0.3747) (-19.2499, -0.1719) (-18.8862, -0.1144) (-18.6835, -0.2617) (-18.606, -0.5) (-18.7732, -0.8281) (-19.0115, -0.9055) (-19.1368, -0.8856), closed, covered)
  P8_DCP_L3_h20 = polyline(z=-1.27mm, xy in mm: (-17.9522, -0.8856) (-18.1638, -0.7211) (-18.2126, -0.3747) (-18.0653, -0.1719) (-17.7016, -0.1144) (-17.4989, -0.2617) (-17.4214, -0.5) (-17.5886, -0.8281) (-17.8269, -0.9055) (-17.9522, -0.8856), closed, covered)
  P8_DCP_L3_h21 = polyline(z=-1.27mm, xy in mm: (-16.7676, -0.8856) (-17.028, -0.6253) (-17.028, -0.3747) (-16.8806, -0.1719) (-16.517, -0.1144) (-16.3143, -0.2617) (-16.2368, -0.5) (-16.404, -0.8281) (-16.6423, -0.9055) (-16.7676, -0.8856), closed, covered)
  P8_DCP_L3_h22 = polyline(z=-1.27mm, xy in mm: (-15.583, -0.8856) (-15.7945, -0.7211) (-15.8433, -0.3747) (-15.696, -0.1719) (-15.3324, -0.1144) (-15.072, -0.3747) (-15.072, -0.6253) (-15.2193, -0.8281) (-15.4577, -0.9055) (-15.583, -0.8856), closed, covered)
  P8_DCP_L3_h23 = polyline(z=-1.27mm, xy in mm: (-14.3984, -0.8856) (-14.6099, -0.7211) (-14.6587, -0.3747) (-14.5114, -0.1719) (-14.1478, -0.1144) (-13.8874, -0.3747) (-13.8874, -0.6253) (-14.0347, -0.8281) (-14.2731, -0.9055) (-14.3984, -0.8856), closed, covered)
  P8_DCP_L3_h24 = polyline(z=-1.27mm, xy in mm: (-13.2138, -0.8856) (-13.4253, -0.7211) (-13.4741, -0.3747) (-13.3268, -0.1719) (-12.9632, -0.1144) (-12.7028, -0.3747) (-12.7028, -0.6253) (-12.8501, -0.8281) (-13.0885, -0.9055) (-13.2138, -0.8856), closed, covered)
  P8_DCP_L3_h25 = polyline(z=-1.27mm, xy in mm: (-12.0291, -0.8856) (-12.2407, -0.7211) (-12.2895, -0.3747) (-12.1422, -0.1719) (-11.7785, -0.1144) (-11.5182, -0.3747) (-11.5182, -0.6253) (-11.6655, -0.8281) (-11.9038, -0.9055) (-12.0291, -0.8856), closed, covered)
  P8_DCP_L3_h26 = polyline(z=-1.27mm, xy in mm: (-10.8445, -0.8856) (-11.0561, -0.7211) (-11.1049, -0.3747) (-10.9576, -0.1719) (-10.5939, -0.1144) (-10.3912, -0.2617) (-10.3137, -0.5) (-10.4809, -0.8281) (-10.7192, -0.9055) (-10.8445, -0.8856), closed, covered)
  P8_DCP_L3_h27 = polyline(z=-1.27mm, xy in mm: (-9.6599, -0.8856) (-9.9203, -0.6253) (-9.9203, -0.3747) (-9.773, -0.1719) (-9.4093, -0.1144) (-9.2066, -0.2617) (-9.1291, -0.5) (-9.2963, -0.8281) (-9.5346, -0.9055) (-9.6599, -0.8856), closed, covered)
  P8_DCP_L3_h28 = polyline(z=-1.27mm, xy in mm: (-8.4753, -0.8856) (-8.6868, -0.7211) (-8.7356, -0.3747) (-8.5883, -0.1719) (-8.2247, -0.1144) (-8.0219, -0.2617) (-7.9445, -0.5) (-8.0219, -0.7383) (-8.35, -0.9055) (-8.4753, -0.8856), closed, covered)
  P8_DCP_L3_h29 = polyline(z=-1.27mm, xy in mm: (-7.2753, -0.8856) (-7.5356, -0.6253) (-7.5356, -0.3747) (-7.3883, -0.1719) (-7.0247, -0.1144) (-6.8219, -0.2617) (-6.7445, -0.5) (-6.9117, -0.8281) (-7.15, -0.9055) (-7.2753, -0.8856), closed, covered)
  P8_DCP_L3_h30 = polyline(z=-1.27mm, xy in mm: (-6.0753, -0.8856) (-6.3356, -0.6253) (-6.3356, -0.3747) (-6.1883, -0.1719) (-5.8247, -0.1144) (-5.6219, -0.2617) (-5.5445, -0.5) (-5.6219, -0.7383) (-5.95, -0.9055) (-6.0753, -0.8856), closed, covered)
  P8_DCP_L3_h31 = polyline(z=-1.27mm, xy in mm: (-4.8753, -0.8856) (-5.1356, -0.6253) (-5.1356, -0.3747) (-4.9883, -0.1719) (-4.6247, -0.1144) (-4.422, -0.2617) (-4.3445, -0.5) (-4.5117, -0.8281) (-4.75, -0.9055) (-4.8753, -0.8856), closed, covered)
  P8_DCP_L3_h32 = polyline(z=-1.27mm, xy in mm: (-3.6753, -0.8856) (-3.9356, -0.6253) (-3.9356, -0.3747) (-3.7883, -0.1719) (-3.4247, -0.1144) (-3.2219, -0.2617) (-3.1445, -0.5) (-3.2219, -0.7383) (-3.55, -0.9055) (-3.6753, -0.8856), closed, covered)
  P8_DCP_L3_h33 = polyline(z=-1.27mm, xy in mm: (-2.4753, -0.8856) (-2.7356, -0.6253) (-2.7356, -0.3747) (-2.5883, -0.1719) (-2.2247, -0.1144) (-2.0219, -0.2617) (-1.9445, -0.5) (-2.0219, -0.7383) (-2.35, -0.9055) (-2.4753, -0.8856), closed, covered)
  P8_DCP_L3.subtract(P8_DCP_L3_h0..P8_DCP_L3_h33)
  P8_DCP_L3.sweep_along_vector((0mm, 0mm, 0.07mm))
  P9_DCP_L4 = polyline(z=-1.44mm, xy in mm: (-28.4908, 1.4689) (-28.45, 3.201) (-28.5184, 3.2952) (-29.5953, 3.3) (-29.8268, 3.0565) (-30.08, 2.9742) (-30.3332, 3.0565) (-30.5647, 3.3) (-37.951, 3.3) (-38.0452, 3.2316) (-38.05, 1.549) (-37.9816, 1.4548) (-28.549, 1.45) (-28.4908, 1.4689), closed, covered)
  P9_DCP_L4.sweep_along_vector((0mm, 0mm, 0.07mm))
  P10_DCP_L4 = polyline(z=-1.44mm, xy in mm: (-11.8361, 1.4689) (-11.8843, 2.6203) (-12.3943, 2.7352) (-12.7843, 3.1043) (-12.8973, 3.0768) (-13.0898, 2.8395) (-13.3978, 2.7009) (-14.0522, 2.7009) (-14.5345, 2.9871) (-15.0478, 2.7009) (-15.6316, 2.6945) (-16.0102, 2.8395) (-16.3508, 3.3) (-17.42, 3.2392) (-17.6548, 3.3) (-18.951, 3.3) (-19.0452, 3.2316) (-19.05, 1.549) (-18.9816, 1.4548) (-11.8943, 1.45) (-11.8361, 1.4689), closed, covered)
  P10_DCP_L4.sweep_along_vector((0mm, 0mm, 0.07mm))
  P11_GH_L1_L1 [copper] = polyline(z=0.17mm, xy in mm: (-29.2, 6.28) (-31.048, 6.28) (-31.048, 5.98) (-29.2, 5.98) (-29.2, 6.28), closed, covered)
  P11_GH_L1_L1.sweep_along_vector((0mm, 0mm, 0.07mm))
  P12_GH_L1_L4 = polyline(z=-1.44mm, xy in mm: (-29.955, 6.255) (-32.25, 6.255) (-32.25, 6.005) (-29.955, 6.005) (-29.955, 6.255), closed, covered)
  P12_GH_L1_L4.sweep_along_vector((0mm, 0mm, 0.07mm))
  P13_GH_R1_L1 [copper] = polyline(z=0.17mm, xy in mm: (-16.452, 3.82) (-18.3, 3.82) (-18.3, 3.52) (-16.452, 3.52) (-16.452, 3.82), closed, covered)
  P13_GH_R1_L1.sweep_along_vector((0mm, 0mm, 0.07mm))
  P14_GH_R1_L4 = polyline(z=-1.44mm, xy in mm: (-15.25, 3.795) (-17.545, 3.795) (-17.545, 3.545) (-15.25, 3.545) (-15.25, 3.795), closed, covered)
  P14_GH_R1_L4.sweep_along_vector((0mm, 0mm, 0.07mm))
  P15_GH_STAR1_L1 [copper] = polyline(z=0.17mm, xy in mm: (-24.8511, 10.55) (-24.8, 10.55) (-24.8, 10.6692) (-24.753, 10.7788) (-24.8, 10.7989) (-24.8, 11.2724) (-24.7558, 11.2896) (-24.8, 11.4031) (-24.8, 11.525) (-24.8474, 11.525) (-24.8646, 11.5692) (-24.9781, 11.525) (-25.1, 11.525) (-25.1, 11.4776) (-26.9442, 10.7604) (-26.8354, 10.4808) (-25.1, 11.1557) (-25.1, 10.7308) (-25.447, 9.9212) (-25.1712, 9.803) (-24.8511, 10.55), closed, covered)
  P15_GH_STAR1_L1.sweep_along_vector((0mm, 0mm, 0.07mm))
  P16_GH_STAR1_L1 = polyline(z=0.17mm, xy in mm: (-28.7779, 4.75) (-26.875, 4.75) (-26.875, 4.635) (-26.625, 4.635) (-26.625, 4.75) (-18.7221, 4.75) (-18.66, 4.6879) (-18.5979, 4.75) (-18.51, 4.75) (-18.51, 4.8379) (-17.9379, 5.41) (-18.15, 5.6221) (-18.7221, 5.05) (-23.6, 5.05) (-23.6, 6.75) (-23.9, 6.75) (-23.9, 5.05) (-28.7779, 5.05) (-28.84, 5.1121) (-28.9021, 5.05) (-28.99, 5.05) (-28.99, 4.9621) (-29.5621, 4.39) (-29.35, 4.1779) (-28.7779, 4.75), closed, covered)
  P16_GH_STAR1_L1.sweep_along_vector((0mm, 0mm, 0.07mm))
  P17_GH_STAR1_L3 = polyline(z=-1.27mm, xy in mm: (-23.5379, 6.6) (-24.35, 7.4121) (-24.35, 9.1879) (-24.2879, 9.25) (-24.35, 9.3121) (-24.35, 9.4) (-24.4379, 9.4) (-25.25, 10.2121) (-25.4621, 10) (-24.65, 9.1879) (-24.65, 7.4121) (-24.7121, 7.35) (-24.65, 7.2879) (-24.65, 7.2) (-24.5621, 7.2) (-23.75, 6.3879) (-23.5379, 6.6), closed, covered)
  P17_GH_STAR1_L3.sweep_along_vector((0mm, 0mm, 0.07mm))
  P18_GL_L1_L1 [copper] = polyline(z=0.17mm, xy in mm: (-29.2, 10.58) (-31.048, 10.58) (-31.048, 10.28) (-29.2, 10.28) (-29.2, 10.58), closed, covered)
  P18_GL_L1_L1.sweep_along_vector((0mm, 0mm, 0.07mm))
  P19_GL_L1_L4 = polyline(z=-1.44mm, xy in mm: (-29.955, 10.555) (-32.25, 10.555) (-32.25, 10.305) (-29.955, 10.305) (-29.955, 10.555), closed, covered)
  P19_GL_L1_L4.sweep_along_vector((0mm, 0mm, 0.07mm))
  P20_GL_R1_L1 [copper] = polyline(z=0.17mm, xy in mm: (-16.452, 8.12) (-18.3, 8.12) (-18.3, 7.82) (-16.452, 7.82) (-16.452, 8.12), closed, covered)
  P20_GL_R1_L1.sweep_along_vector((0mm, 0mm, 0.07mm))
  P21_GL_R1_L4 = polyline(z=-1.44mm, xy in mm: (-15.25, 8.095) (-17.545, 8.095) (-17.545, 7.845) (-15.25, 7.845) (-15.25, 8.095), closed, covered)
  P21_GL_R1_L4.sweep_along_vector((0mm, 0mm, 0.07mm))
  P22_GL_STAR1_L1 [copper] = polyline(z=0.17mm, xy in mm: (-28.7779, 9.05) (-26.875, 9.05) (-26.875, 8.935) (-26.625, 8.935) (-26.625, 9.05) (-18.7221, 9.05) (-18.66, 8.9879) (-18.5979, 9.05) (-18.51, 9.05) (-18.51, 9.1379) (-17.9379, 9.71) (-18.15, 9.9221) (-18.7221, 9.35) (-23.6, 9.35) (-23.6, 10.15) (-22.4, 10.15) (-22.4, 11.1557) (-20.6646, 10.4808) (-20.5558, 10.7604) (-22.4, 11.4776) (-22.4, 11.525) (-22.5219, 11.525) (-22.6354, 11.5692) (-22.6526, 11.525) (-22.7, 11.525) (-22.7, 11.4031) (-22.7442, 11.2896) (-22.7, 11.2724) (-22.7, 10.45) (-23.9, 10.45) (-23.9, 9.35) (-28.7779, 9.35) (-28.84, 9.4121) (-28.9021, 9.35) (-28.99, 9.35) (-28.99, 9.2621) (-29.5621, 8.69) (-29.35, 8.4779) (-28.7779, 9.05), closed, covered)
  P22_GL_STAR1_L1.sweep_along_vector((0mm, 0mm, 0.07mm))
  P23_KH1_L1 = polyline(z=0.17mm, xy in mm: (-16.452, 6.35) (-22.1, 6.35) (-22.1, 6.05) (-16.452, 6.05) (-16.452, 6.35), closed, covered)
  P23_KH1_L1.sweep_along_vector((0mm, 0mm, 0.07mm))
  P24_KH1_L1 = polyline(z=0.17mm, xy in mm: (-25.4, 3.75) (-26.625, 3.75) (-26.625, 3.865) (-26.875, 3.865) (-26.875, 3.75) (-31.048, 3.75) (-31.048, 3.45) (-25.4, 3.45) (-25.4, 3.75), closed, covered)
  P24_KH1_L1.sweep_along_vector((0mm, 0mm, 0.07mm))
  P25_KH1_L2 = polyline(z=0mm, xy in mm: (-39.0876, 20.8197) (-39.0418, 20.8725) (-39.0319, 20.9416) (-39.0588, 21.0027) (-39.0677, 21.0135) (-39.1652, 21.196) (-39.2253, 21.3941) (-39.2456, 21.6) (-39.2253, 21.8059) (-39.1664, 22) (-40.15, 22) (-40.15, 20.924) (-40.1303, 20.857) (-40.0775, 20.8112) (-40.026, 20.8) (-39.1546, 20.8) (-39.0876, 20.8197), closed, covered)
  P25_KH1_L2.sweep_along_vector((0mm, 0mm, 0.07mm))
  P26_KH1_L2 = polyline(z=0mm, xy in mm: (-36.7575, 20.8197) (-36.7117, 20.8725) (-36.7005, 20.924) (-36.7005, 22) (-37.2136, 22) (-37.1547, 21.8059) (-37.1344, 21.6) (-37.1547, 21.3941) (-37.2148, 21.196) (-37.3123, 21.0135) (-37.3212, 21.0027) (-37.3486, 20.9384) (-37.3368, 20.8695) (-37.2896, 20.8179) (-37.2254, 20.8) (-36.8245, 20.8) (-36.7575, 20.8197), closed, covered)
  P26_KH1_L2.sweep_along_vector((0mm, 0mm, 0.07mm))
  P27_KH1_L2 = polyline(z=0mm, xy in mm: (-33.557, 20.8197) (-33.5112, 20.8725) (-33.5, 20.924) (-33.5, 22) (-34.5995, 22) (-34.5995, 20.924) (-34.5798, 20.857) (-34.527, 20.8112) (-34.4755, 20.8) (-33.624, 20.8) (-33.557, 20.8197), closed, covered)
  P27_KH1_L2.sweep_along_vector((0mm, 0mm, 0.07mm))
  P28_KH1_L2 = polyline(z=0mm, xy in mm: (-24.1379, 10) (-24.8, 10.6621) (-24.8, 13.5524) (-24.741, 13.636) (-24.8, 13.6777) (-24.8, 13.75) (-24.9024, 13.75) (-25.836, 14.409) (-26.009, 14.164) (-25.1, 13.5223) (-25.1, 11.15) (-27.8, 11.15) (-27.8, 10.85) (-25.1, 10.85) (-25.1, 10.6621) (-25.1621, 10.6) (-25.1, 10.5379) (-25.1, 10.45) (-25.0121, 10.45) (-24.35, 9.7879) (-24.1379, 10), closed, covered)
  P28_KH1_L2.sweep_along_vector((0mm, 0mm, 0.07mm))
  P29_KH1_L2 = polyline(z=0mm, xy in mm: (-23.7015, 4.75) (-23.6, 4.75) (-23.6, 4.8233) (-21.7406, 6.1662) (-21.9162, 6.4094) (-23.6, 5.1934) (-23.6, 5.5379) (-22.9379, 6.2) (-22.85, 6.2) (-22.85, 6.2879) (-22.7879, 6.35) (-22.85, 6.4121) (-22.85, 7.15) (-23.15, 7.15) (-23.15, 6.4121) (-23.8121, 5.75) (-23.9, 5.75) (-23.9, 5.6621) (-23.9621, 5.6) (-23.9, 5.5379) (-23.9, 4.9767) (-25.7594, 3.6338) (-25.5838, 3.3906) (-23.7015, 4.75), closed, covered)
  P29_KH1_L2.sweep_along_vector((0mm, 0mm, 0.07mm))
  P30_KH1_L3 = polyline(z=-1.27mm, xy in mm: (-27.5, 16.75) (-34, 16.75) (-34, 22) (-34.3, 22) (-34.3, 16.45) (-27.8, 16.45) (-27.8, 10.85) (-27.5, 10.85) (-27.5, 16.75), closed, covered)
  P30_KH1_L3.sweep_along_vector((0mm, 0mm, 0.07mm))
  P31_KH1_L4 = polyline(z=-1.44mm, xy in mm: (-25.6734, 14.0734) (-24.8344, 14.25) (-24.7, 14.25) (-24.7, 14.2783) (-24.6723, 14.2841) (-24.7, 14.4156) (-24.7, 14.775) (-25, 14.775) (-25, 14.5217) (-25.8, 14.3533) (-26.6, 14.5217) (-26.6, 14.775) (-26.9, 14.775) (-26.9, 14.4156) (-26.9277, 14.2841) (-26.9, 14.2783) (-26.9, 14.25) (-26.7656, 14.25) (-25.9266, 14.0734) (-25.9159, 14.0223) (-25.8, 14.0467) (-25.6841, 14.0223) (-25.6734, 14.0734), closed, covered)
  P31_KH1_L4.sweep_along_vector((0mm, 0mm, 0.07mm))
  P32_KH1_L4 = polyline(z=-1.44mm, xy in mm: (-22.7988, 7.0671) (-24.35, 7.8427) (-24.35, 9.7879) (-24.1379, 10) (-24.35, 10.2121) (-24.5621, 10) (-24.65, 10) (-24.65, 9.9121) (-24.7121, 9.85) (-24.65, 9.7879) (-24.65, 7.7854) (-24.7012, 7.6829) (-24.65, 7.6573) (-24.65, 7.6) (-24.5354, 7.6) (-22.9329, 6.7988) (-22.7988, 7.0671), closed, covered)
  P32_KH1_L4.sweep_along_vector((0mm, 0mm, 0.07mm))
  P33_KH1_L4 = polyline(z=-1.44mm, xy in mm: (-29.955, 5.205) (-37.025, 5.205) (-37.025, 7.805) (-37.425, 7.805) (-37.425, 4.455) (-37.025, 4.455) (-37.025, 4.955) (-30.205, 4.955) (-30.205, 3.28) (-29.955, 3.28) (-29.955, 5.205), closed, covered)
  P33_KH1_L4.sweep_along_vector((0mm, 0mm, 0.07mm))
  P34_KH1_L4 = polyline(z=-1.44mm, xy in mm: (-10.075, 5.345) (-10.475, 5.345) (-10.475, 4.845) (-17.295, 4.845) (-17.295, 6.52) (-17.545, 6.52) (-17.545, 4.595) (-10.475, 4.595) (-10.475, 1.995) (-10.075, 1.995) (-10.075, 5.345), closed, covered)
  P34_KH1_L4.sweep_along_vector((0mm, 0mm, 0.07mm))
  P35_KL1_L1 = polyline(z=0.17mm, xy in mm: (-16.452, 10.65) (-19.9, 10.65) (-19.9, 10.35) (-16.452, 10.35) (-16.452, 10.65), closed, covered)
  P35_KL1_L1.sweep_along_vector((0mm, 0mm, 0.07mm))
  P36_KL1_L1 = polyline(z=0.17mm, xy in mm: (-26.2, 8.05) (-26.625, 8.05) (-26.625, 8.165) (-26.875, 8.165) (-26.875, 8.05) (-31.048, 8.05) (-31.048, 7.75) (-26.2, 7.75) (-26.2, 8.05), closed, covered)
  P36_KL1_L1.sweep_along_vector((0mm, 0mm, 0.07mm))
  P37_KL1_L2 = polyline(z=0mm, xy in mm: (-12.7476, 20.8197) (-12.7018, 20.8725) (-12.6919, 20.9416) (-12.7188, 21.0027) (-12.7277, 21.0135) (-12.8252, 21.196) (-12.8853, 21.3941) (-12.9056, 21.6) (-12.8853, 21.8059) (-12.8264, 22) (-14, 22) (-14, 20.924) (-13.9803, 20.857) (-13.9275, 20.8112) (-13.876, 20.8) (-12.8146, 20.8) (-12.7476, 20.8197), closed, covered)
  P37_KL1_L2.sweep_along_vector((0mm, 0mm, 0.07mm))
  P38_KL1_L2 = polyline(z=0mm, xy in mm: (-10.4175, 20.8197) (-10.3717, 20.8725) (-10.3605, 20.924) (-10.3605, 22) (-10.8736, 22) (-10.8147, 21.8059) (-10.7944, 21.6) (-10.8147, 21.3941) (-10.8748, 21.196) (-10.9723, 21.0135) (-10.9812, 21.0027) (-11.0086, 20.9384) (-10.9968, 20.8695) (-10.9496, 20.8179) (-10.8854, 20.8) (-10.4845, 20.8) (-10.4175, 20.8197), closed, covered)
  P38_KL1_L2.sweep_along_vector((0mm, 0mm, 0.07mm))
  P39_KL1_L2 = polyline(z=0mm, xy in mm: (-7.407, 20.8197) (-7.3612, 20.8725) (-7.35, 20.924) (-7.35, 22) (-8.2595, 22) (-8.2595, 20.924) (-8.2398, 20.857) (-8.187, 20.8112) (-8.1355, 20.8) (-7.474, 20.8) (-7.407, 20.8197), closed, covered)
  P39_KL1_L2.sweep_along_vector((0mm, 0mm, 0.07mm))
  P40_KL1_L2 = polyline(z=0mm, xy in mm: (-23.7262, 9.05) (-23.6, 9.05) (-23.6, 9.091) (-19.561, 10.4037) (-19.6537, 10.689) (-23.6, 9.4065) (-23.6, 10.15) (-22.4, 10.15) (-22.4, 10.85) (-19.7, 10.85) (-19.7, 11.15) (-22.4, 11.15) (-22.4, 13.5223) (-21.491, 14.164) (-21.664, 14.409) (-22.5976, 13.75) (-22.7, 13.75) (-22.7, 13.6777) (-22.759, 13.636) (-22.7, 13.5524) (-22.7, 10.45) (-23.9, 10.45) (-23.9, 9.309) (-27.939, 7.9963) (-27.8463, 7.711) (-23.7262, 9.05), closed, covered)
  P40_KL1_L2.sweep_along_vector((0mm, 0mm, 0.07mm))
  P41_KL1_L3 = polyline(z=-1.27mm, xy in mm: (-19.7, 16.45) (-13.2, 16.45) (-13.2, 22) (-13.5, 22) (-13.5, 16.75) (-20, 16.75) (-20, 10.85) (-19.7, 10.85) (-19.7, 16.45), closed, covered)
  P41_KL1_L3.sweep_along_vector((0mm, 0mm, 0.07mm))
  P42_KL1_L4 = polyline(z=-1.44mm, xy in mm: (-21.5734, 14.0734) (-20.7344, 14.25) (-20.6, 14.25) (-20.6, 14.2783) (-20.5723, 14.2841) (-20.6, 14.4156) (-20.6, 14.775) (-20.9, 14.775) (-20.9, 14.5217) (-21.7, 14.3533) (-22.5, 14.5217) (-22.5, 14.775) (-22.8, 14.775) (-22.8, 14.4156) (-22.8277, 14.2841) (-22.8, 14.2783) (-22.8, 14.25) (-22.6656, 14.25) (-21.8266, 14.0734) (-21.8159, 14.0223) (-21.7, 14.0467) (-21.5841, 14.0223) (-21.5734, 14.0734), closed, covered)
  P42_KL1_L4.sweep_along_vector((0mm, 0mm, 0.07mm))
  P43_KL1_L4 = polyline(z=-1.44mm, xy in mm: (-29.955, 9.505) (-40.225, 9.505) (-40.225, 12.105) (-40.625, 12.105) (-40.625, 8.755) (-40.225, 8.755) (-40.225, 9.255) (-30.205, 9.255) (-30.205, 7.58) (-29.955, 7.58) (-29.955, 9.505), closed, covered)
  P43_KL1_L4.sweep_along_vector((0mm, 0mm, 0.07mm))
  P44_KL1_L4 = polyline(z=-1.44mm, xy in mm: (-6.875, 9.645) (-7.275, 9.645) (-7.275, 9.145) (-17.295, 9.145) (-17.295, 10.82) (-17.545, 10.82) (-17.545, 8.895) (-7.275, 8.895) (-7.275, 6.295) (-6.875, 6.295) (-6.875, 9.645), closed, covered)
  P44_KL1_L4.sweep_along_vector((0mm, 0mm, 0.07mm))
  P45_LSRC1_L1 [copper] = polyline(z=0.17mm, xy in mm: (-36.3943, 9.5189) (-36.3505, 10.9623) (-36.1153, 11.1975) (-35.1146, 11.2005) (-34.9004, 11.0685) (-34.8505, 9.599) (-34.7515, 9.5) (-34.2995, 9.5) (-34.2053, 9.5684) (-34.2005, 10.9612) (-34.1264, 11.1264) (-33.9611, 11.2005) (-33.3114, 11.1851) (-33.1495, 10.9611) (-33.1306, 9.5408) (-32.5995, 9.5) (-32.5005, 9.599) (-32.5005, 10.9612) (-32.4264, 11.1264) (-32.2611, 11.2005) (-30.4106, 11.2005) (-30.2785, 11.1506) (-30.0687, 10.8591) (-29.6565, 10.9405) (-28.8335, 10.8877) (-28.7512, 10.97) (-28.75, 11.2) (-28.65, 11.299) (-28.6689, 12.3592) (-43.6092, 12.3811) (-43.65, 11.299) (-43.5816, 11.2048) (-37.75, 11.2) (-37.7311, 9.5408) (-36.4525, 9.5) (-36.3943, 9.5189), closed, covered)
  P45_LSRC1_L1.sweep_along_vector((0mm, 0mm, 0.07mm))
  P46_LSRC1_L4 = polyline(z=-1.44mm, xy in mm: (-37.025, 13.225) (-37.025, 18.87) (-38.55, 18.87) (-38.55, 18.47) (-37.425, 18.47) (-37.425, 15.49) (-38.55, 15.49) (-38.55, 15.09) (-37.425, 15.09) (-37.425, 11.6) (-37.025, 11.6) (-37.025, 13.225), closed, covered)
  P46_LSRC1_L4.sweep_along_vector((0mm, 0mm, 0.07mm))
  P47_LSRC2_L1 [copper] = polyline(z=0.17mm, xy in mm: (-14.3913, 9.5189) (-14.3505, 10.9612) (-14.1886, 11.1851) (-13.5389, 11.2005) (-13.3149, 11.0386) (-13.2995, 9.599) (-13.2311, 9.5048) (-12.7485, 9.5) (-12.6543, 9.5684) (-12.6495, 10.9364) (-12.5175, 11.1506) (-11.4106, 11.2005) (-11.2785, 11.1506) (-11.1495, 10.9623) (-11.1276, 9.5408) (-9.849, 9.5) (-9.75, 9.599) (-9.75, 11.2) (-3.949, 11.2) (-3.85, 11.299) (-3.85, 12.301) (-3.949, 12.4) (-18.751, 12.4) (-18.85, 12.301) (-18.85, 11.299) (-18.75, 11.2) (-18.6816, 10.8553) (-17.879, 10.8505) (-17.5531, 11.1047) (-17.0894, 11.2005) (-15.1614, 11.1851) (-14.9995, 10.9611) (-14.9806, 9.5408) (-14.4495, 9.5) (-14.3913, 9.5189), closed, covered)
  P47_LSRC2_L1.sweep_along_vector((0mm, 0mm, 0.07mm))
  P48_LSRC2_L4 = polyline(z=-1.44mm, xy in mm: (-10.075, 13.225) (-10.075, 15.09) (-8.95, 15.09) (-8.95, 15.49) (-10.075, 15.49) (-10.075, 18.47) (-8.95, 18.47) (-8.95, 18.87) (-10.475, 18.87) (-10.475, 11.6) (-10.075, 11.6) (-10.075, 13.225), closed, covered)
  P48_LSRC2_L4.sweep_along_vector((0mm, 0mm, 0.07mm))
  P49_OFFA1_L1 [copper] = polyline(z=0.17mm, xy in mm: (-26.6, 13.65) (-26.9, 13.65) (-26.9, 12.175) (-26.6, 12.175) (-26.6, 13.65), closed, covered)
  P49_OFFA1_L1.sweep_along_vector((0mm, 0mm, 0.07mm))
  P50_OFFB1_L1 [copper] = polyline(z=0.17mm, xy in mm: (-20.6, 13.65) (-20.9, 13.65) (-20.9, 12.175) (-20.6, 12.175) (-20.6, 13.65), closed, covered)
  P50_OFFB1_L1.sweep_along_vector((0mm, 0mm, 0.07mm))
  P51_OUTA1_L1 [copper] = polyline(z=0.17mm, xy in mm: (-24.85, 17.2) (-25.15, 17.2) (-25.15, 15.7) (-26.9, 15.7) (-26.9, 15.4) (-25.15, 15.4) (-25.15, 12.875) (-24.85, 12.875) (-24.85, 17.2), closed, covered)
  P51_OUTA1_L1.sweep_along_vector((0mm, 0mm, 0.07mm))
  P52_OUTB1_L1 [copper] = polyline(z=0.17mm, xy in mm: (-22.35, 15.4) (-20.6, 15.4) (-20.6, 15.7) (-22.35, 15.7) (-22.35, 17.2) (-22.65, 17.2) (-22.65, 12.875) (-22.35, 12.875) (-22.35, 15.4), closed, covered)
  P52_OUTB1_L1.sweep_along_vector((0mm, 0mm, 0.07mm))
  P53_AC1_L1 [copper] = polyline(z=0.17mm, xy in mm: (-40.3908, 20.8189) (-40.35, 22) (-43.65, 22) (-43.65, 20.899) (-43.5816, 20.8048) (-40.449, 20.8) (-40.3908, 20.8189), closed, covered)
  P53_AC1_L1.sweep_along_vector((0mm, 0mm, 0.07mm))
  P54_AC2_L1 [copper] = polyline(z=0.17mm, xy in mm: (-3.8908, 20.8189) (-3.85, 22) (-7.15, 22) (-7.15, 20.899) (-7.0816, 20.8048) (-3.949, 20.8) (-3.8908, 20.8189), closed, covered)
  P54_AC2_L1.sweep_along_vector((0mm, 0mm, 0.07mm))
  P55_AC1_L1 = polyline(z=0.17mm, xy in mm: (-36.3943, 5.2189) (-36.3505, 6.6623) (-36.1153, 6.8975) (-35.1146, 6.9005) (-34.9004, 6.7685) (-34.8505, 5.299) (-34.7515, 5.2) (-34.2995, 5.2) (-34.2053, 5.2684) (-34.2005, 6.6612) (-34.1264, 6.8264) (-33.9611, 6.9005) (-33.3114, 6.8851) (-33.1495, 6.6611) (-33.1306, 5.2408) (-32.5995, 5.2) (-32.5005, 5.299) (-32.5005, 6.6612) (-32.3386, 6.8851) (-30.4106, 6.9005) (-30.2785, 6.8506) (-30.0687, 6.5591) (-29.6565, 6.6405) (-28.8335, 6.5877) (-28.7512, 6.67) (-28.75, 7.4505) (-28.849, 7.5495) (-29.621, 7.5495) (-29.9469, 7.2953) (-30.3847, 7.2025) (-31.4113, 7.2025) (-31.6465, 7.4377) (-31.6684, 8.8592) (-32.2005, 8.9) (-32.2995, 8.801) (-32.3149, 7.3614) (-32.5389, 7.1995) (-33.1886, 7.2149) (-33.3505, 7.4389) (-33.3694, 8.8592) (-33.9005, 8.9) (-33.9995, 8.801) (-34.0149, 7.3614) (-34.1614, 7.2149) (-34.8112, 7.1995) (-34.9764, 7.2736) (-35.0505, 7.4389) (-35.0505, 8.801) (-35.1189, 8.8952) (-37.651, 8.9) (-37.75, 8.801) (-37.75, 5.299) (-37.651, 5.2) (-36.4525, 5.2) (-36.3943, 5.2189), closed, covered)
  P55_AC1_L1.sweep_along_vector((0mm, 0mm, 0.07mm))
  P56_AC2_L1 = polyline(z=0.17mm, xy in mm: (-14.3913, 5.2189) (-14.3505, 6.6612) (-14.2764, 6.8264) (-14.1111, 6.9005) (-13.4614, 6.8851) (-13.3149, 6.7386) (-13.2995, 5.299) (-13.2311, 5.2048) (-12.7485, 5.2) (-12.6543, 5.2684) (-12.6465, 6.6623) (-12.5175, 6.8506) (-12.3854, 6.9005) (-11.4106, 6.9005) (-11.1964, 6.7685) (-11.1465, 5.299) (-11.0781, 5.2048) (-9.7908, 5.2189) (-9.7689, 8.8592) (-12.4087, 8.8811) (-12.4649, 7.3614) (-12.6114, 7.2149) (-13.2612, 7.1995) (-13.4264, 7.2736) (-13.5005, 7.4389) (-13.5194, 8.8592) (-14.0505, 8.9) (-14.1495, 8.801) (-14.1649, 7.3614) (-14.3114, 7.2149) (-14.9612, 7.1995) (-15.1264, 7.2736) (-15.2005, 7.4389) (-15.2194, 8.8592) (-15.7515, 8.9) (-15.8966, 8.68) (-15.8505, 7.4636) (-15.9825, 7.2494) (-17.0894, 7.1995) (-17.3427, 7.3439) (-17.7478, 7.1659) (-18.7318, 7.1502) (-18.75, 6.6495) (-18.651, 6.5505) (-17.879, 6.5505) (-17.5531, 6.8047) (-17.0894, 6.9005) (-15.1614, 6.8851) (-14.9995, 6.6611) (-14.9806, 5.2408) (-14.4495, 5.2) (-14.3913, 5.2189), closed, covered)
  P56_AC2_L1.sweep_along_vector((0mm, 0mm, 0.07mm))
  P57_AC1_L2 = polyline(z=0mm, xy in mm: (-40.4125, 20.8197) (-40.3555, 20.924) (-40.3555, 22) (-43.65, 22) (-43.65, 20.924) (-43.5775, 20.8112) (-40.4795, 20.8) (-40.4125, 20.8197), closed, covered)
  P57_AC1_L2.sweep_along_vector((0mm, 0mm, 0.07mm))
  P58_AC2_L2 = polyline(z=0mm, xy in mm: (-3.907, 20.8252) (-3.85, 20.9295) (-3.85, 22) (-7.1445, 22) (-7.1445, 20.9295) (-7.072, 20.8167) (-3.974, 20.8055) (-3.907, 20.8252), closed, covered)
  P58_AC2_L2.sweep_along_vector((0mm, 0mm, 0.07mm))
  P59_AC1_L3 = polyline(z=-1.27mm, xy in mm: (-29.207, 5.2197) (-29.15, 5.324) (-29.1697, 12.9556) (-29.6553, 13.3499) (-29.9117, 13.072) (-30.15, 12.9945) (-30.3883, 13.072) (-30.6553, 13.3499) (-30.9117, 13.072) (-31.15, 12.9945) (-31.3883, 13.072) (-31.6553, 13.3499) (-31.9117, 13.072) (-32.15, 12.9945) (-32.3883, 13.072) (-32.6553, 13.3499) (-32.9117, 13.072) (-33.15, 12.9945) (-33.3883, 13.072) (-33.6553, 13.3499) (-33.9117, 13.072) (-34.15, 12.9945) (-34.3883, 13.072) (-34.6553, 13.3499) (-34.9117, 13.072) (-35.15, 12.9945) (-35.3883, 13.072) (-35.6553, 13.3499) (-35.9117, 13.072) (-36.15, 12.9945) (-36.3883, 13.072) (-36.5356, 13.2747) (-36.5356, 13.5253) (-36.4206, 13.7236) (-36.5555, 14.1) (-36.4206, 14.4236) (-36.5555, 14.8) (-36.4206, 15.1236) (-36.5555, 15.5) (-36.478, 15.7383) (-36.2753, 15.8856) (-36.0247, 15.8856) (-35.6447, 15.5501) (-35.2753, 15.8856) (-35.0247, 15.8856) (-34.8504, 15.7946) (-34.7003, 15.9069) (-34.7, 18.5842) (-34.8416, 18.707) (-35.0247, 18.6144) (-35.2753, 18.6144) (-35.478, 18.7617) (-35.5555, 19) (-35.3956, 19.3486) (-35.5555, 19.75) (-35.478, 19.9883) (-35.15, 20.1555) (-34.7807, 20.0496) (-34.7003, 20.1569) (-34.7197, 20.4925) (-34.824, 20.5495) (-36.5198, 20.5495) (-36.6446, 20.6054) (-36.7005, 20.7302) (-36.7005, 22) (-37.2136, 22) (-37.1547, 21.3941) (-37.3123, 21.0135) (-37.6035, 20.7223) (-38.19, 20.5444) (-38.7765, 20.7223) (-39.0677, 21.0135) (-39.2253, 21.3941) (-39.1664, 22) (-43.65, 22) (-43.6303, 5.257) (-43.526, 5.2) (-29.274, 5.2) (-29.207, 5.2197), closed, covered)
  P59_AC1_L3_h0 = polyline(z=-1.27mm, xy in mm: (-42.2753, 13.0144) (-42.478, 13.1617) (-42.5555, 13.4) (-42.478, 13.6383) (-42.15, 13.8055) (-41.9117, 13.728) (-41.6447, 13.4501) (-41.3883, 13.728) (-41.15, 13.8055) (-40.9117, 13.728) (-40.6447, 13.4501) (-40.3883, 13.728) (-40.15, 13.8055) (-39.9117, 13.728) (-39.6447, 13.4501) (-39.3883, 13.728) (-39.0247, 13.7856) (-38.6447, 13.4501) (-38.3883, 13.728) (-38.15, 13.8055) (-37.9117, 13.728) (-37.7445, 13.4) (-37.822, 13.1617) (-38.15, 12.9945) (-38.3883, 13.072) (-38.6553, 13.3499) (-38.9117, 13.072) (-39.15, 12.9945) (-39.3883, 13.072) (-39.6553, 13.3499) (-39.9117, 13.072) (-40.15, 12.9945) (-40.3883, 13.072) (-40.6553, 13.3499) (-40.9117, 13.072) (-41.2753, 13.0144) (-41.6553, 13.3499) (-41.9117, 13.072) (-42.15, 12.9945) (-42.2753, 13.0144), closed, covered)
  P59_AC1_L3_h1 = polyline(z=-1.27mm, xy in mm: (-37.3503, 11.4144) (-37.6106, 11.6747) (-37.6106, 11.9253) (-37.4633, 12.1281) (-37.0997, 12.1856) (-36.897, 12.0383) (-36.8195, 11.8) (-36.897, 11.5617) (-37.225, 11.3945) (-37.3503, 11.4144), closed, covered)
  P59_AC1_L3_h2 = polyline(z=-1.27mm, xy in mm: (-30.1975, 10.0684) (-30.3876, 10.2065) (-30.4416, 10.5475) (-30.3035, 10.7376) (-29.9625, 10.7916) (-29.7724, 10.6535) (-29.7184, 10.3125) (-29.8565, 10.1224) (-30.08, 10.0498) (-30.1975, 10.0684), closed, covered)
  P59_AC1_L3_h3 = polyline(z=-1.27mm, xy in mm: (-30.1975, 7.3434) (-30.3876, 7.4815) (-30.4416, 7.8225) (-30.3035, 8.0126) (-29.9625, 8.0666) (-29.7724, 7.9285) (-29.7184, 7.5875) (-29.8565, 7.3974) (-30.08, 7.3248) (-30.1975, 7.3434), closed, covered)
  P59_AC1_L3_h4 = polyline(z=-1.27mm, xy in mm: (-30.1975, 5.7684) (-30.3876, 5.9065) (-30.4416, 6.2475) (-30.3035, 6.4376) (-29.9625, 6.4916) (-29.7724, 6.3535) (-29.7184, 6.0125) (-29.8565, 5.8224) (-30.08, 5.7498) (-30.1975, 5.7684), closed, covered)
  P59_AC1_L3.subtract(P59_AC1_L3_h0..P59_AC1_L3_h4)
  P59_AC1_L3.sweep_along_vector((0mm, 0mm, 0.07mm))
  P60_AC2_L3 = polyline(z=-1.27mm, xy in mm: (-3.907, 5.2197) (-3.85, 5.324) (-3.85, 22) (-8.2595, 22) (-8.2595, 20.7302) (-8.4402, 20.5495) (-10.2382, 20.5611) (-10.3605, 20.7302) (-10.3605, 22) (-10.8736, 22) (-10.7944, 21.6) (-10.8748, 21.196) (-11.2636, 20.7223) (-11.85, 20.5444) (-12.254, 20.6248) (-12.6616, 20.8817) (-12.8, 20.7585) (-12.7803, 20.0987) (-12.6584, 20.043) (-12.4753, 20.1356) (-12.2247, 20.1356) (-12.022, 19.9883) (-11.9445, 19.75) (-12.1044, 19.4014) (-11.9445, 19) (-12.022, 18.7617) (-12.2247, 18.6144) (-12.4753, 18.6144) (-12.6496, 18.7054) (-12.7997, 18.5931) (-12.8, 15.9158) (-12.6584, 15.793) (-12.4753, 15.8856) (-12.2247, 15.8856) (-11.8447, 15.5501) (-11.4753, 15.8856) (-11.2247, 15.8856) (-11.022, 15.7383) (-10.9445, 15.5) (-11.0744, 15.1067) (-10.9445, 14.8) (-11.0794, 14.4764) (-10.9445, 14.1) (-11.0794, 13.7764) (-10.9644, 13.5253) (-10.9644, 13.2747) (-11.1117, 13.072) (-11.35, 12.9945) (-11.5883, 13.072) (-11.8553, 13.3499) (-12.1117, 13.072) (-12.35, 12.9945) (-12.5883, 13.072) (-12.8553, 13.3499) (-13.1117, 13.072) (-13.35, 12.9945) (-13.5883, 13.072) (-13.8553, 13.3499) (-14.1117, 13.072) (-14.35, 12.9945) (-14.5883, 13.072) (-14.8553, 13.3499) (-15.1117, 13.072) (-15.35, 12.9945) (-15.5883, 13.072) (-15.8553, 13.3499) (-16.1117, 13.072) (-16.35, 12.9945) (-16.5883, 13.072) (-16.8553, 13.3499) (-17.1117, 13.072) (-17.35, 12.9945) (-17.5883, 13.072) (-17.8553, 13.3499) (-18.1117, 13.072) (-18.3085, 12.9811) (-18.3303, 5.257) (-18.226, 5.2) (-3.974, 5.2) (-3.907, 5.2197), closed, covered)
  P60_AC2_L3_h0 = polyline(z=-1.27mm, xy in mm: (-9.4753, 13.0144) (-9.6781, 13.1617) (-9.7555, 13.4) (-9.6781, 13.6383) (-9.35, 13.8055) (-9.1117, 13.728) (-8.8447, 13.4501) (-8.5883, 13.728) (-8.35, 13.8055) (-8.1117, 13.728) (-7.8447, 13.4501) (-7.5883, 13.728) (-7.35, 13.8055) (-7.1117, 13.728) (-6.8447, 13.4501) (-6.4753, 13.7856) (-6.1117, 13.728) (-5.8447, 13.4501) (-5.5883, 13.728) (-5.35, 13.8055) (-5.1117, 13.728) (-4.9445, 13.4) (-5.022, 13.1617) (-5.35, 12.9945) (-5.5883, 13.072) (-5.8553, 13.3499) (-6.1117, 13.072) (-6.35, 12.9945) (-6.5883, 13.072) (-6.8553, 13.3499) (-7.1117, 13.072) (-7.35, 12.9945) (-7.5883, 13.072) (-7.8553, 13.3499) (-8.1117, 13.072) (-8.4753, 13.0144) (-8.8553, 13.3499) (-9.1117, 13.072) (-9.35, 12.9945) (-9.4753, 13.0144), closed, covered)
  P60_AC2_L3_h1 = polyline(z=-1.27mm, xy in mm: (-10.4003, 11.4144) (-10.6606, 11.6747) (-10.6606, 11.9253) (-10.5133, 12.1281) (-10.1497, 12.1856) (-9.9469, 12.0383) (-9.8695, 11.8) (-9.9469, 11.5617) (-10.275, 11.3945) (-10.4003, 11.4144), closed, covered)
  P60_AC2_L3_h2 = polyline(z=-1.27mm, xy in mm: (-17.5375, 10.3334) (-17.7276, 10.4715) (-17.7816, 10.8125) (-17.6435, 11.0026) (-17.3025, 11.0566) (-17.1124, 10.9185) (-17.0584, 10.5775) (-17.1965, 10.3874) (-17.42, 10.3148) (-17.5375, 10.3334), closed, covered)
  P60_AC2_L3_h3 = polyline(z=-1.27mm, xy in mm: (-17.5375, 7.6084) (-17.7276, 7.7465) (-17.7816, 8.0875) (-17.6435, 8.2776) (-17.3025, 8.3316) (-17.1124, 8.1935) (-17.0584, 7.8525) (-17.1965, 7.6624) (-17.42, 7.5898) (-17.5375, 7.6084), closed, covered)
  P60_AC2_L3_h4 = polyline(z=-1.27mm, xy in mm: (-17.5375, 6.0334) (-17.7276, 6.1715) (-17.7816, 6.5125) (-17.6435, 6.7026) (-17.3025, 6.7566) (-17.1124, 6.6185) (-17.0584, 6.2775) (-17.1965, 6.0874) (-17.42, 6.0148) (-17.5375, 6.0334), closed, covered)
  P60_AC2_L3.subtract(P60_AC2_L3_h0..P60_AC2_L3_h4)
  P60_AC2_L3.sweep_along_vector((0mm, 0mm, 0.07mm))
  P61_AC1_L4 = polyline(z=-1.44mm, xy in mm: (-38.5663, 4.6189) (-38.5226, 5.0147) (-38.3971, 5.2522) (-38.1597, 5.3776) (-37.7245, 5.3805) (-37.6255, 5.4795) (-37.6444, 6.8387) (-38.2879, 6.9272) (-38.5226, 7.2453) (-38.4778, 8.0929) (-38.1293, 8.3305) (-36.1621, 8.2828) (-35.9245, 7.9343) (-35.9274, 7.2453) (-36.0862, 6.8982) (-35.9923, 6.8305) (-35.2121, 6.7828) (-34.9603, 6.4731) (-34.3987, 6.4744) (-34.1003, 6.7906) (-33.5435, 6.8055) (-33.3367, 6.7331) (-33.1745, 6.4365) (-33.1745, 5.8235) (-33.3169, 5.52) (-33.264, 5.4163) (-32.6227, 5.4244) (-32.5867, 5.5351) (-32.7255, 5.8235) (-32.7255, 6.4365) (-32.653, 6.6433) (-32.4503, 6.7906) (-31.8935, 6.8055) (-31.6867, 6.7331) (-31.4431, 6.4555) (-30.3971, 6.4555) (-30.08, 6.5608) (-29.8268, 6.4785) (-29.6703, 6.2631) (-29.7315, 5.8768) (-29.9469, 5.7203) (-30.3971, 5.8045) (-31.4431, 5.8045) (-31.6669, 5.52) (-31.614, 5.4163) (-29.967, 5.3906) (-29.7694, 5.193) (-29.7545, 4.699) (-29.6861, 4.6048) (-27.0908, 4.6189) (-27.05, 9.901) (-27.149, 10) (-28.35, 10) (-28.35, 14.901) (-28.4184, 14.9952) (-28.5589, 15) (-28.653, 14.9316) (-28.7587, 14.4585) (-28.6444, 14.1) (-28.7587, 13.7585) (-28.6648, 13.5425) (-28.6648, 13.2575) (-28.8189, 13.0179) (-29.078, 12.8995) (-29.3601, 12.94) (-29.6276, 13.158) (-30.078, 12.8995) (-30.3601, 12.94) (-30.6276, 13.158) (-31.078, 12.8995) (-31.3601, 12.94) (-31.6276, 13.158) (-32.078, 12.8995) (-32.3601, 12.94) (-32.6276, 13.158) (-33.078, 12.8995) (-33.3601, 12.94) (-33.6276, 13.158) (-34.078, 12.8995) (-34.3601, 12.94) (-34.6276, 13.158) (-35.078, 12.8995) (-35.3601, 12.94) (-35.6276, 13.158) (-35.9399, 12.94) (-36.222, 12.8995) (-36.4811, 13.0179) (-36.7368, 13.3154) (-36.8245, 13.217) (-36.8245, 12.139) (-36.7398, 11.6575) (-36.8939, 11.4179) (-37.153, 11.2995) (-37.4351, 11.34) (-37.7102, 11.6575) (-37.7102, 11.9425) (-37.6259, 12.1305) (-37.6444, 13.0338) (-37.7551, 13.0697) (-37.9399, 12.94) (-38.222, 12.8995) (-38.6885, 13.1528) (-39.1089, 12.8191) (-38.835, 12.3328) (-38.8157, 11.4797) (-38.1563, 11.2727) (-37.7986, 10.756) (-34.7656, 10.7555) (-34.4102, 11.2605) (-34.0316, 11.4055) (-33.4478, 11.3991) (-32.9655, 11.1129) (-32.4522, 11.3991) (-31.7978, 11.3991) (-31.4898, 11.2605) (-31.1461, 10.7562) (-30.3971, 10.7555) (-30.08, 10.8608) (-29.8268, 10.7785) (-29.6492, 10.43) (-29.8268, 10.0815) (-30.08, 9.9992) (-30.3971, 10.1045) (-31.1344, 10.1045) (-31.2286, 10.0361) (-31.3013, 9.7961) (-31.2027, 9.7055) (-30.0226, 9.7055) (-29.7938, 9.5453) (-29.7545, 8.0221) (-29.6492, 7.705) (-29.8268, 7.3565) (-30.2131, 7.2953) (-30.4897, 7.5719) (-30.4055, 8.0221) (-30.4055, 8.9555) (-30.5045, 9.0545) (-38.7255, 9.0545) (-38.8197, 8.9861) (-38.835, 8.5272) (-38.9823, 8.2113) (-39.4222, 7.94) (-41.325, 7.9295) (-41.7437, 8.0873) (-42.015, 8.5272) (-42.0255, 9.28) (-41.9598, 9.5493) (-41.5943, 9.9148) (-40.8663, 9.9994) (-40.8255, 10.7805) (-40.8939, 10.8747) (-41.5943, 10.9452) (-41.9598, 11.3107) (-42.0255, 11.58) (-42.015, 12.3328) (-41.8677, 12.6487) (-41.4763, 12.976) (-41.6276, 13.158) (-41.9399, 12.94) (-42.3601, 12.94) (-42.6352, 13.2575) (-42.5754, 13.6734) (-42.222, 13.9005) (-41.9399, 13.86) (-41.6724, 13.642) (-41.222, 13.9005) (-40.9399, 13.86) (-40.6724, 13.642) (-40.222, 13.9005) (-39.9399, 13.86) (-39.6724, 13.642) (-39.222, 13.9005) (-38.9399, 13.86) (-38.6724, 13.642) (-38.222, 13.9005) (-37.686, 13.7332) (-37.6255, 13.8244) (-37.6255, 14.2899) (-37.7245, 14.3889) (-41.6348, 14.3889) (-42.0046, 14.5779) (-42.1161, 14.8686) (-42.1161, 16.4899) (-41.9827, 16.8) (-40.3038, 16.8) (-40.0042, 16.3934) (-39.4913, 16.2113) (-38.9958, 16.3934) (-38.5014, 17.0058) (-38.9958, 17.6066) (-39.4913, 17.7887) (-40.0042, 17.6066) (-40.3066, 17.2) (-41.9854, 17.2) (-42.1161, 17.5086) (-42.1161, 19.1299) (-42.0252, 19.3946) (-41.8249, 19.5638) (-41.6361, 19.6111) (-37.3651, 19.6111) (-37.1004, 19.5202) (-36.9129, 19.2757) (-36.8195, 18.67) (-36.8245, 15.683) (-36.7561, 15.5888) (-36.6454, 15.6248) (-36.4811, 15.8821) (-36.222, 16.0005) (-35.9399, 15.96) (-35.6724, 15.742) (-35.222, 16.0005) (-34.9399, 15.96) (-34.6724, 15.742) (-34.222, 16.0005) (-33.9399, 15.96) (-33.6724, 15.742) (-33.222, 16.0005) (-32.9399, 15.96) (-32.6724, 15.742) (-32.222, 16.0005) (-31.9399, 15.96) (-31.6724, 15.742) (-31.222, 16.0005) (-30.9399, 15.96) (-30.6724, 15.742) (-30.3601, 15.96) (-30.078, 16.0005) (-29.6115, 15.7472) (-29.15, 16.0929) (-29.15, 17.801) (-29.249, 17.9) (-34.7, 17.9) (-34.7189, 18.5711) (-34.8296, 18.6071) (-35.078, 18.4995) (-35.3601, 18.54) (-35.5754, 18.7266) (-35.6556, 19) (-35.5197, 19.3665) (-35.6556, 19.75) (-35.5754, 20.0234) (-35.222, 20.2505) (-34.7363, 20.1604) (-34.7189, 20.5087) (-36.6445, 20.6054) (-36.7005, 20.7302) (-36.7005, 22) (-37.2136, 22) (-37.1547, 21.3941) (-37.3123, 21.0135) (-37.6035, 20.7223) (-38.19, 20.5444) (-38.7765, 20.7223) (-39.0677, 21.0135) (-39.2253, 21.3941) (-39.1664, 22) (-43.65, 22) (-43.65, 4.699) (-43.551, 4.6) (-38.6245, 4.6) (-38.5663, 4.6189), closed, covered)
  P61_AC1_L4_h0 = polyline(z=-1.44mm, xy in mm: (-27.8831, 7.4903) (-28.0985, 7.6468) (-28.1597, 8.0331) (-28.0032, 8.2485) (-27.6169, 8.3097) (-27.4015, 8.1532) (-27.3192, 7.9) (-27.4015, 7.6468) (-27.75, 7.4692) (-27.8831, 7.4903), closed, covered)
  P61_AC1_L4.subtract(P61_AC1_L4_h0)
  P61_AC1_L4.sweep_along_vector((0mm, 0mm, 0.07mm))
  P62_AC2_L4 = polyline(z=-1.44mm, xy in mm: (-17.7863, 4.6189) (-17.7455, 6.0779) (-17.8297, 6.5281) (-17.6732, 6.7435) (-17.42, 6.8258) (-17.1668, 6.7435) (-17.0103, 6.5281) (-17.0945, 6.0779) (-17.0945, 5.1445) (-17.0261, 5.0503) (-11.6745, 5.0455) (-11.5803, 5.1139) (-11.5278, 5.6329) (-11.3379, 5.8228) (-9.3707, 5.8705) (-9.0222, 5.6329) (-8.9975, 4.6705) (-8.9049, 4.6) (-3.8908, 4.6189) (-3.85, 22) (-7.9595, 22) (-7.9659, 20.6425) (-8.2177, 20.3062) (-8.4121, 20.2495) (-10.2675, 20.2559) (-10.5175, 20.3924) (-10.7337, 20.7429) (-11.3863, 20.3261) (-11.954, 20.2345) (-11.9995, 20.1273) (-11.8444, 19.75) (-11.9803, 19.3835) (-11.8648, 19.1425) (-11.8648, 18.8575) (-12.1399, 18.54) (-12.422, 18.4995) (-12.7637, 18.5896) (-12.8, 17.9) (-18.3092, 17.8811) (-18.35, 16.0957) (-17.8724, 15.742) (-17.422, 16.0005) (-17.1399, 15.96) (-16.8724, 15.742) (-16.422, 16.0005) (-16.1399, 15.96) (-15.8724, 15.742) (-15.422, 16.0005) (-15.1399, 15.96) (-14.8724, 15.742) (-14.422, 16.0005) (-14.1399, 15.96) (-13.8724, 15.742) (-13.422, 16.0005) (-13.1399, 15.96) (-12.8724, 15.742) (-12.422, 16.0005) (-12.1399, 15.96) (-11.8724, 15.742) (-11.5601, 15.96) (-11.278, 16.0005) (-11.0189, 15.8821) (-10.7632, 15.5846) (-10.6755, 15.683) (-10.6805, 18.67) (-10.578, 19.2978) (-10.4269, 19.4997) (-10.1361, 19.6111) (-5.6972, 19.573) (-5.4953, 19.4219) (-5.3839, 19.1314) (-5.3839, 17.5102) (-5.5173, 17.2) (-7.1962, 17.2) (-7.4958, 17.6066) (-8.0087, 17.7887) (-8.5042, 17.6066) (-8.9986, 16.9942) (-8.5042, 16.3934) (-8.0087, 16.2113) (-7.4958, 16.3934) (-7.1934, 16.8) (-5.5147, 16.8) (-5.3839, 16.4914) (-5.3839, 14.8702) (-5.4747, 14.6056) (-5.8639, 14.3889) (-9.7755, 14.3889) (-9.8697, 14.3204) (-9.8745, 13.8244) (-9.7449, 13.7303) (-9.5601, 13.86) (-9.278, 13.9005) (-8.8724, 13.642) (-8.5601, 13.86) (-8.278, 13.9005) (-7.8724, 13.642) (-7.5601, 13.86) (-7.278, 13.9005) (-6.8724, 13.642) (-6.5601, 13.86) (-6.278, 13.9005) (-5.8724, 13.642) (-5.5601, 13.86) (-5.278, 13.9005) (-4.9246, 13.6734) (-4.8444, 13.4) (-4.9246, 13.1266) (-5.278, 12.8995) (-5.5601, 12.94) (-5.8276, 13.158) (-6.278, 12.8995) (-6.5601, 12.94) (-6.8276, 13.158) (-7.278, 12.8995) (-7.5601, 12.94) (-7.8276, 13.158) (-8.278, 12.8995) (-8.5601, 12.94) (-8.8276, 13.158) (-9.278, 12.8995) (-9.814, 13.0668) (-9.8745, 12.9756) (-9.8745, 12.139) (-9.7898, 11.6575) (-10.0649, 11.34) (-10.347, 11.2995) (-10.6061, 11.4179) (-10.7602, 11.6575) (-10.6755, 12.139) (-10.6755, 13.217) (-10.7439, 13.3112) (-10.8546, 13.2752) (-11.0189, 13.0179) (-11.278, 12.8995) (-11.5601, 12.94) (-11.8276, 13.158) (-12.278, 12.8995) (-12.5601, 12.94) (-12.8276, 13.158) (-13.278, 12.8995) (-13.5601, 12.94) (-13.8276, 13.158) (-14.278, 12.8995) (-14.5601, 12.94) (-14.8276, 13.158) (-15.278, 12.8995) (-15.5601, 12.94) (-15.8276, 13.158) (-16.278, 12.8995) (-16.5601, 12.94) (-16.8276, 13.158) (-17.278, 12.8995) (-17.5601, 12.94) (-17.8276, 13.158) (-18.1399, 12.94) (-18.422, 12.8995) (-18.6811, 13.0179) (-18.8352, 13.2575) (-18.8352, 13.5425) (-18.7413, 13.7415) (-18.8556, 14.1) (-18.7413, 14.4415) (-18.8536, 14.9472) (-19.1092, 14.9811) (-19.15, 10) (-20.351, 10) (-20.45, 9.901) (-20.45, 4.699) (-20.351, 4.6) (-17.8445, 4.6) (-17.7863, 4.6189), closed, covered)
  P62_AC2_L4_h0 = polyline(z=-1.44mm, xy in mm: (-8.0778, 5.48) (-8.3937, 5.6273) (-8.6098, 5.9007) (-8.6843, 6.9203) (-9.3437, 7.1273) (-9.7014, 7.644) (-12.7344, 7.6445) (-13.0898, 7.1395) (-13.4684, 6.9945) (-14.0522, 7.0009) (-14.5345, 7.2871) (-15.0478, 7.0009) (-15.7022, 7.0009) (-16.0102, 7.1395) (-16.3539, 7.6438) (-17.1029, 7.6445) (-17.42, 7.5392) (-17.6732, 7.6215) (-17.8508, 7.97) (-17.6732, 8.3185) (-17.42, 8.4008) (-17.1029, 8.2955) (-16.3656, 8.2955) (-16.2714, 8.3639) (-16.1987, 8.6039) (-16.2973, 8.6945) (-17.4774, 8.6945) (-17.7062, 8.8547) (-17.7455, 10.3779) (-17.8508, 10.695) (-17.7685, 10.9482) (-17.42, 11.1258) (-17.1668, 11.0435) (-17.0103, 10.8281) (-17.0945, 10.3779) (-17.0945, 9.4445) (-16.9955, 9.3455) (-8.7745, 9.3455) (-8.6803, 9.4139) (-8.6098, 10.0393) (-8.2443, 10.4048) (-7.975, 10.4705) (-6.175, 10.4705) (-5.9057, 10.4048) (-5.6323, 10.1887) (-5.485, 9.8728) (-5.485, 9.0172) (-5.6323, 8.7013) (-5.9057, 8.4852) (-6.6337, 8.4006) (-6.6745, 7.6195) (-6.6061, 7.5253) (-5.9057, 7.4548) (-5.6323, 7.2387) (-5.4745, 6.82) (-5.5402, 5.9007) (-5.7563, 5.6273) (-6.0722, 5.48) (-7.975, 5.4695) (-8.0778, 5.48), closed, covered)
  P62_AC2_L4.subtract(P62_AC2_L4_h0)
  P62_AC2_L4.sweep_along_vector((0mm, 0mm, 0.07mm))
  P63_VDDA1_L1 [copper] = polyline(z=0.17mm, xy in mm: (-25.5344, 17.1825) (-25.8325, 17.2156) (-25.9656, 16.0175) (-25.6675, 15.9844) (-25.5344, 17.1825), closed, covered)
  P63_VDDA1_L1.sweep_along_vector((0mm, 0mm, 0.07mm))
  P64_VDDA1_L3 = polyline(z=-1.27mm, xy in mm: (-25.65, 17.45) (-33.4, 17.45) (-33.4, 22) (-33.7, 22) (-33.7, 17.15) (-25.95, 17.15) (-25.95, 16) (-25.65, 16) (-25.65, 17.45), closed, covered)
  P64_VDDA1_L3.sweep_along_vector((0mm, 0mm, 0.07mm))
  P65_VDDA1_L4 = polyline(z=-1.44mm, xy in mm: (-25.65, 16.3125) (-26.9, 16.3125) (-26.9, 16.0125) (-25.65, 16.0125) (-25.65, 16.3125), closed, covered)
  P65_VDDA1_L4.sweep_along_vector((0mm, 0mm, 0.07mm))
  P66_VDDB1_L1 [copper] = polyline(z=0.17mm, xy in mm: (-22.9274, 17.1733) (-23.2233, 17.2226) (-23.4226, 16.0267) (-23.1267, 15.9774) (-22.9274, 17.1733), closed, covered)
  P66_VDDB1_L1.sweep_along_vector((0mm, 0mm, 0.07mm))
  P67_VDDB1_L3 = polyline(z=-1.27mm, xy in mm: (-23.1, 17.85) (-14.4, 17.85) (-14.4, 22) (-14.7, 22) (-14.7, 18.15) (-23.4, 18.15) (-23.4, 16) (-23.1, 16) (-23.1, 17.85), closed, covered)
  P67_VDDB1_L3.sweep_along_vector((0mm, 0mm, 0.07mm))
  P68_VDDB1_L4 = polyline(z=-1.44mm, xy in mm: (-22.5, 16.3125) (-23.4, 16.3125) (-23.4, 16.0125) (-22.5, 16.0125) (-22.5, 16.3125), closed, covered)
  P68_VDDB1_L4.sweep_along_vector((0mm, 0mm, 0.07mm))
  P69_VEEA1_L1 [copper] = polyline(z=0.17mm, xy in mm: (-24.0774, 16.0267) (-24.2767, 17.2226) (-24.5726, 17.1733) (-24.3733, 15.9774) (-24.0774, 16.0267), closed, covered)
  P69_VEEA1_L1.sweep_along_vector((0mm, 0mm, 0.07mm))
  P70_VEEA1_L3 = polyline(z=-1.27mm, xy in mm: (-24.1, 18.15) (-32.8, 18.15) (-32.8, 22) (-33.1, 22) (-33.1, 17.85) (-24.4, 17.85) (-24.4, 16) (-24.1, 16) (-24.1, 18.15), closed, covered)
  P70_VEEA1_L3.sweep_along_vector((0mm, 0mm, 0.07mm))
  P71_VEEA1_L4 = polyline(z=-1.44mm, xy in mm: (-24.1, 16.3125) (-25, 16.3125) (-25, 16.0125) (-24.1, 16.0125) (-24.1, 16.3125), closed, covered)
  P71_VEEA1_L4.sweep_along_vector((0mm, 0mm, 0.07mm))
  P72_VEEB1_L1 [copper] = polyline(z=0.17mm, xy in mm: (-21.5344, 16.0175) (-21.6675, 17.2156) (-21.9656, 17.1825) (-21.8325, 15.9844) (-21.5344, 16.0175), closed, covered)
  P72_VEEB1_L1.sweep_along_vector((0mm, 0mm, 0.07mm))
  P73_VEEB1_L3 = polyline(z=-1.27mm, xy in mm: (-21.55, 17.15) (-13.8, 17.15) (-13.8, 22) (-14.1, 22) (-14.1, 17.45) (-21.85, 17.45) (-21.85, 16) (-21.55, 16) (-21.55, 17.15), closed, covered)
  P73_VEEB1_L3.sweep_along_vector((0mm, 0mm, 0.07mm))
  P74_VEEB1_L4 = polyline(z=-1.44mm, xy in mm: (-20.6, 16.3125) (-21.85, 16.3125) (-21.85, 16.0125) (-20.6, 16.0125) (-20.6, 16.3125), closed, covered)
  P74_VEEB1_L4.sweep_along_vector((0mm, 0mm, 0.07mm))
  V0_DCP = cylinder(axis=Z, base_centre=(-12.9mm, 2.5mm, -1.44mm), radius=0.15mm, height=1.68mm)
  V1_DCP = cylinder(axis=Z, base_centre=(-18.3mm, 2.5mm, -1.44mm), radius=0.15mm, height=1.68mm)
  V2_DCP = cylinder(axis=Z, base_centre=(-32.8mm, 2.5mm, -1.44mm), radius=0.15mm, height=1.68mm)
  V3_DCP = cylinder(axis=Z, base_centre=(-31mm, 2.5mm, -1.44mm), radius=0.15mm, height=1.68mm)
  V4_DCP = cylinder(axis=Z, base_centre=(-34.6mm, 2.5mm, -1.44mm), radius=0.15mm, height=1.68mm)
  V5_DCP = cylinder(axis=Z, base_centre=(-29.2mm, 2.5mm, -1.44mm), radius=0.15mm, height=1.68mm)
  V6_DCP = cylinder(axis=Z, base_centre=(-15.6mm, 2.5mm, -1.44mm), radius=0.15mm, height=1.68mm)
  V7_DCP = cylinder(axis=Z, base_centre=(-16.5mm, 2.5mm, -1.44mm), radius=0.15mm, height=1.68mm)
  V8_DCP = cylinder(axis=Z, base_centre=(-35.5mm, 2.5mm, -1.44mm), radius=0.15mm, height=1.68mm)
  V9_DCP = cylinder(axis=Z, base_centre=(-33.7mm, 2.5mm, -1.44mm), radius=0.15mm, height=1.68mm)
  V10_DCP = cylinder(axis=Z, base_centre=(-30.1mm, 2.5mm, -1.44mm), radius=0.15mm, height=1.68mm)
  V11_DCP = cylinder(axis=Z, base_centre=(-17.4mm, 2.5mm, -1.44mm), radius=0.15mm, height=1.68mm)
  V12_DCP = cylinder(axis=Z, base_centre=(-31.9mm, 2.5mm, -1.44mm), radius=0.15mm, height=1.68mm)
  V13_DCP = cylinder(axis=Z, base_centre=(-12mm, 2.5mm, -1.44mm), radius=0.15mm, height=1.68mm)
  V14_DCP = cylinder(axis=Z, base_centre=(-14.7mm, 2.5mm, -1.44mm), radius=0.15mm, height=1.68mm)
  V15_DCP = cylinder(axis=Z, base_centre=(-13.8mm, 2.5mm, -1.44mm), radius=0.15mm, height=1.68mm)
  V16_DCN = cylinder(axis=Z, base_centre=(-30.15mm, 15.5mm, -1.44mm), radius=0.15mm, height=1.68mm)
  V17_DCN = cylinder(axis=Z, base_centre=(-35.15mm, 15.5mm, -1.44mm), radius=0.15mm, height=1.68mm)
  V18_DCN = cylinder(axis=Z, base_centre=(-14.35mm, 15.5mm, -1.44mm), radius=0.15mm, height=1.68mm)
  V19_DCN = cylinder(axis=Z, base_centre=(-33.15mm, 14.1mm, -1.44mm), radius=0.15mm, height=1.68mm)
  V20_DCN = cylinder(axis=Z, base_centre=(-9.5346mm, -0.5mm, -1.44mm), radius=0.15mm, height=1.68mm)
  V21_DCN = cylinder(axis=Z, base_centre=(-11.9038mm, -0.5mm, -1.44mm), radius=0.15mm, height=1.68mm)
  V22_DCN = cylinder(axis=Z, base_centre=(-41.15mm, 13.4mm, -1.44mm), radius=0.15mm, height=1.68mm)
  V23_DCN = cylinder(axis=Z, base_centre=(-11.35mm, 13.4mm, -1.44mm), radius=0.15mm, height=1.68mm)
  V24_DCN = cylinder(axis=Z, base_centre=(-35.15mm, 19.75mm, -1.44mm), radius=0.15mm, height=1.68mm)
  V25_DCN = cylinder(axis=Z, base_centre=(-13.35mm, 14.8mm, -1.44mm), radius=0.15mm, height=1.68mm)
  V26_DCN = cylinder(axis=Z, base_centre=(-36.15mm, 14.8mm, -1.44mm), radius=0.15mm, height=1.68mm)
  V27_DCN = cylinder(axis=Z, base_centre=(-29.15mm, 14.1mm, -1.44mm), radius=0.15mm, height=1.68mm)
  V28_DCN = cylinder(axis=Z, base_centre=(-32.0423mm, -0.5mm, -1.44mm), radius=0.15mm, height=1.68mm)
  V29_DCN = cylinder(axis=Z, base_centre=(-33.15mm, 15.5mm, -1.44mm), radius=0.15mm, height=1.68mm)
  V30_DCN = cylinder(axis=Z, base_centre=(-30.15mm, 13.4mm, -1.44mm), radius=0.15mm, height=1.68mm)
  V31_DCN = cylinder(axis=Z, base_centre=(-36.15mm, 15.5mm, -1.44mm), radius=0.15mm, height=1.68mm)
  V32_DCN = cylinder(axis=Z, base_centre=(-7.35mm, 13.4mm, -1.44mm), radius=0.15mm, height=1.68mm)
  V33_DCN = cylinder(axis=Z, base_centre=(-21.3808mm, -0.5mm, -1.44mm), radius=0.15mm, height=1.68mm)
  V34_DCN = cylinder(axis=Z, base_centre=(-12.35mm, 19mm, -1.44mm), radius=0.15mm, height=1.68mm)
  V35_DCN = cylinder(axis=Z, base_centre=(-15.35mm, 14.8mm, -1.44mm), radius=0.15mm, height=1.68mm)
  V36_DCN = cylinder(axis=Z, base_centre=(-16.6423mm, -0.5mm, -1.44mm), radius=0.15mm, height=1.68mm)
  V37_DCN = cylinder(axis=Z, base_centre=(-35.5962mm, -0.5mm, -1.44mm), radius=0.15mm, height=1.68mm)
  V38_DCN = cylinder(axis=Z, base_centre=(-31.15mm, 13.4mm, -1.44mm), radius=0.15mm, height=1.68mm)
  V39_DCN = cylinder(axis=Z, base_centre=(-26.1192mm, -0.5mm, -1.44mm), radius=0.15mm, height=1.68mm)
  V40_DCN = cylinder(axis=Z, base_centre=(-18.35mm, 15.5mm, -1.44mm), radius=0.15mm, height=1.68mm)
  V41_DCN = cylinder(axis=Z, base_centre=(-17.35mm, 15.5mm, -1.44mm), radius=0.15mm, height=1.68mm)
  V42_DCN = cylinder(axis=Z, base_centre=(-39.15mm, -0.5mm, -1.44mm), radius=0.15mm, height=1.68mm)
  V43_DCN = cylinder(axis=Z, base_centre=(-16.35mm, 14.1mm, -1.44mm), radius=0.15mm, height=1.68mm)
  V44_DCN = cylinder(axis=Z, base_centre=(-42.15mm, 13.4mm, -1.44mm), radius=0.15mm, height=1.68mm)
  V45_DCN = cylinder(axis=Z, base_centre=(-20.1962mm, -0.5mm, -1.44mm), radius=0.15mm, height=1.68mm)
  V46_DCN = cylinder(axis=Z, base_centre=(-11.35mm, 14.8mm, -1.44mm), radius=0.15mm, height=1.68mm)
  V47_DCN = cylinder(axis=Z, base_centre=(-19.0115mm, -0.5mm, -1.44mm), radius=0.15mm, height=1.68mm)
  V48_DCN = cylinder(axis=Z, base_centre=(-12.35mm, 13.4mm, -1.44mm), radius=0.15mm, height=1.68mm)
  V49_DCN = cylinder(axis=Z, base_centre=(-29.15mm, 14.8mm, -1.44mm), radius=0.15mm, height=1.68mm)
  V50_DCN = cylinder(axis=Z, base_centre=(-17.8269mm, -0.5mm, -1.44mm), radius=0.15mm, height=1.68mm)
  V51_DCN = cylinder(axis=Z, base_centre=(-3.55mm, -0.5mm, -1.44mm), radius=0.15mm, height=1.68mm)
  V52_DCN = cylinder(axis=Z, base_centre=(-11.35mm, 15.5mm, -1.44mm), radius=0.15mm, height=1.68mm)
  V53_DCN = cylinder(axis=Z, base_centre=(-27.3038mm, -0.5mm, -1.44mm), radius=0.15mm, height=1.68mm)
  V54_DCN = cylinder(axis=Z, base_centre=(-36.7808mm, -0.5mm, -1.44mm), radius=0.15mm, height=1.68mm)
  V55_DCN = cylinder(axis=Z, base_centre=(-35.15mm, 14.8mm, -1.44mm), radius=0.15mm, height=1.68mm)
  V56_DCN = cylinder(axis=Z, base_centre=(-28.4885mm, -0.5mm, -1.44mm), radius=0.15mm, height=1.68mm)
  V57_DCN = cylinder(axis=Z, base_centre=(-32.15mm, 13.4mm, -1.44mm), radius=0.15mm, height=1.68mm)
  V58_DCN = cylinder(axis=Z, base_centre=(-32.15mm, 14.8mm, -1.44mm), radius=0.15mm, height=1.68mm)
  V59_DCN = cylinder(axis=Z, base_centre=(-16.35mm, 15.5mm, -1.44mm), radius=0.15mm, height=1.68mm)
  V60_DCN = cylinder(axis=Z, base_centre=(-12.35mm, 15.5mm, -1.44mm), radius=0.15mm, height=1.68mm)
  V61_DCN = cylinder(axis=Z, base_centre=(-33.15mm, 14.8mm, -1.44mm), radius=0.15mm, height=1.68mm)
  V62_DCN = cylinder(axis=Z, base_centre=(-14.35mm, 14.1mm, -1.44mm), radius=0.15mm, height=1.68mm)
  V63_DCN = cylinder(axis=Z, base_centre=(-29.6731mm, -0.5mm, -1.44mm), radius=0.15mm, height=1.68mm)
  V64_DCN = cylinder(axis=Z, base_centre=(-36.15mm, 13.4mm, -1.44mm), radius=0.15mm, height=1.68mm)
  V65_DCN = cylinder(axis=Z, base_centre=(-34.4115mm, -0.5mm, -1.44mm), radius=0.15mm, height=1.68mm)
  V66_DCN = cylinder(axis=Z, base_centre=(-15.4577mm, -0.5mm, -1.44mm), radius=0.15mm, height=1.68mm)
  V67_DCN = cylinder(axis=Z, base_centre=(-8.35mm, 13.4mm, -1.44mm), radius=0.15mm, height=1.68mm)
  V68_DCN = cylinder(axis=Z, base_centre=(-10.7192mm, -0.5mm, -1.44mm), radius=0.15mm, height=1.68mm)
  V69_DCN = cylinder(axis=Z, base_centre=(-15.35mm, 15.5mm, -1.44mm), radius=0.15mm, height=1.68mm)
  V70_DCN = cylinder(axis=Z, base_centre=(-13.35mm, 15.5mm, -1.44mm), radius=0.15mm, height=1.68mm)
  V71_DCN = cylinder(axis=Z, base_centre=(-8.35mm, -0.5mm, -1.44mm), radius=0.15mm, height=1.68mm)
  V72_DCN = cylinder(axis=Z, base_centre=(-24.9346mm, -0.5mm, -1.44mm), radius=0.15mm, height=1.68mm)
  V73_DCN = cylinder(axis=Z, base_centre=(-30.8577mm, -0.5mm, -1.44mm), radius=0.15mm, height=1.68mm)
  V74_DCN = cylinder(axis=Z, base_centre=(-35.15mm, 14.1mm, -1.44mm), radius=0.15mm, height=1.68mm)
  V75_DCN = cylinder(axis=Z, base_centre=(-31.15mm, 14.8mm, -1.44mm), radius=0.15mm, height=1.68mm)
  V76_DCN = cylinder(axis=Z, base_centre=(-13.35mm, 14.1mm, -1.44mm), radius=0.15mm, height=1.68mm)
  V77_DCN = cylinder(axis=Z, base_centre=(-32.15mm, 15.5mm, -1.44mm), radius=0.15mm, height=1.68mm)
  V78_DCN = cylinder(axis=Z, base_centre=(-15.35mm, 14.1mm, -1.44mm), radius=0.15mm, height=1.68mm)
  V79_DCN = cylinder(axis=Z, base_centre=(-11.35mm, 14.1mm, -1.44mm), radius=0.15mm, height=1.68mm)
  V80_DCN = cylinder(axis=Z, base_centre=(-34.15mm, 13.4mm, -1.44mm), radius=0.15mm, height=1.68mm)
  V81_DCN = cylinder(axis=Z, base_centre=(-35.15mm, 13.4mm, -1.44mm), radius=0.15mm, height=1.68mm)
  V82_DCN = cylinder(axis=Z, base_centre=(-33.2269mm, -0.5mm, -1.44mm), radius=0.15mm, height=1.68mm)
  V83_DCN = cylinder(axis=Z, base_centre=(-34.15mm, 15.5mm, -1.44mm), radius=0.15mm, height=1.68mm)
  V84_DCN = cylinder(axis=Z, base_centre=(-34.15mm, 14.1mm, -1.44mm), radius=0.15mm, height=1.68mm)
  V85_DCN = cylinder(axis=Z, base_centre=(-29.15mm, 15.5mm, -1.44mm), radius=0.15mm, height=1.68mm)
  V86_DCN = cylinder(axis=Z, base_centre=(-14.35mm, 14.8mm, -1.44mm), radius=0.15mm, height=1.68mm)
  V87_DCN = cylinder(axis=Z, base_centre=(-40.15mm, 13.4mm, -1.44mm), radius=0.15mm, height=1.68mm)
  V88_DCN = cylinder(axis=Z, base_centre=(-7.15mm, -0.5mm, -1.44mm), radius=0.15mm, height=1.68mm)
  V89_DCN = cylinder(axis=Z, base_centre=(-14.2731mm, -0.5mm, -1.44mm), radius=0.15mm, height=1.68mm)
  V90_DCN = cylinder(axis=Z, base_centre=(-31.15mm, 15.5mm, -1.44mm), radius=0.15mm, height=1.68mm)
  V91_DCN = cylinder(axis=Z, base_centre=(-23.75mm, -0.5mm, -1.44mm), radius=0.15mm, height=1.68mm)
  V92_DCN = cylinder(axis=Z, base_centre=(-13.0885mm, -0.5mm, -1.44mm), radius=0.15mm, height=1.68mm)
  V93_DCN = cylinder(axis=Z, base_centre=(-35.15mm, 19mm, -1.44mm), radius=0.15mm, height=1.68mm)
  V94_DCN = cylinder(axis=Z, base_centre=(-13.35mm, 13.4mm, -1.44mm), radius=0.15mm, height=1.68mm)
  V95_DCN = cylinder(axis=Z, base_centre=(-14.35mm, 13.4mm, -1.44mm), radius=0.15mm, height=1.68mm)
  V96_DCN = cylinder(axis=Z, base_centre=(-4.75mm, -0.5mm, -1.44mm), radius=0.15mm, height=1.68mm)
  V97_DCN = cylinder(axis=Z, base_centre=(-18.35mm, 14.1mm, -1.44mm), radius=0.15mm, height=1.68mm)
  V98_DCN = cylinder(axis=Z, base_centre=(-17.35mm, 14.1mm, -1.44mm), radius=0.15mm, height=1.68mm)
  V99_DCN = cylinder(axis=Z, base_centre=(-2.35mm, -0.5mm, -1.44mm), radius=0.15mm, height=1.68mm)
  V100_DCN = cylinder(axis=Z, base_centre=(-9.35mm, 13.4mm, -1.44mm), radius=0.15mm, height=1.68mm)
  V101_DCN = cylinder(axis=Z, base_centre=(-18.35mm, 13.4mm, -1.44mm), radius=0.15mm, height=1.68mm)
  V102_DCN = cylinder(axis=Z, base_centre=(-6.35mm, 13.4mm, -1.44mm), radius=0.15mm, height=1.68mm)
  V103_DCN = cylinder(axis=Z, base_centre=(-17.35mm, 13.4mm, -1.44mm), radius=0.15mm, height=1.68mm)
  V104_DCN = cylinder(axis=Z, base_centre=(-17.35mm, 14.8mm, -1.44mm), radius=0.15mm, height=1.68mm)
  V105_DCN = cylinder(axis=Z, base_centre=(-12.35mm, 14.1mm, -1.44mm), radius=0.15mm, height=1.68mm)
  V106_DCN = cylinder(axis=Z, base_centre=(-32.15mm, 14.1mm, -1.44mm), radius=0.15mm, height=1.68mm)
  V107_DCN = cylinder(axis=Z, base_centre=(-37.9654mm, -0.5mm, -1.44mm), radius=0.15mm, height=1.68mm)
  V108_DCN = cylinder(axis=Z, base_centre=(-16.35mm, 13.4mm, -1.44mm), radius=0.15mm, height=1.68mm)
  V109_DCN = cylinder(axis=Z, base_centre=(-31.15mm, 14.1mm, -1.44mm), radius=0.15mm, height=1.68mm)
  V110_DCN = cylinder(axis=Z, base_centre=(-22.5654mm, -0.5mm, -1.44mm), radius=0.15mm, height=1.68mm)
  V111_DCN = cylinder(axis=Z, base_centre=(-5.35mm, 13.4mm, -1.44mm), radius=0.15mm, height=1.68mm)
  V112_DCN = cylinder(axis=Z, base_centre=(-34.15mm, 14.8mm, -1.44mm), radius=0.15mm, height=1.68mm)
  V113_DCN = cylinder(axis=Z, base_centre=(-12.35mm, 14.8mm, -1.44mm), radius=0.15mm, height=1.68mm)
  V114_DCN = cylinder(axis=Z, base_centre=(-5.95mm, -0.5mm, -1.44mm), radius=0.15mm, height=1.68mm)
  V115_DCN = cylinder(axis=Z, base_centre=(-39.15mm, 13.4mm, -1.44mm), radius=0.15mm, height=1.68mm)
  V116_DCN = cylinder(axis=Z, base_centre=(-36.15mm, 14.1mm, -1.44mm), radius=0.15mm, height=1.68mm)
  V117_DCN = cylinder(axis=Z, base_centre=(-16.35mm, 14.8mm, -1.44mm), radius=0.15mm, height=1.68mm)
  V118_DCN = cylinder(axis=Z, base_centre=(-29.15mm, 13.4mm, -1.44mm), radius=0.15mm, height=1.68mm)
  V119_DCN = cylinder(axis=Z, base_centre=(-30.15mm, 14.8mm, -1.44mm), radius=0.15mm, height=1.68mm)
  V120_DCN = cylinder(axis=Z, base_centre=(-33.15mm, 13.4mm, -1.44mm), radius=0.15mm, height=1.68mm)
  V121_DCN = cylinder(axis=Z, base_centre=(-38.15mm, 13.4mm, -1.44mm), radius=0.15mm, height=1.68mm)
  V122_DCN = cylinder(axis=Z, base_centre=(-18.35mm, 14.8mm, -1.44mm), radius=0.15mm, height=1.68mm)
  V123_DCN = cylinder(axis=Z, base_centre=(-30.15mm, 14.1mm, -1.44mm), radius=0.15mm, height=1.68mm)
  V124_DCN = cylinder(axis=Z, base_centre=(-12.35mm, 19.75mm, -1.44mm), radius=0.15mm, height=1.68mm)
  V125_DCN = cylinder(axis=Z, base_centre=(-15.35mm, 13.4mm, -1.44mm), radius=0.15mm, height=1.68mm)
  V126_AC1 = cylinder(axis=Z, base_centre=(-43.05mm, 21.6mm, -1.44mm), radius=0.15mm, height=1.68mm)
  V127_AC2 = cylinder(axis=Z, base_centre=(-18.3mm, 7.05mm, -1.44mm), radius=0.15mm, height=1.68mm)
  V128_AC2 = cylinder(axis=Z, base_centre=(-5.35mm, 21.6mm, -1.44mm), radius=0.15mm, height=1.68mm)
  V129_AC2 = cylinder(axis=Z, base_centre=(-6.55mm, 21.6mm, -1.44mm), radius=0.15mm, height=1.68mm)
  V130_AC1 = cylinder(axis=Z, base_centre=(-29.2mm, 7.05mm, -1.44mm), radius=0.15mm, height=1.68mm)
  V131_AC1 = cylinder(axis=Z, base_centre=(-41.85mm, 21.6mm, -1.44mm), radius=0.15mm, height=1.68mm)
  V132_LSRC1 = cylinder(axis=Z, base_centre=(-37.225mm, 11.8mm, -1.44mm), radius=0.15mm, height=1.68mm)
  V133_LSRC2 = cylinder(axis=Z, base_centre=(-10.275mm, 11.8mm, -1.44mm), radius=0.15mm, height=1.68mm)
  V134_GH_L1 = cylinder(axis=Z, base_centre=(-30.08mm, 6.13mm, -1.44mm), radius=0.15mm, height=1.68mm)
  V135_KH1 = cylinder(axis=Z, base_centre=(-25.8mm, 14.2mm, -1.44mm), radius=0.15mm, height=1.68mm)
  V136_KH1 = cylinder(axis=Z, base_centre=(-27.65mm, 11mm, -1.44mm), radius=0.15mm, height=1.68mm)
  V137_KH1 = cylinder(axis=Z, base_centre=(-25.55mm, 3.6mm, -1.44mm), radius=0.15mm, height=1.68mm)
  V138_KH1 = cylinder(axis=Z, base_centre=(-30.08mm, 3.405mm, -1.44mm), radius=0.15mm, height=1.68mm)
  V139_KH1 = cylinder(axis=Z, base_centre=(-21.95mm, 6.2mm, -1.44mm), radius=0.15mm, height=1.68mm)
  V140_KH1 = cylinder(axis=Z, base_centre=(-24.35mm, 10mm, -1.44mm), radius=0.15mm, height=1.68mm)
  V141_KH1 = cylinder(axis=Z, base_centre=(-23mm, 7mm, -1.44mm), radius=0.15mm, height=1.68mm)
  V142_KH1 = cylinder(axis=Z, base_centre=(-17.42mm, 6.395mm, -1.44mm), radius=0.15mm, height=1.68mm)
  V143_GL_L1 = cylinder(axis=Z, base_centre=(-30.08mm, 10.43mm, -1.44mm), radius=0.15mm, height=1.68mm)
  V144_KL1 = cylinder(axis=Z, base_centre=(-30.08mm, 7.705mm, -1.44mm), radius=0.15mm, height=1.68mm)
  V145_KL1 = cylinder(axis=Z, base_centre=(-17.42mm, 10.695mm, -1.44mm), radius=0.15mm, height=1.68mm)
  V146_KL1 = cylinder(axis=Z, base_centre=(-21.7mm, 14.2mm, -1.44mm), radius=0.15mm, height=1.68mm)
  V147_KL1 = cylinder(axis=Z, base_centre=(-27.75mm, 7.9mm, -1.44mm), radius=0.15mm, height=1.68mm)
  V148_KL1 = cylinder(axis=Z, base_centre=(-19.85mm, 11mm, -1.44mm), radius=0.15mm, height=1.68mm)
  V149_KL1 = cylinder(axis=Z, base_centre=(-19.75mm, 10.5mm, -1.44mm), radius=0.15mm, height=1.68mm)
  V150_GH_R1 = cylinder(axis=Z, base_centre=(-17.42mm, 3.67mm, -1.44mm), radius=0.15mm, height=1.68mm)
  V151_GL_R1 = cylinder(axis=Z, base_centre=(-17.42mm, 7.97mm, -1.44mm), radius=0.15mm, height=1.68mm)
  V152_GH_STAR1 = cylinder(axis=Z, base_centre=(-23.75mm, 6.6mm, -1.44mm), radius=0.15mm, height=1.68mm)
  V153_GH_STAR1 = cylinder(axis=Z, base_centre=(-25.25mm, 10mm, -1.44mm), radius=0.15mm, height=1.68mm)
  V154_VEEB1 = cylinder(axis=Z, base_centre=(-21.7mm, 16.15mm, -1.44mm), radius=0.15mm, height=1.68mm)
  V155_VDDB1 = cylinder(axis=Z, base_centre=(-23.25mm, 16.15mm, -1.44mm), radius=0.15mm, height=1.68mm)
  V156_VEEA1 = cylinder(axis=Z, base_centre=(-24.25mm, 16.15mm, -1.44mm), radius=0.15mm, height=1.68mm)
  V157_VDDA1 = cylinder(axis=Z, base_centre=(-25.8mm, 16.15mm, -1.44mm), radius=0.15mm, height=1.68mm)
  Q2_1 = box(corner=(-17.153mm, 3.1mm, 0.17mm), size=(1.102mm, 1.14mm, 0.105mm))
  Q2_2 = box(corner=(-17.153mm, 4.44mm, 0.17mm), size=(1.102mm, 2.26mm, 0.105mm))
  Q2_3 = box(corner=(-15.85mm, 3.1mm, 0.17mm), size=(0.65mm, 3.6mm, 0.105mm))
  Q2_4 = box(corner=(-15mm, 3.1mm, 0.17mm), size=(0.65mm, 3.6mm, 0.105mm))
  Q2_5 = box(corner=(-14.15mm, 3.1mm, 0.17mm), size=(0.65mm, 3.6mm, 0.105mm))
  Q2_6 = box(corner=(-13.3mm, 3.1mm, 0.17mm), size=(0.65mm, 3.6mm, 0.105mm))
  Q2_7 = box(corner=(-12.449mm, 3.1mm, 0.17mm), size=(1.102mm, 3.6mm, 0.105mm))
  Q1_1 = box(corner=(-31.449mm, 5.56mm, 0.17mm), size=(1.102mm, 1.14mm, 0.105mm))
  Q1_2 = box(corner=(-31.449mm, 3.1mm, 0.17mm), size=(1.102mm, 2.26mm, 0.105mm))
  Q1_3 = box(corner=(-32.3mm, 3.1mm, 0.17mm), size=(0.65mm, 3.6mm, 0.105mm))
  Q1_4 = box(corner=(-33.15mm, 3.1mm, 0.17mm), size=(0.65mm, 3.6mm, 0.105mm))
  Q1_5 = box(corner=(-34mm, 3.1mm, 0.17mm), size=(0.65mm, 3.6mm, 0.105mm))
  Q1_6 = box(corner=(-34.85mm, 3.1mm, 0.17mm), size=(0.65mm, 3.6mm, 0.105mm))
  Q1_7 = box(corner=(-36.153mm, 3.1mm, 0.17mm), size=(1.102mm, 3.6mm, 0.105mm))
  Q3_1 = box(corner=(-31.449mm, 9.86mm, 0.17mm), size=(1.102mm, 1.14mm, 0.105mm))
  Q3_2 = box(corner=(-31.449mm, 7.4mm, 0.17mm), size=(1.102mm, 2.26mm, 0.105mm))
  Q3_3 = box(corner=(-32.3mm, 7.4mm, 0.17mm), size=(0.65mm, 3.6mm, 0.105mm))
  Q3_4 = box(corner=(-33.15mm, 7.4mm, 0.17mm), size=(0.65mm, 3.6mm, 0.105mm))
  Q3_5 = box(corner=(-34mm, 7.4mm, 0.17mm), size=(0.65mm, 3.6mm, 0.105mm))
  Q3_6 = box(corner=(-34.85mm, 7.4mm, 0.17mm), size=(0.65mm, 3.6mm, 0.105mm))
  Q3_7 = box(corner=(-36.153mm, 7.4mm, 0.17mm), size=(1.102mm, 3.6mm, 0.105mm))
  Q4_1 = box(corner=(-17.153mm, 7.4mm, 0.17mm), size=(1.102mm, 1.14mm, 0.105mm))
  Q4_2 = box(corner=(-17.153mm, 8.74mm, 0.17mm), size=(1.102mm, 2.26mm, 0.105mm))
  Q4_3 = box(corner=(-15.85mm, 7.4mm, 0.17mm), size=(0.65mm, 3.6mm, 0.105mm))
  Q4_4 = box(corner=(-15mm, 7.4mm, 0.17mm), size=(0.65mm, 3.6mm, 0.105mm))
  Q4_5 = box(corner=(-14.15mm, 7.4mm, 0.17mm), size=(0.65mm, 3.6mm, 0.105mm))
  Q4_6 = box(corner=(-13.3mm, 7.4mm, 0.17mm), size=(0.65mm, 3.6mm, 0.105mm))
  Q4_7 = box(corner=(-12.449mm, 7.4mm, 0.17mm), size=(1.102mm, 3.6mm, 0.105mm))
  C6_1 = box(corner=(-29.975mm, 1.55mm, 0.17mm), size=(1.45mm, 1mm, 0.105mm))
  C6_2 = box(corner=(-29.975mm, -0.35mm, 0.17mm), size=(1.45mm, 1mm, 0.105mm))
  C5_1 = box(corner=(-31.575mm, 1.55mm, 0.17mm), size=(1.45mm, 1mm, 0.105mm))
  C5_2 = box(corner=(-31.575mm, -0.35mm, 0.17mm), size=(1.45mm, 1mm, 0.105mm))
  C3_1 = box(corner=(-34.775mm, 1.55mm, 0.17mm), size=(1.45mm, 1mm, 0.105mm))
  C3_2 = box(corner=(-34.775mm, -0.35mm, 0.17mm), size=(1.45mm, 1mm, 0.105mm))
  C4_1 = box(corner=(-33.175mm, 1.55mm, 0.17mm), size=(1.45mm, 1mm, 0.105mm))
  C4_2 = box(corner=(-33.175mm, -0.35mm, 0.17mm), size=(1.45mm, 1mm, 0.105mm))
  R2_1 = box(corner=(-18.625mm, 5.01mm, 0.17mm), size=(0.95mm, 0.8mm, 0.105mm))
  R2_2 = box(corner=(-18.625mm, 3.36mm, 0.17mm), size=(0.95mm, 0.8mm, 0.105mm))
  R8_1 = box(corner=(-27.225mm, 11.925mm, 0.17mm), size=(0.95mm, 0.8mm, 0.105mm))
  R8_2 = box(corner=(-27.225mm, 10.275mm, 0.17mm), size=(0.95mm, 0.8mm, 0.105mm))
  R10_1 = box(corner=(-21.225mm, 11.925mm, 0.17mm), size=(0.95mm, 0.8mm, 0.105mm))
  R10_2 = box(corner=(-21.225mm, 10.275mm, 0.17mm), size=(0.95mm, 0.8mm, 0.105mm))
  R4_1 = box(corner=(-29.825mm, 9.94mm, 0.17mm), size=(0.95mm, 0.8mm, 0.105mm))
  R4_2 = box(corner=(-29.825mm, 8.29mm, 0.17mm), size=(0.95mm, 0.8mm, 0.105mm))
  C9_1 = box(corner=(-15.775mm, 1.55mm, 0.17mm), size=(1.45mm, 1mm, 0.105mm))
  C9_2 = box(corner=(-15.775mm, -0.35mm, 0.17mm), size=(1.45mm, 1mm, 0.105mm))
  R9_1 = box(corner=(-23.025mm, 12.625mm, 0.17mm), size=(0.95mm, 0.8mm, 0.105mm))
  R9_2 = box(corner=(-23.025mm, 10.975mm, 0.17mm), size=(0.95mm, 0.8mm, 0.105mm))
  C12_1 = box(corner=(-10.975mm, 1.55mm, 0.17mm), size=(1.45mm, 1mm, 0.105mm))
  C12_2 = box(corner=(-10.975mm, -0.35mm, 0.17mm), size=(1.45mm, 1mm, 0.105mm))
  R7_1 = box(corner=(-25.425mm, 12.625mm, 0.17mm), size=(0.95mm, 0.8mm, 0.105mm))
  R7_2 = box(corner=(-25.425mm, 10.975mm, 0.17mm), size=(0.95mm, 0.8mm, 0.105mm))
  RS2_1 = box(corner=(-18.85mm, 11.2mm, 0.17mm), size=(15mm, 1.2mm, 0.105mm))
  RS2_2 = box(corner=(-18.85mm, 12.9mm, 0.17mm), size=(15mm, 3mm, 0.105mm))
  C2_1 = box(corner=(-36.375mm, 1.55mm, 0.17mm), size=(1.45mm, 1mm, 0.105mm))
  C2_2 = box(corner=(-36.375mm, -0.35mm, 0.17mm), size=(1.45mm, 1mm, 0.105mm))
  C7_1 = box(corner=(-18.975mm, 1.55mm, 0.17mm), size=(1.45mm, 1mm, 0.105mm))
  C7_2 = box(corner=(-18.975mm, -0.35mm, 0.17mm), size=(1.45mm, 1mm, 0.105mm))
  RS1_1 = box(corner=(-43.65mm, 11.2mm, 0.17mm), size=(15mm, 1.2mm, 0.105mm))
  RS1_2 = box(corner=(-43.65mm, 12.9mm, 0.17mm), size=(15mm, 3mm, 0.105mm))
  C10_1 = box(corner=(-14.175mm, 1.55mm, 0.17mm), size=(1.45mm, 1mm, 0.105mm))
  C10_2 = box(corner=(-14.175mm, -0.35mm, 0.17mm), size=(1.45mm, 1mm, 0.105mm))
  D2_1 = box(corner=(-21mm, 15.45mm, 0.17mm), size=(0.5mm, 0.5mm, 0.105mm))
  D2_2 = box(corner=(-21mm, 13.25mm, 0.17mm), size=(0.5mm, 0.5mm, 0.105mm))
  C1_1 = box(corner=(-37.975mm, 1.55mm, 0.17mm), size=(1.45mm, 1mm, 0.105mm))
  C1_2 = box(corner=(-37.975mm, -0.35mm, 0.17mm), size=(1.45mm, 1mm, 0.105mm))
  C11_1 = box(corner=(-12.575mm, 1.55mm, 0.17mm), size=(1.45mm, 1mm, 0.105mm))
  C11_2 = box(corner=(-12.575mm, -0.35mm, 0.17mm), size=(1.45mm, 1mm, 0.105mm))
  R5_1 = box(corner=(-18.625mm, 9.31mm, 0.17mm), size=(0.95mm, 0.8mm, 0.105mm))
  R5_2 = box(corner=(-18.625mm, 7.66mm, 0.17mm), size=(0.95mm, 0.8mm, 0.105mm))
  U1_8 = box(corner=(-21.975mm, 16.675mm, 0.17mm), size=(0.35mm, 0.75mm, 0.105mm))
  U1_9 = box(corner=(-22.625mm, 16.675mm, 0.17mm), size=(0.35mm, 0.75mm, 0.105mm))
  U1_10 = box(corner=(-23.275mm, 16.675mm, 0.17mm), size=(0.35mm, 0.75mm, 0.105mm))
  U1_11 = box(corner=(-24.575mm, 16.675mm, 0.17mm), size=(0.35mm, 0.75mm, 0.105mm))
  U1_12 = box(corner=(-25.225mm, 16.675mm, 0.17mm), size=(0.35mm, 0.75mm, 0.105mm))
  U1_13 = box(corner=(-25.875mm, 16.675mm, 0.17mm), size=(0.35mm, 0.75mm, 0.105mm))
  R1_1 = box(corner=(-29.825mm, 5.64mm, 0.17mm), size=(0.95mm, 0.8mm, 0.105mm))
  R1_2 = box(corner=(-29.825mm, 3.99mm, 0.17mm), size=(0.95mm, 0.8mm, 0.105mm))
  C8_1 = box(corner=(-17.375mm, 1.55mm, 0.17mm), size=(1.45mm, 1mm, 0.105mm))
  C8_2 = box(corner=(-17.375mm, -0.35mm, 0.17mm), size=(1.45mm, 1mm, 0.105mm))
  D1_1 = box(corner=(-27mm, 15.45mm, 0.17mm), size=(0.5mm, 0.5mm, 0.105mm))
  D1_2 = box(corner=(-27mm, 13.25mm, 0.17mm), size=(0.5mm, 0.5mm, 0.105mm))
  C28_1 = box(corner=(-31.575mm, -0.25mm, -1.475mm), size=(1.45mm, 1mm, 0.105mm))
  C28_2 = box(corner=(-31.575mm, 1.65mm, -1.475mm), size=(1.45mm, 1mm, 0.105mm))
  C16_1 = box(corner=(-23.125mm, 14.175mm, -1.475mm), size=(0.95mm, 0.9mm, 0.105mm))
  C16_2 = box(corner=(-23.125mm, 15.725mm, -1.475mm), size=(0.95mm, 0.9mm, 0.105mm))
  C27_1 = box(corner=(-33.175mm, -0.25mm, -1.475mm), size=(1.45mm, 1mm, 0.105mm))
  C27_2 = box(corner=(-33.175mm, 1.65mm, -1.475mm), size=(1.45mm, 1mm, 0.105mm))
  C33_1 = box(corner=(-18.975mm, -0.25mm, -1.475mm), size=(1.45mm, 1mm, 0.105mm))
  C33_2 = box(corner=(-18.975mm, 1.65mm, -1.475mm), size=(1.45mm, 1mm, 0.105mm))
  C30_1 = box(corner=(-14.175mm, -0.25mm, -1.475mm), size=(1.45mm, 1mm, 0.105mm))
  C30_2 = box(corner=(-14.175mm, 1.65mm, -1.475mm), size=(1.45mm, 1mm, 0.105mm))
  C15_1 = box(corner=(-21.225mm, 14.175mm, -1.475mm), size=(0.95mm, 0.9mm, 0.105mm))
  C15_2 = box(corner=(-21.225mm, 15.725mm, -1.475mm), size=(0.95mm, 0.9mm, 0.105mm))
  C26_1 = box(corner=(-34.775mm, -0.25mm, -1.475mm), size=(1.45mm, 1mm, 0.105mm))
  C26_2 = box(corner=(-34.775mm, 1.65mm, -1.475mm), size=(1.45mm, 1mm, 0.105mm))
  C29_1 = box(corner=(-29.975mm, -0.25mm, -1.475mm), size=(1.45mm, 1mm, 0.105mm))
  C29_2 = box(corner=(-29.975mm, 1.65mm, -1.475mm), size=(1.45mm, 1mm, 0.105mm))
  C31_1 = box(corner=(-15.775mm, -0.25mm, -1.475mm), size=(1.45mm, 1mm, 0.105mm))
  C31_2 = box(corner=(-15.775mm, 1.65mm, -1.475mm), size=(1.45mm, 1mm, 0.105mm))
  C14_1 = box(corner=(-25.325mm, 14.175mm, -1.475mm), size=(0.95mm, 0.9mm, 0.105mm))
  C14_2 = box(corner=(-25.325mm, 15.725mm, -1.475mm), size=(0.95mm, 0.9mm, 0.105mm))
  C13_1 = box(corner=(-27.225mm, 14.175mm, -1.475mm), size=(0.95mm, 0.9mm, 0.105mm))
  C13_2 = box(corner=(-27.225mm, 15.725mm, -1.475mm), size=(0.95mm, 0.9mm, 0.105mm))
  C32_1 = box(corner=(-17.375mm, -0.25mm, -1.475mm), size=(1.45mm, 1mm, 0.105mm))
  C32_2 = box(corner=(-17.375mm, 1.65mm, -1.475mm), size=(1.45mm, 1mm, 0.105mm))
  P35_KL1_L1.unite(P36_KL1_L1, P37_KL1_L2, P38_KL1_L2, P39_KL1_L2, P40_KL1_L2, P41_KL1_L3, P42_KL1_L4, P43_KL1_L4, P44_KL1_L4, V144_KL1, V145_KL1, V146_KL1, V147_KL1, V148_KL1, V149_KL1, Q3_2, Q4_2, C16_1, C15_1)
  P35_KL1_L1_Separate3 [copper] = P35_KL1_L1.separate_bodies()
  P35_KL1_L1.delete()
  P66_VDDB1_L1.unite(P67_VDDB1_L3, P68_VDDB1_L4, V155_VDDB1, U1_10, C16_2)
  P66_VDDB1_L1.separate_bodies()
  P63_VDDA1_L1.unite(P64_VDDA1_L3, P65_VDDA1_L4, V157_VDDA1, U1_13, C13_2)
  P63_VDDA1_L1.separate_bodies()
  P22_GL_STAR1_L1.unite(R10_2, R4_2, R9_2, R5_1)
  P22_GL_STAR1_L1.separate_bodies()
  P51_OUTA1_L1.unite(R7_1, U1_12, D1_1)
  P51_OUTA1_L1.separate_bodies()
  P72_VEEB1_L1.unite(P73_VEEB1_L3, P74_VEEB1_L4, V154_VEEB1, U1_8, C15_2)
  P72_VEEB1_L1.separate_bodies()
  P11_GH_L1_L1.unite(P12_GH_L1_L4, V134_GH_L1, Q1_1, R1_1)
  P11_GH_L1_L1.separate_bodies()
  P47_LSRC2_L1.unite(P48_LSRC2_L4, V133_LSRC2, Q4_4, Q4_6, RS2_1)
  P47_LSRC2_L1.separate_bodies()
  P45_LSRC1_L1.unite(P46_LSRC1_L4, V132_LSRC1, Q3_4, Q3_6, RS1_1)
  P45_LSRC1_L1.separate_bodies()
  P23_KH1_L1.unite(P24_KH1_L1, P25_KH1_L2, P26_KH1_L2, P27_KH1_L2, P28_KH1_L2, P29_KH1_L2, P30_KH1_L3, P31_KH1_L4, P32_KH1_L4, P33_KH1_L4, P34_KH1_L4, V135_KH1, V136_KH1, V137_KH1, V138_KH1, V139_KH1, V140_KH1, V141_KH1, V142_KH1, Q2_2, Q1_2, C14_1, C13_1)
  P23_KH1_L1_Separate3 [copper] = P23_KH1_L1.separate_bodies()
  P23_KH1_L1.delete()
  P20_GL_R1_L1.unite(P21_GL_R1_L4, V151_GL_R1, Q4_1, R5_2)
  P20_GL_R1_L1.separate_bodies()
  P0_DCN_L1.unite(P1_DCN_L1, P2_DCN_L1, P3_DCN_L2, P4_DCN_L4, P5_DCN_L4, V16_DCN, V17_DCN, V18_DCN, V19_DCN, V20_DCN, V21_DCN, V22_DCN, V23_DCN, V24_DCN, V25_DCN, V26_DCN, V27_DCN, V28_DCN, V29_DCN, V30_DCN, V31_DCN, V32_DCN, V33_DCN, V34_DCN, V35_DCN, V36_DCN, V37_DCN, V38_DCN, V39_DCN, V40_DCN, V41_DCN, V42_DCN, V43_DCN, V44_DCN, V45_DCN, V46_DCN, V47_DCN, V48_DCN, V49_DCN, V50_DCN, V51_DCN, V52_DCN, V53_DCN, V54_DCN, V55_DCN, V56_DCN, V57_DCN, V58_DCN, V59_DCN, V60_DCN, V61_DCN, V62_DCN, V63_DCN, V64_DCN, V65_DCN, V66_DCN, V67_DCN, V68_DCN, V69_DCN, V70_DCN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)
  P0_DCN_L1.separate_bodies()
  P6_DCP_L1.unite(P7_DCP_L1, P8_DCP_L3, P9_DCP_L4, P10_DCP_L4, V0_DCP, V1_DCP, V2_DCP, V3_DCP, V4_DCP, V5_DCP, V6_DCP, V7_DCP, V8_DCP, V9_DCP, V10_DCP, V11_DCP, V12_DCP, V13_DCP, V14_DCP, V15_DCP, Q2_3, Q2_5, Q2_7, Q1_3, Q1_5, Q1_7, C6_1, C5_1, C3_1, C4_1, C9_1, C12_1, C2_1, C7_1, C10_1, C1_1, C11_1, C8_1, C28_2, C27_2, C33_2, C30_2, C26_2, C29_2, C31_2, C32_2)
  P6_DCP_L1.separate_bodies()
  P49_OFFA1_L1.unite(R8_1, D1_2)
  P49_OFFA1_L1.separate_bodies()
  P53_AC1_L1.unite(P55_AC1_L1, P57_AC1_L2, P59_AC1_L3, P61_AC1_L4, V126_AC1, V130_AC1, V131_AC1, Q1_4, Q1_6, Q3_3, Q3_5, Q3_7)
  P53_AC1_L1.separate_bodies()
  P54_AC2_L1.unite(P56_AC2_L1, P58_AC2_L2, P60_AC2_L3, P62_AC2_L4, V127_AC2, V128_AC2, V129_AC2, Q2_4, Q2_6, Q4_3, Q4_5, Q4_7)
  P54_AC2_L1.separate_bodies()
  P69_VEEA1_L1.unite(P70_VEEA1_L3, P71_VEEA1_L4, V156_VEEA1, U1_11, C14_2)
  P69_VEEA1_L1.separate_bodies()
  P13_GH_R1_L1.unite(P14_GH_R1_L4, V150_GH_R1, Q2_1, R2_2)
  P13_GH_R1_L1.separate_bodies()
  P52_OUTB1_L1.unite(R9_1, D2_1, U1_9)
  P52_OUTB1_L1.separate_bodies()
  P50_OFFB1_L1.unite(R10_1, D2_2)
  P50_OFFB1_L1.separate_bodies()
  P18_GL_L1_L1.unite(P19_GL_L1_L4, V143_GL_L1, Q3_1, R4_1)
  P18_GL_L1_L1.separate_bodies()
  P15_GH_STAR1_L1.unite(P16_GH_STAR1_L1, P17_GH_STAR1_L3, V152_GH_STAR1, V153_GH_STAR1, R2_1, R8_2, R7_2, R1_2)
  P15_GH_STAR1_L1.separate_bodies()
boundaries and excitations:
  KL1: SignalNet Objects=P35_KL1_L1_Separate3
  VDDB1: SignalNet Objects=P66_VDDB1_L1
  VDDA1: SignalNet Objects=P63_VDDA1_L1
  GL_STAR1: SignalNet Objects=P22_GL_STAR1_L1
  OUTA1: SignalNet Objects=P51_OUTA1_L1
  VEEB1: SignalNet Objects=P72_VEEB1_L1
  GH_L1: SignalNet Objects=P11_GH_L1_L1
  LSRC2: SignalNet Objects=P47_LSRC2_L1
  LSRC1: SignalNet Objects=P45_LSRC1_L1
  KH1: SignalNet Objects=P23_KH1_L1_Separate3
  GL_R1: SignalNet Objects=P20_GL_R1_L1
  DCN: SignalNet Objects=P0_DCN_L1
  DCP: SignalNet Objects=P6_DCP_L1
  OFFA1: SignalNet Objects=P49_OFFA1_L1
  AC1: SignalNet Objects=P53_AC1_L1
  AC2: SignalNet Objects=P54_AC2_L1
  VEEA1: SignalNet Objects=P69_VEEA1_L1
  GH_R1: SignalNet Objects=P13_GH_R1_L1
  OUTB1: SignalNet Objects=P52_OUTB1_L1
  OFFB1: SignalNet Objects=P50_OFFB1_L1
  GL_L1: SignalNet Objects=P18_GL_L1_L1
  GH_STAR1: SignalNet Objects=P15_GH_STAR1_L1
  C13_2: Source Faces=P63_VDDA1_L1.face(at (-26.75, 16.175, -1.475)) TerminalType=ConstantVoltage Net=VDDA1
  C14_1: Source Faces=P23_KH1_L1_Separate3.face(at (-24.85, 14.625, -1.475)) TerminalType=ConstantVoltage Net=KH1
  C14_2: Source Faces=P69_VEEA1_L1.face(at (-24.85, 16.175, -1.475)) TerminalType=ConstantVoltage Net=VEEA1
  C15_1: Source Faces=P35_KL1_L1_Separate3.face(at (-20.75, 14.625, -1.475)) TerminalType=ConstantVoltage Net=KL1
  C15_2: Source Faces=P72_VEEB1_L1.face(at (-20.75, 16.175, -1.475)) TerminalType=ConstantVoltage Net=VEEB1
  C16_2: Source Faces=P66_VDDB1_L1.face(at (-22.65, 16.175, -1.475)) TerminalType=ConstantVoltage Net=VDDB1
  CapN_2: Source Faces=P0_DCN_L1.face(at (-15.05, 0.15, 0.275), at (-10.25, 0.15, 0.275), at (-18.25, 0.15, 0.275), at (-13.45, 0.15, 0.275), at (-11.85, 0.15, 0.275), at (-16.65, 0.15, 0.275)) TerminalType=ConstantVoltage Net=DCN
  CapNb_1: Source Faces=P0_DCN_L1.face(at (-30.85, 0.25, -1.475), at (-32.45, 0.25, -1.475), at (-34.05, 0.25, -1.475), at (-29.25, 0.25, -1.475)) TerminalType=ConstantVoltage Net=DCN
  CapNb_2: Source Faces=P0_DCN_L1.face(at (-18.25, 0.25, -1.475), at (-13.45, 0.25, -1.475), at (-15.05, 0.25, -1.475), at (-16.65, 0.25, -1.475)) TerminalType=ConstantVoltage Net=DCN
  CapP_2: Source Faces=P6_DCP_L1.face(at (-15.05, 2.05, 0.275), at (-10.25, 2.05, 0.275), at (-18.25, 2.05, 0.275), at (-13.45, 2.05, 0.275), at (-11.85, 2.05, 0.275), at (-16.65, 2.05, 0.275)) TerminalType=ConstantVoltage Net=DCP
  CapPb_1: Source Faces=P6_DCP_L1.face(at (-30.85, 2.15, -1.475), at (-32.45, 2.15, -1.475), at (-34.05, 2.15, -1.475), at (-29.25, 2.15, -1.475)) TerminalType=ConstantVoltage Net=DCP
  CapPb_2: Source Faces=P6_DCP_L1.face(at (-18.25, 2.15, -1.475), at (-13.45, 2.15, -1.475), at (-15.05, 2.15, -1.475), at (-16.65, 2.15, -1.475)) TerminalType=ConstantVoltage Net=DCP
  D1_1: Source Faces=P51_OUTA1_L1.face(at (-26.75, 15.7, 0.275)) TerminalType=ConstantVoltage Net=OUTA1
  D2_1: Source Faces=P52_OUTB1_L1.face(at (-20.75, 15.7, 0.275)) TerminalType=ConstantVoltage Net=OUTB1
  G_Q1: Source Faces=P11_GH_L1_L1.face(at (-30.898, 6.13, 0.275)) TerminalType=ConstantVoltage Net=GH_L1
  G_Q2: Source Faces=P13_GH_R1_L1.face(at (-16.602, 3.67, 0.275)) TerminalType=ConstantVoltage Net=GH_R1
  G_Q3: Source Faces=P18_GL_L1_L1.face(at (-30.898, 10.43, 0.275)) TerminalType=ConstantVoltage Net=GL_L1
  G_Q4: Source Faces=P20_GL_R1_L1.face(at (-16.602, 7.97, 0.275)) TerminalType=ConstantVoltage Net=GL_R1
  K_Q1: Source Faces=P23_KH1_L1_Separate3.face(at (-30.898, 4.23, 0.275)) TerminalType=ConstantVoltage Net=KH1
  K_Q2: Source Faces=P23_KH1_L1_Separate3.face(at (-16.602, 5.57, 0.275)) TerminalType=ConstantVoltage Net=KH1
  K_Q3: Source Faces=P35_KL1_L1_Separate3.face(at (-30.898, 8.53, 0.275)) TerminalType=ConstantVoltage Net=KL1
  K_Q4: Source Faces=P35_KL1_L1_Separate3.face(at (-16.602, 9.87, 0.275)) TerminalType=ConstantVoltage Net=KL1
  QH_D_1: Source Faces=P6_DCP_L1.face(at (-31.975, 4.9, 0.275), at (-33.675, 4.9, 0.275), at (-35.602, 4.9, 0.275)) TerminalType=ConstantVoltage Net=DCP
  QH_D_2: Source Faces=P6_DCP_L1.face(at (-15.525, 4.9, 0.275), at (-13.825, 4.9, 0.275), at (-11.898, 4.9, 0.275)) TerminalType=ConstantVoltage Net=DCP
  QL_D_1: Source Faces=P53_AC1_L1.face(at (-31.975, 9.2, 0.275), at (-33.675, 9.2, 0.275), at (-35.602, 9.2, 0.275)) TerminalType=ConstantVoltage Net=AC1
  QL_D_2: Source Faces=P54_AC2_L1.face(at (-15.525, 9.2, 0.275), at (-13.825, 9.2, 0.275), at (-11.898, 9.2, 0.275)) TerminalType=ConstantVoltage Net=AC2
  QL_S_1: Source Faces=P45_LSRC1_L1.face(at (-32.825, 9.2, 0.275), at (-34.525, 9.2, 0.275)) TerminalType=ConstantVoltage Net=LSRC1
  QL_S_2: Source Faces=P47_LSRC2_L1.face(at (-14.675, 9.2, 0.275), at (-12.975, 9.2, 0.275)) TerminalType=ConstantVoltage Net=LSRC2
  R10_1: Source Faces=P50_OFFB1_L1.face(at (-20.75, 12.325, 0.275)) TerminalType=ConstantVoltage Net=OFFB1
  R10_2: Source Faces=P22_GL_STAR1_L1.face(at (-20.75, 10.675, 0.275)) TerminalType=ConstantVoltage Net=GL_STAR1
  R1_2: Source Faces=P15_GH_STAR1_L1.face(at (-29.35, 4.39, 0.275)) TerminalType=ConstantVoltage Net=GH_STAR1
  R2_1: Source Faces=P15_GH_STAR1_L1.face(at (-18.15, 5.41, 0.275)) TerminalType=ConstantVoltage Net=GH_STAR1
  R4_2: Source Faces=P22_GL_STAR1_L1.face(at (-29.35, 8.69, 0.275)) TerminalType=ConstantVoltage Net=GL_STAR1
  R5_1: Source Faces=P22_GL_STAR1_L1.face(at (-18.15, 9.71, 0.275)) TerminalType=ConstantVoltage Net=GL_STAR1
  R7_1: Source Faces=P51_OUTA1_L1.face(at (-24.95, 13.025, 0.275)) TerminalType=ConstantVoltage Net=OUTA1
  R8_1: Source Faces=P49_OFFA1_L1.face(at (-26.75, 12.325, 0.275)) TerminalType=ConstantVoltage Net=OFFA1
  R8_2: Source Faces=P15_GH_STAR1_L1.face(at (-26.75, 10.675, 0.275)) TerminalType=ConstantVoltage Net=GH_STAR1
  R9_1: Source Faces=P52_OUTB1_L1.face(at (-22.55, 13.025, 0.275)) TerminalType=ConstantVoltage Net=OUTB1
  RSN_1: Source Faces=P0_DCN_L1.face(at (-36.15, 14.4, 0.275)) TerminalType=ConstantVoltage Net=DCN
  RSN_2: Source Faces=P0_DCN_L1.face(at (-11.35, 14.4, 0.275)) TerminalType=ConstantVoltage Net=DCN
  C13_1: Sink Faces=P23_KH1_L1_Separate3.face(at (-26.75, 14.625, -1.475)) TerminalType=ConstantVoltage Net=KH1
  C16_1: Sink Faces=P35_KL1_L1_Separate3.face(at (-22.65, 14.625, -1.475)) TerminalType=ConstantVoltage Net=KL1
  CapN_1: Sink Faces=P0_DCN_L1.face(at (-29.25, 0.15, 0.275), at (-30.85, 0.15, 0.275), at (-34.05, 0.15, 0.275), at (-32.45, 0.15, 0.275), at (-35.65, 0.15, 0.275), at (-37.25, 0.15, 0.275)) TerminalType=ConstantVoltage Net=DCN
  CapP_1: Sink Faces=P6_DCP_L1.face(at (-29.25, 2.05, 0.275), at (-30.85, 2.05, 0.275), at (-34.05, 2.05, 0.275), at (-32.45, 2.05, 0.275), at (-35.65, 2.05, 0.275), at (-37.25, 2.05, 0.275)) TerminalType=ConstantVoltage Net=DCP
  D1_2: Sink Faces=P49_OFFA1_L1.face(at (-26.75, 13.5, 0.275)) TerminalType=ConstantVoltage Net=OFFA1
  D2_2: Sink Faces=P50_OFFB1_L1.face(at (-20.75, 13.5, 0.275)) TerminalType=ConstantVoltage Net=OFFB1
  QH_S_1: Sink Faces=P53_AC1_L1.face(at (-32.825, 4.9, 0.275), at (-34.525, 4.9, 0.275)) TerminalType=ConstantVoltage Net=AC1
  QH_S_2: Sink Faces=P54_AC2_L1.face(at (-14.675, 4.9, 0.275), at (-12.975, 4.9, 0.275)) TerminalType=ConstantVoltage Net=AC2
  R1_1: Sink Faces=P11_GH_L1_L1.face(at (-29.35, 6.04, 0.275)) TerminalType=ConstantVoltage Net=GH_L1
  R2_2: Sink Faces=P13_GH_R1_L1.face(at (-18.15, 3.76, 0.275)) TerminalType=ConstantVoltage Net=GH_R1
  R4_1: Sink Faces=P18_GL_L1_L1.face(at (-29.35, 10.34, 0.275)) TerminalType=ConstantVoltage Net=GL_L1
  R5_2: Sink Faces=P20_GL_R1_L1.face(at (-18.15, 8.06, 0.275)) TerminalType=ConstantVoltage Net=GL_R1
  R7_2: Sink Faces=P15_GH_STAR1_L1.face(at (-24.95, 11.375, 0.275)) TerminalType=ConstantVoltage Net=GH_STAR1
  R9_2: Sink Faces=P22_GL_STAR1_L1.face(at (-22.55, 11.375, 0.275)) TerminalType=ConstantVoltage Net=GL_STAR1
  RSI_1: Sink Faces=P45_LSRC1_L1.face(at (-36.15, 11.8, 0.275)) TerminalType=ConstantVoltage Net=LSRC1
  RSI_2: Sink Faces=P47_LSRC2_L1.face(at (-11.35, 11.8, 0.275)) TerminalType=ConstantVoltage Net=LSRC2
  U1_10: Sink Faces=P66_VDDB1_L1.face(at (-23.1, 17.05, 0.275)) TerminalType=ConstantVoltage Net=VDDB1
  U1_11: Sink Faces=P69_VEEA1_L1.face(at (-24.4, 17.05, 0.275)) TerminalType=ConstantVoltage Net=VEEA1
  U1_12: Sink Faces=P51_OUTA1_L1.face(at (-25.05, 17.05, 0.275)) TerminalType=ConstantVoltage Net=OUTA1
  U1_13: Sink Faces=P63_VDDA1_L1.face(at (-25.7, 17.05, 0.275)) TerminalType=ConstantVoltage Net=VDDA1
  U1_8: Sink Faces=P72_VEEB1_L1.face(at (-21.8, 17.05, 0.275)) TerminalType=ConstantVoltage Net=VEEB1
  U1_9: Sink Faces=P52_OUTB1_L1.face(at (-22.45, 17.05, 0.275)) TerminalType=ConstantVoltage Net=OUTB1
setups:
  Setup1: Matrix AdaptiveFreq=100MHz Cap{MaxPass=1 MinPass=1 MinConvPass=1 PerError=30 PerRefine=30 AutoIncreaseAccuracy AccuracyLevel=High Solver_Type=Iterative} DC{SolveResOnly Cond{MaxPass=3 MinPass=1 MinConvPass=1 PerError=5 PerRefine=30} Mult{MaxPass=1 MinPass=1 MinConvPass=1 PerError=1 PerRefine=30} AccuracyLevel=Normal} AC{MaxPass=8 MinPass=2 MinConvPass=1 PerError=2 PerRefine=30 ACRLSolverType=ACA} ErrorValue=0.1
source amplitudes:
  AC1:QL_D_1, AC2:QL_D_2, DCN:CapN_2, DCN:CapNb_1, DCN:CapNb_2, DCN:RSN_1, DCN:RSN_2, DCP:CapP_2, DCP:CapPb_1, DCP:CapPb_2, DCP:QH_D_1, DCP:QH_D_2, GH_L1:G_Q1, GH_R1:G_Q2, GH_STAR1:R1_2, GH_STAR1:R2_1, GH_STAR1:R8_2, GL_L1:G_Q3, GL_R1:G_Q4, GL_STAR1:R4_2, GL_STAR1:R5_1, GL_STAR1:R10_2, KH1:C14_1, KH1:K_Q1, KH1:K_Q2, KL1:C15_1, KL1:K_Q3, KL1:K_Q4, LSRC1:QL_S_1, LSRC2:QL_S_2, OFFA1:R8_1, OFFB1:R10_1, OUTA1:D1_1, OUTA1:R7_1, OUTB1:D2_1, OUTB1:R9_1, VDDB1:C16_2, VEEA1:C14_2, VEEB1:C15_2: AC R/L Fields 0A
  VDDA1:C13_2: AC R/L Fields 1A
  AC1, AC2, DCN, DCP, GH_L1, GH_R1, GH_STAR1, GL_L1, GL_R1, GL_STAR1, KH1, LSRC1, LSRC2, OFFA1, OFFB1, OUTA1, OUTB1, VDDA1, VDDB1, VEEA1, VEEB1: CG Fields 0V 0deg
  KL1: CG Fields 1V 0deg
  AC1:QL_D_1, AC2:QL_D_2, DCN:CapN_2, DCN:CapNb_1, DCN:CapNb_2, DCN:RSN_1, DCN:RSN_2, DCP:CapP_2, DCP:CapPb_1, DCP:CapPb_2, DCP:QH_D_1, DCP:QH_D_2, GH_L1:G_Q1, GH_R1:G_Q2, GH_STAR1:R1_2, GH_STAR1:R2_1, GH_STAR1:R8_2, GL_L1:G_Q3, GL_R1:G_Q4, GL_STAR1:R4_2, GL_STAR1:R5_1, GL_STAR1:R10_2, KH1:C14_1, KH1:K_Q1, KH1:K_Q2, KL1:C15_1, KL1:K_Q3, KL1:K_Q4, LSRC1:QL_S_1, LSRC2:QL_S_2, OFFA1:R8_1, OFFB1:R10_1, OUTA1:D1_1, OUTA1:R7_1, OUTB1:D2_1, OUTB1:R9_1, VDDB1:C16_2, VEEA1:C14_2, VEEB1:C15_2: DC R/L Fields 0A
  VDDA1:C13_2: DC R/L Fields 1A
