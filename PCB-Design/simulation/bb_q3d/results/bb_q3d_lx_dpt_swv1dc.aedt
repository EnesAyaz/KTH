# Ansys Electronics Desktop project, version 2024.2
materials:
  vacuum: permittivity=1
  copper: permeability=0.999991 conductivity=58000000

design BB_PL_LX_dpt_swv1dc (Q3D Extractor, model units mm)
options: SParamCalcMethod=EqTransLine Calculate_Lossy_Dielectrics
geometry:
  P0_DCN_L1 [copper] = polyline(z=0.17mm, xy in mm: (-28.6908, 12.9189) (-28.6689, 16.7592) (-34.5, 16.8) (-34.5, 20.101) (-34.5684, 20.1952) (-43.551, 20.2) (-43.6452, 20.1316) (-43.65, 12.999) (-43.5816, 12.9048) (-28.749, 12.9) (-28.6908, 12.9189), closed, covered)
  P0_DCN_L1.sweep_along_vector((0mm, 0mm, 0.07mm))
  P1_DCN_L1 = polyline(z=0.17mm, xy in mm: (-3.8908, 12.9189) (-3.85, 20.101) (-3.9184, 20.1952) (-12.901, 20.2) (-13, 20.101) (-13, 16.8) (-18.751, 16.8) (-18.8452, 16.7316) (-18.85, 12.999) (-18.7816, 12.9048) (-3.949, 12.9) (-3.8908, 12.9189), closed, covered)
  P1_DCN_L1.sweep_along_vector((0mm, 0mm, 0.07mm))
  P2_DCN_L1 = polyline(z=0.17mm, xy in mm: (18.8092, 12.9189) (18.8311, 16.7592) (13, 16.8) (13, 20.101) (12.9316, 20.1952) (3.949, 20.2) (3.8548, 20.1316) (3.85, 12.999) (3.9184, 12.9048) (18.751, 12.9) (18.8092, 12.9189), closed, covered)
  P2_DCN_L1.sweep_along_vector((0mm, 0mm, 0.07mm))
  P3_DCN_L1 = polyline(z=0.17mm, xy in mm: (43.6092, 12.9189) (43.65, 20.101) (43.5816, 20.1952) (34.599, 20.2) (34.5, 20.101) (34.5, 16.8) (28.749, 16.8) (28.6548, 16.7316) (28.65, 12.999) (28.7184, 12.9048) (43.551, 12.9) (43.6092, 12.9189), closed, covered)
  P3_DCN_L1.sweep_along_vector((0mm, 0mm, 0.07mm))
  P4_DCN_L1 = polyline(z=0.17mm, xy in mm: (39.7092, -4.1811) (39.75, 0.801) (39.651, 0.9) (-39.651, 0.9) (-39.75, 0.801) (-39.75, -4.101) (-39.651, -4.2) (39.651, -4.2) (39.7092, -4.1811), closed, covered)
  P4_DCN_L1.sweep_along_vector((0mm, 0mm, 0.07mm))
  P5_DCN_L1 = polyline(z=0.17mm, xy in mm: (41.3621, -12.2) (41.0621, -11.9) (42.5621, -10.4) (42.35, -10.1879) (40.85, -11.6879) (40.3, -11.1379) (40.3, -11.05) (40.15, -10.9879) (40.0879, -11.05) (39.75, -11.05) (39.75, -8.299) (39.651, -8.2) (36.0524, -8.2) (35.7693, -8.3848) (35.5, -8.4505) (30.5, -8.4505) (30.0155, -8.2536) (29.5, -8.4505) (24.5, -8.4505) (24.0155, -8.2536) (23.5, -8.4505) (18.5, -8.4505) (18.0155, -8.2536) (17.5, -8.4505) (12.5, -8.4505) (12.0155, -8.2536) (11.5, -8.4505) (6.5, -8.4505) (6.0155, -8.2536) (5.5, -8.4505) (0.5, -8.4505) (0.0155, -8.2536) (-0.5, -8.4505) (-5.5, -8.4505) (-5.9845, -8.2536) (-6.5, -8.4505) (-11.5, -8.4505) (-11.9845, -8.2536) (-12.5, -8.4505) (-17.5, -8.4505) (-17.9845, -8.2536) (-18.5, -8.4505) (-23.5, -8.4505) (-23.9845, -8.2536) (-24.5, -8.4505) (-29.5, -8.4505) (-29.9845, -8.2536) (-30.5, -8.4505) (-35.5, -8.4505) (-35.7693, -8.3848) (-36.0524, -8.2) (-39.651, -8.2) (-39.75, -8.299) (-39.75, -11.301) (-39.651, -11.4) (40.0879, -11.35) (41.15, -12.4121) (41.3621, -12.2), closed, covered)
  P5_DCN_L1.sweep_along_vector((0mm, 0mm, 0.07mm))
  P6_DCN_L2 = polyline(z=0mm, xy in mm: (-10.0241, -23.3803) (-9.9974, -23.1948) (-10.4268, -22.7521) (-10.6603, -22.2672) (-10.7405, -21.735) (-10.6603, -21.2028) (-10.4268, -20.7179) (-10.0607, -20.3234) (-9.5946, -20.0543) (-9.0699, -19.9345) (-8.5332, -19.9747) (-8.0322, -20.1713) (-7.6114, -20.5069) (-7.2097, -21.2028) (-7.1295, -21.735) (-7.2097, -22.2672) (-7.4432, -22.7521) (-7.893, -23.2276) (-7.8704, -23.3597) (-7.7789, -23.4) (-4.1541, -23.3803) (-4.1274, -23.1948) (-4.5568, -22.7521) (-4.7903, -22.2672) (-4.8705, -21.735) (-4.7903, -21.2028) (-4.5568, -20.7179) (-4.1907, -20.3234) (-3.7246, -20.0543) (-3.1999, -19.9345) (-2.6632, -19.9747) (-2.1622, -20.1713) (-1.7414, -20.5069) (-1.3397, -21.2028) (-1.2595, -21.735) (-1.3397, -22.2672) (-1.5732, -22.7521) (-2.023, -23.2276) (-2.0004, -23.3597) (-1.9089, -23.4) (35.693, -23.3803) (35.75, -23.276) (35.75, -13.1763) (35.6775, -13.0635) (35.4709, -13.0356) (35.2681, -12.8883) (35.2105, -12.5247) (35.3578, -12.322) (35.7293, -12.1922) (35.75, -11.3) (39.626, -11.3) (39.75, -11.176) (39.75, -5.7211) (39.6084, -5.5984) (39.2753, -5.8856) (39.0247, -5.8856) (38.8219, -5.7383) (38.7445, -5.5) (38.8219, -5.2617) (39.0247, -5.1144) (39.2753, -5.1144) (39.6313, -5.4028) (39.75, -5.2789) (39.75, 11.9) (43.926, 11.9) (44.0388, 11.9725) (44.0303, 20.543) (43.926, 20.6) (39.0598, 20.5495) (35.9907, 20.6) (35.65, 20.5444) (33.624, 20.5945) (33.5, 20.4705) (33.5, 17.6) (28.707, 17.5803) (28.65, 17.476) (28.65, 11.9) (28.407, 11.8803) (28.35, 11.776) (28.35, 10) (27.3652, 10) (27.1357, 9.9318) (27.0508, 9.828) (27.05, 3.3) (22.3031, 3.3) (21.95, 3.1692) (21.5969, 3.3) (20.45, 3.3) (20.45, 7.5883) (20.3084, 7.711) (19.8831, 7.4903) (19.6169, 7.4903) (19.3403, 7.7669) (19.3403, 8.0331) (19.4968, 8.2485) (20.422, 8.5076) (20.45, 9.876) (20.326, 10) (19.15, 10) (19.15, 11.776) (19.0775, 11.8888) (18.85, 11.9) (18.8303, 17.543) (18.726, 17.6) (14, 17.6) (14, 20.4705) (13.9275, 20.5833) (-13.876, 20.5945) (-14, 20.4705) (-14, 17.6) (-18.726, 17.6) (-18.8388, 17.5275) (-18.85, 11.9) (-19.093, 11.8803) (-19.15, 11.776) (-19.15, 10) (-20.1348, 10) (-20.3643, 9.9318) (-20.4492, 9.828) (-20.45, 3.3) (-25.1969, 3.3) (-25.55, 3.1692) (-25.9031, 3.3) (-27.05, 3.3) (-27.05, 7.5883) (-27.1916, 7.711) (-27.6169, 7.4903) (-27.8831, 7.4903) (-28.1597, 7.7669) (-28.1597, 8.0331) (-28.0032, 8.2485) (-27.078, 8.5076) (-27.05, 9.876) (-27.174, 10) (-28.35, 10) (-28.35, 11.776) (-28.4225, 11.8888) (-28.65, 11.9) (-28.6697, 17.543) (-28.774, 17.6) (-33.5, 17.6) (-33.5, 20.4705) (-33.624, 20.5945) (-43.993, 20.5803) (-44.05, 20.476) (-44.0303, 11.957) (-43.926, 11.9) (-39.75, 11.9) (-39.75, -5.2789) (-39.6084, -5.4016) (-39.2753, -5.1144) (-39.0247, -5.1144) (-38.822, -5.2617) (-38.7445, -5.5) (-38.822, -5.7383) (-39.0247, -5.8856) (-39.2753, -5.8856) (-39.6313, -5.5972) (-39.75, -5.7211) (-39.75, -11.176) (-39.626, -11.3) (-35.75, -11.3) (-35.7303, -12.1907) (-35.3578, -12.322) (-35.2105, -12.5247) (-35.2681, -12.8883) (-35.4708, -13.0356) (-35.6759, -13.0628) (-35.75, -13.1745) (-35.7303, -23.343) (-35.626, -23.4) (-10.0911, -23.4) (-10.0241, -23.3803), closed, covered)
  P6_DCN_L2_h0 = polyline(z=0mm, xy in mm: (-37.3503, 11.4144) (-37.6106, 11.6747) (-37.6106, 11.9253) (-37.4633, 12.1281) (-37.0997, 12.1856) (-36.897, 12.0383) (-36.8195, 11.8) (-36.897, 11.5617) (-37.225, 11.3945) (-37.3503, 11.4144), closed, covered)
  P6_DCN_L2_h1 = polyline(z=0mm, xy in mm: (-10.4003, 11.4144) (-10.6606, 11.6747) (-10.6606, 11.9253) (-10.5133, 12.1281) (-10.1497, 12.1856) (-9.9469, 12.0383) (-9.8695, 11.8) (-9.9469, 11.5617) (-10.275, 11.3945) (-10.4003, 11.4144), closed, covered)
  P6_DCN_L2_h2 = polyline(z=0mm, xy in mm: (10.1497, 11.4144) (9.8894, 11.6747) (9.8894, 11.9253) (10.0367, 12.1281) (10.4003, 12.1856) (10.603, 12.0383) (10.6805, 11.8) (10.603, 11.5617) (10.275, 11.3945) (10.1497, 11.4144), closed, covered)
  P6_DCN_L2_h3 = polyline(z=0mm, xy in mm: (37.0997, 11.4144) (36.8394, 11.6747) (36.8394, 11.9253) (36.9867, 12.1281) (37.3503, 12.1856) (37.5531, 12.0383) (37.6305, 11.8) (37.5531, 11.5617) (37.225, 11.3945) (37.0997, 11.4144), closed, covered)
  P6_DCN_L2_h4 = polyline(z=0mm, xy in mm: (-17.5375, 10.3334) (-17.7276, 10.4715) (-17.7816, 10.8125) (-17.6435, 11.0026) (-17.3025, 11.0566) (-17.1124, 10.9185) (-17.0584, 10.5775) (-17.1965, 10.3874) (-17.42, 10.3148) (-17.5375, 10.3334), closed, covered)
  P6_DCN_L2_h5 = polyline(z=0mm, xy in mm: (29.9625, 10.3334) (29.7724, 10.4715) (29.7184, 10.8125) (29.8565, 11.0026) (30.1975, 11.0566) (30.3876, 10.9185) (30.4416, 10.5775) (30.3035, 10.3874) (30.08, 10.3148) (29.9625, 10.3334), closed, covered)
  P6_DCN_L2_h6 = polyline(z=0mm, xy in mm: (-30.1975, 10.0684) (-30.3876, 10.2065) (-30.4416, 10.5475) (-30.3035, 10.7376) (-29.9625, 10.7916) (-29.7724, 10.6535) (-29.7184, 10.3125) (-29.8565, 10.1224) (-30.08, 10.0498) (-30.1975, 10.0684), closed, covered)
  P6_DCN_L2_h7 = polyline(z=0mm, xy in mm: (17.3025, 10.0684) (17.1124, 10.2065) (17.0584, 10.5475) (17.1965, 10.7376) (17.5375, 10.7916) (17.7276, 10.6535) (17.7816, 10.3125) (17.6435, 10.1224) (17.42, 10.0498) (17.3025, 10.0684), closed, covered)
  P6_DCN_L2_h8 = polyline(z=0mm, xy in mm: (-5.4753, 5.4144) (-5.6781, 5.5617) (-5.7555, 5.8) (-5.5956, 6.1486) (-5.7555, 6.55) (-5.5956, 6.8986) (-5.7555, 7.3) (-5.5956, 7.6486) (-5.7555, 8.05) (-5.5956, 8.3986) (-5.7555, 8.8) (-5.5956, 9.1486) (-5.7555, 9.55) (-5.5956, 9.8986) (-5.7356, 10.1747) (-5.7356, 10.4253) (-5.5883, 10.6281) (-5.35, 10.7055) (-5.1117, 10.6281) (-4.8447, 10.3501) (-4.5883, 10.6281) (-4.2247, 10.6856) (-4.022, 10.5383) (-3.9445, 10.3) (-4.1044, 9.9514) (-3.9445, 9.55) (-4.1044, 9.2014) (-3.9445, 8.8) (-4.1044, 8.4514) (-3.9445, 8.05) (-4.1044, 7.7014) (-3.9445, 7.3) (-4.1044, 6.9514) (-3.9445, 6.55) (-4.1044, 6.2014) (-3.9644, 5.9253) (-3.9644, 5.6747) (-4.1117, 5.472) (-4.35, 5.3945) (-4.5883, 5.472) (-4.8553, 5.7499) (-5.1117, 5.472) (-5.35, 5.3945) (-5.4753, 5.4144), closed, covered)
  P6_DCN_L2_h9 = polyline(z=0mm, xy in mm: (4.2247, 5.4144) (4.022, 5.5617) (3.9445, 5.8) (4.1044, 6.1486) (3.9445, 6.55) (4.1044, 6.8986) (3.9445, 7.3) (4.1044, 7.6486) (3.9445, 8.05) (4.1044, 8.3986) (3.9445, 8.8) (4.1044, 9.1486) (3.9445, 9.55) (4.1044, 9.8986) (3.9644, 10.1747) (3.9644, 10.4253) (4.1117, 10.6281) (4.35, 10.7055) (4.5883, 10.6281) (4.8553, 10.3501) (5.1117, 10.6281) (5.4753, 10.6856) (5.6781, 10.5383) (5.7555, 10.3) (5.5956, 9.9514) (5.7555, 9.55) (5.5956, 9.2014) (5.7555, 8.8) (5.5956, 8.4514) (5.7555, 8.05) (5.5956, 7.7014) (5.7555, 7.3) (5.5956, 6.9514) (5.7555, 6.55) (5.5956, 6.2014) (5.7356, 5.9253) (5.7356, 5.6747) (5.5883, 5.472) (5.35, 5.3945) (5.1117, 5.472) (4.8447, 5.7499) (4.5883, 5.472) (4.35, 5.3945) (4.2247, 5.4144), closed, covered)
  P6_DCN_L2_h10 = polyline(z=0mm, xy in mm: (-17.5375, 7.6084) (-17.7276, 7.7465) (-17.7816, 8.0875) (-17.6435, 8.2776) (-17.3025, 8.3316) (-17.1124, 8.1935) (-17.0584, 7.8525) (-17.1965, 7.6624) (-17.42, 7.5898) (-17.5375, 7.6084), closed, covered)
  P6_DCN_L2_h11 = polyline(z=0mm, xy in mm: (29.9625, 7.6084) (29.7724, 7.7465) (29.7184, 8.0875) (29.8565, 8.2776) (30.1975, 8.3316) (30.3876, 8.1935) (30.4416, 7.8525) (30.3035, 7.6624) (30.08, 7.5898) (29.9625, 7.6084), closed, covered)
  P6_DCN_L2_h12 = polyline(z=0mm, xy in mm: (-30.1975, 7.3434) (-30.3876, 7.4815) (-30.4416, 7.8225) (-30.3035, 8.0126) (-29.9625, 8.0666) (-29.7724, 7.9285) (-29.7184, 7.5875) (-29.8565, 7.3974) (-30.08, 7.3248) (-30.1975, 7.3434), closed, covered)
  P6_DCN_L2_h13 = polyline(z=0mm, xy in mm: (17.3025, 7.3434) (17.1124, 7.4815) (17.0584, 7.8225) (17.1965, 8.0126) (17.5375, 8.0666) (17.7276, 7.9285) (17.7816, 7.5875) (17.6435, 7.3974) (17.42, 7.3248) (17.3025, 7.3434), closed, covered)
  P6_DCN_L2_h14 = polyline(z=0mm, xy in mm: (-29.3253, 6.6644) (-29.5856, 6.9247) (-29.5856, 7.1753) (-29.4383, 7.3781) (-29.0747, 7.4356) (-28.8719, 7.2883) (-28.7945, 7.05) (-28.8719, 6.8117) (-29.2, 6.6445) (-29.3253, 6.6644), closed, covered)
  P6_DCN_L2_h15 = polyline(z=0mm, xy in mm: (-18.4253, 6.6644) (-18.6856, 6.9247) (-18.6856, 7.1753) (-18.5383, 7.3781) (-18.1747, 7.4356) (-17.9719, 7.2883) (-17.8945, 7.05) (-17.9719, 6.8117) (-18.3, 6.6445) (-18.4253, 6.6644), closed, covered)
  P6_DCN_L2_h16 = polyline(z=0mm, xy in mm: (18.1747, 6.6644) (17.9144, 6.9247) (17.9144, 7.1753) (18.0617, 7.3781) (18.4253, 7.4356) (18.6281, 7.2883) (18.7055, 7.05) (18.6281, 6.8117) (18.3, 6.6445) (18.1747, 6.6644), closed, covered)
  P6_DCN_L2_h17 = polyline(z=0mm, xy in mm: (29.0747, 6.6644) (28.8144, 6.9247) (28.8144, 7.1753) (28.9617, 7.3781) (29.3253, 7.4356) (29.5281, 7.2883) (29.6055, 7.05) (29.5281, 6.8117) (29.2, 6.6445) (29.0747, 6.6644), closed, covered)
  P6_DCN_L2_h18 = polyline(z=0mm, xy in mm: (-17.5375, 6.0334) (-17.7276, 6.1715) (-17.7816, 6.5125) (-17.6435, 6.7026) (-17.3025, 6.7566) (-17.1124, 6.6185) (-17.0584, 6.2775) (-17.1965, 6.0874) (-17.42, 6.0148) (-17.5375, 6.0334), closed, covered)
  P6_DCN_L2_h19 = polyline(z=0mm, xy in mm: (29.9625, 6.0334) (29.7724, 6.1715) (29.7184, 6.5125) (29.8565, 6.7026) (30.1975, 6.7566) (30.3876, 6.6185) (30.4416, 6.2775) (30.3035, 6.0874) (30.08, 6.0148) (29.9625, 6.0334), closed, covered)
  P6_DCN_L2_h20 = polyline(z=0mm, xy in mm: (-30.1975, 5.7684) (-30.3876, 5.9065) (-30.4416, 6.2475) (-30.3035, 6.4376) (-29.9625, 6.4916) (-29.7724, 6.3535) (-29.7184, 6.0125) (-29.8565, 5.8224) (-30.08, 5.7498) (-30.1975, 5.7684), closed, covered)
  P6_DCN_L2_h21 = polyline(z=0mm, xy in mm: (17.3025, 5.7684) (17.1124, 5.9065) (17.0584, 6.2475) (17.1965, 6.4376) (17.5375, 6.4916) (17.7276, 6.3535) (17.7816, 6.0125) (17.6435, 5.8224) (17.42, 5.7498) (17.3025, 5.7684), closed, covered)
  P6_DCN_L2_h22 = polyline(z=0mm, xy in mm: (-17.5375, 3.3084) (-17.7276, 3.4465) (-17.7816, 3.7875) (-17.6435, 3.9776) (-17.3025, 4.0316) (-17.1124, 3.8935) (-17.0584, 3.5525) (-17.1965, 3.3624) (-17.42, 3.2898) (-17.5375, 3.3084), closed, covered)
  P6_DCN_L2_h23 = polyline(z=0mm, xy in mm: (29.9625, 3.3084) (29.7724, 3.4465) (29.7184, 3.7875) (29.8565, 3.9776) (30.1975, 4.0316) (30.3876, 3.8935) (30.4416, 3.5525) (30.3035, 3.3624) (30.08, 3.2898) (29.9625, 3.3084), closed, covered)
  P6_DCN_L2_h24 = polyline(z=0mm, xy in mm: (-35.6253, 2.1144) (-35.8281, 2.2617) (-35.9055, 2.5) (-35.8281, 2.7383) (-35.5, 2.9055) (-35.0447, 2.6482) (-34.8383, 2.8281) (-34.6, 2.9055) (-34.1447, 2.6482) (-33.9383, 2.8281) (-33.7, 2.9055) (-33.2447, 2.6482) (-33.0383, 2.8281) (-32.8, 2.9055) (-32.3447, 2.6482) (-32.1383, 2.8281) (-31.9, 2.9055) (-31.4447, 2.6482) (-31.1253, 2.8856) (-30.8747, 2.8856) (-30.5447, 2.6482) (-30.2058, 2.9769) (-30.4416, 3.2875) (-30.4416, 3.5225) (-30.3035, 3.7126) (-30.08, 3.7852) (-29.8565, 3.7126) (-29.6998, 3.405) (-29.7724, 3.1815) (-29.9574, 3.0239) (-29.9517, 2.89) (-29.6447, 2.6482) (-29.3253, 2.8856) (-29.0747, 2.8856) (-28.8719, 2.7383) (-28.7945, 2.5) (-28.8719, 2.2617) (-29.2, 2.0945) (-29.6553, 2.3518) (-29.8617, 2.1719) (-30.1, 2.0945) (-30.5553, 2.3518) (-30.7617, 2.1719) (-31, 2.0945) (-31.4553, 2.3518) (-31.6617, 2.1719) (-31.9, 2.0945) (-32.3553, 2.3517) (-32.6747, 2.1144) (-32.9253, 2.1144) (-33.2553, 2.3518) (-33.4617, 2.1719) (-33.7, 2.0945) (-34.1553, 2.3518) (-34.4747, 2.1144) (-34.7253, 2.1144) (-35.0553, 2.3518) (-35.2617, 2.1719) (-35.5, 2.0945) (-35.6253, 2.1144), closed, covered)
  P6_DCN_L2_h25 = polyline(z=0mm, xy in mm: (11.8747, 2.1144) (11.672, 2.2617) (11.5945, 2.5) (11.7617, 2.8281) (12, 2.9055) (12.4553, 2.6482) (12.6617, 2.8281) (12.9, 2.9055) (13.3553, 2.6482) (13.5617, 2.8281) (13.8, 2.9055) (14.2553, 2.6482) (14.4617, 2.8281) (14.7, 2.9055) (15.1553, 2.6482) (15.3617, 2.8281) (15.6, 2.9055) (16.0553, 2.6482) (16.3747, 2.8856) (16.6253, 2.8856) (16.9553, 2.6482) (17.2942, 2.9769) (17.0584, 3.2875) (17.0584, 3.5225) (17.1965, 3.7126) (17.42, 3.7852) (17.6435, 3.7126) (17.8002, 3.405) (17.7276, 3.1815) (17.5426, 3.0239) (17.5483, 2.89) (17.8553, 2.6482) (18.1747, 2.8856) (18.4253, 2.8856) (18.6281, 2.7383) (18.7055, 2.5) (18.6281, 2.2617) (18.3, 2.0945) (17.8447, 2.3518) (17.6383, 2.1719) (17.4, 2.0945) (16.9447, 2.3518) (16.7383, 2.1719) (16.5, 2.0945) (16.0447, 2.3518) (15.8383, 2.1719) (15.6, 2.0945) (15.1447, 2.3518) (14.9383, 2.1719) (14.7, 2.0945) (14.2447, 2.3518) (14.0383, 2.1719) (13.8, 2.0945) (13.3447, 2.3518) (13.0253, 2.1144) (12.7747, 2.1144) (12.4447, 2.3518) (12.2383, 2.1719) (12, 2.0945) (11.8747, 2.1144), closed, covered)
  P6_DCN_L2_h26 = polyline(z=0mm, xy in mm: (-18.4253, 2.1144) (-18.6281, 2.2617) (-18.7055, 2.5) (-18.6281, 2.7383) (-18.3, 2.9055) (-17.8447, 2.6482) (-17.6383, 2.8281) (-17.4, 2.9055) (-16.9447, 2.6482) (-16.7383, 2.8281) (-16.5, 2.9055) (-16.0447, 2.6482) (-15.8383, 2.8281) (-15.6, 2.9055) (-15.1447, 2.6482) (-14.9383, 2.8281) (-14.7, 2.9055) (-14.2447, 2.6482) (-14.0383, 2.8281) (-13.8, 2.9055) (-13.3447, 2.6482) (-13.0253, 2.8856) (-12.7747, 2.8856) (-12.4447, 2.6482) (-12.2383, 2.8281) (-12, 2.9055) (-11.7617, 2.8281) (-11.5945, 2.5) (-11.7617, 2.1719) (-12, 2.0945) (-12.4553, 2.3517) (-12.7747, 2.1144) (-13.0253, 2.1144) (-13.3553, 2.3518) (-13.5617, 2.1719) (-13.8, 2.0945) (-14.2553, 2.3518) (-14.4617, 2.1719) (-14.7, 2.0945) (-15.1553, 2.3518) (-15.3617, 2.1719) (-15.6, 2.0945) (-16.0553, 2.3518) (-16.2617, 2.1719) (-16.5, 2.0945) (-16.9553, 2.3518) (-17.2747, 2.1144) (-17.5253, 2.1144) (-17.8553, 2.3518) (-18.0617, 2.1719) (-18.3, 2.0945) (-18.4253, 2.1144), closed, covered)
  P6_DCN_L2_h27 = polyline(z=0mm, xy in mm: (29.0747, 2.1144) (28.8719, 2.2617) (28.7945, 2.5) (28.8719, 2.7383) (29.2, 2.9055) (29.6553, 2.6482) (29.8617, 2.8281) (30.1, 2.9055) (30.5553, 2.6482) (30.7617, 2.8281) (31, 2.9055) (31.4553, 2.6482) (31.6617, 2.8281) (31.9, 2.9055) (32.3553, 2.6482) (32.5617, 2.8281) (32.8, 2.9055) (33.2553, 2.6482) (33.4617, 2.8281) (33.7, 2.9055) (34.1553, 2.6482) (34.4747, 2.8856) (34.7253, 2.8856) (35.0553, 2.6482) (35.2617, 2.8281) (35.5, 2.9055) (35.7383, 2.8281) (35.9055, 2.5) (35.7383, 2.1719) (35.5, 2.0945) (35.0447, 2.3518) (34.8383, 2.1719) (34.6, 2.0945) (34.1447, 2.3518) (33.9383, 2.1719) (33.7, 2.0945) (33.2447, 2.3518) (33.0383, 2.1719) (32.8, 2.0945) (32.3447, 2.3517) (32.0253, 2.1144) (31.7747, 2.1144) (31.4447, 2.3518) (31.2383, 2.1719) (31, 2.0945) (30.5447, 2.3518) (30.2253, 2.1144) (29.9747, 2.1144) (29.6447, 2.3518) (29.4383, 2.1719) (29.2, 2.0945) (29.0747, 2.1144), closed, covered)
  P6_DCN_L2_h28 = polyline(z=0mm, xy in mm: (-38.0907, -5.8856) (-38.3022, -5.7211) (-38.351, -5.3747) (-38.2037, -5.1719) (-37.8401, -5.1144) (-37.5797, -5.3747) (-37.5797, -5.6253) (-37.727, -5.8281) (-37.9654, -5.9055) (-38.0907, -5.8856), closed, covered)
  P6_DCN_L2_h29 = polyline(z=0mm, xy in mm: (-36.9061, -5.8856) (-37.1176, -5.7211) (-37.1664, -5.3747) (-37.0191, -5.1719) (-36.6555, -5.1144) (-36.3951, -5.3747) (-36.3951, -5.6253) (-36.5424, -5.8281) (-36.7808, -5.9055) (-36.9061, -5.8856), closed, covered)
  P6_DCN_L2_h30 = polyline(z=0mm, xy in mm: (-35.7215, -5.8856) (-35.933, -5.7211) (-35.9818, -5.3747) (-35.8345, -5.1719) (-35.4708, -5.1144) (-35.2105, -5.3747) (-35.2105, -5.6253) (-35.3578, -5.8281) (-35.5962, -5.9055) (-35.7215, -5.8856), closed, covered)
  P6_DCN_L2_h31 = polyline(z=0mm, xy in mm: (-34.5368, -5.8856) (-34.7484, -5.7211) (-34.7972, -5.3747) (-34.6499, -5.1719) (-34.2862, -5.1144) (-34.0835, -5.2617) (-34.006, -5.5) (-34.1732, -5.8281) (-34.4115, -5.9055) (-34.5368, -5.8856), closed, covered)
  P6_DCN_L2_h32 = polyline(z=0mm, xy in mm: (-33.3522, -5.8856) (-33.5638, -5.7211) (-33.6126, -5.3747) (-33.4653, -5.1719) (-33.1016, -5.1144) (-32.8989, -5.2617) (-32.8214, -5.5) (-32.9886, -5.8281) (-33.2269, -5.9055) (-33.3522, -5.8856), closed, covered)
  P6_DCN_L2_h33 = polyline(z=0mm, xy in mm: (-32.1676, -5.8856) (-32.428, -5.6253) (-32.428, -5.3747) (-32.2806, -5.1719) (-31.917, -5.1144) (-31.7143, -5.2617) (-31.6368, -5.5) (-31.804, -5.8281) (-32.0423, -5.9055) (-32.1676, -5.8856), closed, covered)
  P6_DCN_L2_h34 = polyline(z=0mm, xy in mm: (-30.983, -5.8856) (-31.1945, -5.7211) (-31.2433, -5.3747) (-31.096, -5.1719) (-30.7324, -5.1144) (-30.472, -5.3747) (-30.472, -5.6253) (-30.6193, -5.8281) (-30.8577, -5.9055) (-30.983, -5.8856), closed, covered)
  P6_DCN_L2_h35 = polyline(z=0mm, xy in mm: (-29.7984, -5.8856) (-30.0099, -5.7211) (-30.0587, -5.3747) (-29.9114, -5.1719) (-29.5478, -5.1144) (-29.2874, -5.3747) (-29.2874, -5.6253) (-29.4347, -5.8281) (-29.6731, -5.9055) (-29.7984, -5.8856), closed, covered)
  P6_DCN_L2_h36 = polyline(z=0mm, xy in mm: (-28.6138, -5.8856) (-28.8253, -5.7211) (-28.8741, -5.3747) (-28.7268, -5.1719) (-28.3632, -5.1144) (-28.1028, -5.3747) (-28.1028, -5.6253) (-28.2501, -5.8281) (-28.4885, -5.9055) (-28.6138, -5.8856), closed, covered)
  P6_DCN_L2_h37 = polyline(z=0mm, xy in mm: (-27.4291, -5.8856) (-27.6407, -5.7211) (-27.6895, -5.3747) (-27.5422, -5.1719) (-27.1785, -5.1144) (-26.9182, -5.3747) (-26.9182, -5.6253) (-27.0655, -5.8281) (-27.3038, -5.9055) (-27.4291, -5.8856), closed, covered)
  P6_DCN_L2_h38 = polyline(z=0mm, xy in mm: (-26.2445, -5.8856) (-26.4561, -5.7211) (-26.5049, -5.3747) (-26.3576, -5.1719) (-25.9939, -5.1144) (-25.7912, -5.2617) (-25.7137, -5.5) (-25.8809, -5.8281) (-26.1192, -5.9055) (-26.2445, -5.8856), closed, covered)
  P6_DCN_L2_h39 = polyline(z=0mm, xy in mm: (-25.0599, -5.8856) (-25.3203, -5.6253) (-25.3203, -5.3747) (-25.173, -5.1719) (-24.8093, -5.1144) (-24.6066, -5.2617) (-24.5291, -5.5) (-24.6963, -5.8281) (-24.9346, -5.9055) (-25.0599, -5.8856), closed, covered)
  P6_DCN_L2_h40 = polyline(z=0mm, xy in mm: (-23.8753, -5.8856) (-24.0781, -5.7383) (-24.1356, -5.3747) (-23.9883, -5.1719) (-23.6247, -5.1144) (-23.4219, -5.2617) (-23.3445, -5.5) (-23.4219, -5.7383) (-23.75, -5.9055) (-23.8753, -5.8856), closed, covered)
  P6_DCN_L2_h41 = polyline(z=0mm, xy in mm: (-22.6907, -5.8856) (-22.9022, -5.7211) (-22.951, -5.3747) (-22.8037, -5.1719) (-22.4401, -5.1144) (-22.1797, -5.3747) (-22.1797, -5.6253) (-22.327, -5.8281) (-22.5654, -5.9055) (-22.6907, -5.8856), closed, covered)
  P6_DCN_L2_h42 = polyline(z=0mm, xy in mm: (-21.5061, -5.8856) (-21.7176, -5.7211) (-21.7664, -5.3747) (-21.6191, -5.1719) (-21.2555, -5.1144) (-20.9951, -5.3747) (-20.9951, -5.6253) (-21.1424, -5.8281) (-21.3808, -5.9055) (-21.5061, -5.8856), closed, covered)
  P6_DCN_L2_h43 = polyline(z=0mm, xy in mm: (-20.3215, -5.8856) (-20.533, -5.7211) (-20.5818, -5.3747) (-20.4345, -5.1719) (-20.0708, -5.1144) (-19.8105, -5.3747) (-19.8105, -5.6253) (-19.9578, -5.8281) (-20.1962, -5.9055) (-20.3215, -5.8856), closed, covered)
  P6_DCN_L2_h44 = polyline(z=0mm, xy in mm: (-19.1368, -5.8856) (-19.3484, -5.7211) (-19.3972, -5.3747) (-19.2499, -5.1719) (-18.8862, -5.1144) (-18.6835, -5.2617) (-18.606, -5.5) (-18.7732, -5.8281) (-19.0115, -5.9055) (-19.1368, -5.8856), closed, covered)
  P6_DCN_L2_h45 = polyline(z=0mm, xy in mm: (-17.9522, -5.8856) (-18.1638, -5.7211) (-18.2126, -5.3747) (-18.0653, -5.1719) (-17.7016, -5.1144) (-17.4989, -5.2617) (-17.4214, -5.5) (-17.5886, -5.8281) (-17.8269, -5.9055) (-17.9522, -5.8856), closed, covered)
  P6_DCN_L2_h46 = polyline(z=0mm, xy in mm: (-16.7676, -5.8856) (-17.028, -5.6253) (-17.028, -5.3747) (-16.8806, -5.1719) (-16.517, -5.1144) (-16.3143, -5.2617) (-16.2368, -5.5) (-16.404, -5.8281) (-16.6423, -5.9055) (-16.7676, -5.8856), closed, covered)
  P6_DCN_L2_h47 = polyline(z=0mm, xy in mm: (-15.583, -5.8856) (-15.7945, -5.7211) (-15.8433, -5.3747) (-15.696, -5.1719) (-15.3324, -5.1144) (-15.072, -5.3747) (-15.072, -5.6253) (-15.2193, -5.8281) (-15.4577, -5.9055) (-15.583, -5.8856), closed, covered)
  P6_DCN_L2_h48 = polyline(z=0mm, xy in mm: (-14.3984, -5.8856) (-14.6099, -5.7211) (-14.6587, -5.3747) (-14.5114, -5.1719) (-14.1478, -5.1144) (-13.8874, -5.3747) (-13.8874, -5.6253) (-14.0347, -5.8281) (-14.2731, -5.9055) (-14.3984, -5.8856), closed, covered)
  P6_DCN_L2_h49 = polyline(z=0mm, xy in mm: (-13.2138, -5.8856) (-13.4253, -5.7211) (-13.4741, -5.3747) (-13.3268, -5.1719) (-12.9632, -5.1144) (-12.7028, -5.3747) (-12.7028, -5.6253) (-12.8501, -5.8281) (-13.0885, -5.9055) (-13.2138, -5.8856), closed, covered)
  P6_DCN_L2_h50 = polyline(z=0mm, xy in mm: (-12.0291, -5.8856) (-12.2407, -5.7211) (-12.2895, -5.3747) (-12.1422, -5.1719) (-11.7785, -5.1144) (-11.5182, -5.3747) (-11.5182, -5.6253) (-11.6655, -5.8281) (-11.9038, -5.9055) (-12.0291, -5.8856), closed, covered)
  P6_DCN_L2_h51 = polyline(z=0mm, xy in mm: (-10.8445, -5.8856) (-11.0561, -5.7211) (-11.1049, -5.3747) (-10.9576, -5.1719) (-10.5939, -5.1144) (-10.3912, -5.2617) (-10.3137, -5.5) (-10.4809, -5.8281) (-10.7192, -5.9055) (-10.8445, -5.8856), closed, covered)
  P6_DCN_L2_h52 = polyline(z=0mm, xy in mm: (-9.6599, -5.8856) (-9.9203, -5.6253) (-9.9203, -5.3747) (-9.773, -5.1719) (-9.4093, -5.1144) (-9.2066, -5.2617) (-9.1291, -5.5) (-9.2963, -5.8281) (-9.5346, -5.9055) (-9.6599, -5.8856), closed, covered)
  P6_DCN_L2_h53 = polyline(z=0mm, xy in mm: (-8.4753, -5.8856) (-8.6868, -5.7211) (-8.7356, -5.3747) (-8.5883, -5.1719) (-8.2247, -5.1144) (-8.0219, -5.2617) (-7.9445, -5.5) (-8.0219, -5.7383) (-8.35, -5.9055) (-8.4753, -5.8856), closed, covered)
  P6_DCN_L2_h54 = polyline(z=0mm, xy in mm: (-7.2753, -5.8856) (-7.5356, -5.6253) (-7.5356, -5.3747) (-7.3883, -5.1719) (-7.0247, -5.1144) (-6.8219, -5.2617) (-6.7445, -5.5) (-6.9117, -5.8281) (-7.15, -5.9055) (-7.2753, -5.8856), closed, covered)
  P6_DCN_L2_h55 = polyline(z=0mm, xy in mm: (-6.0753, -5.8856) (-6.3356, -5.6253) (-6.3356, -5.3747) (-6.1883, -5.1719) (-5.8247, -5.1144) (-5.6219, -5.2617) (-5.5445, -5.5) (-5.6219, -5.7383) (-5.95, -5.9055) (-6.0753, -5.8856), closed, covered)
  P6_DCN_L2_h56 = polyline(z=0mm, xy in mm: (-4.8753, -5.8856) (-5.1356, -5.6253) (-5.1356, -5.3747) (-4.9883, -5.1719) (-4.6247, -5.1144) (-4.422, -5.2617) (-4.3445, -5.5) (-4.5117, -5.8281) (-4.75, -5.9055) (-4.8753, -5.8856), closed, covered)
  P6_DCN_L2_h57 = polyline(z=0mm, xy in mm: (-3.6753, -5.8856) (-3.9356, -5.6253) (-3.9356, -5.3747) (-3.7883, -5.1719) (-3.4247, -5.1144) (-3.2219, -5.2617) (-3.1445, -5.5) (-3.2219, -5.7383) (-3.55, -5.9055) (-3.6753, -5.8856), closed, covered)
  P6_DCN_L2_h58 = polyline(z=0mm, xy in mm: (-2.4753, -5.8856) (-2.7356, -5.6253) (-2.7356, -5.3747) (-2.5883, -5.1719) (-2.2247, -5.1144) (-2.0219, -5.2617) (-1.9445, -5.5) (-2.1117, -5.8281) (-2.35, -5.9055) (-2.4753, -5.8856), closed, covered)
  P6_DCN_L2_h59 = polyline(z=0mm, xy in mm: (-1.2753, -5.8856) (-1.5356, -5.6253) (-1.5356, -5.3747) (-1.3883, -5.1719) (-1.0247, -5.1144) (-0.8219, -5.2617) (-0.7445, -5.5) (-0.8219, -5.7383) (-1.15, -5.9055) (-1.2753, -5.8856), closed, covered)
  P6_DCN_L2_h60 = polyline(z=0mm, xy in mm: (-0.0753, -5.8856) (-0.3356, -5.6253) (-0.3356, -5.3747) (-0.1883, -5.1719) (0.1753, -5.1144) (0.3781, -5.2617) (0.4555, -5.5) (0.3781, -5.7383) (0.05, -5.9055) (-0.0753, -5.8856), closed, covered)
  P6_DCN_L2_h61 = polyline(z=0mm, xy in mm: (1.1247, -5.8856) (0.8644, -5.6253) (0.8644, -5.3747) (1.0117, -5.1719) (1.3753, -5.1144) (1.578, -5.2617) (1.6555, -5.5) (1.4883, -5.8281) (1.25, -5.9055) (1.1247, -5.8856), closed, covered)
  P6_DCN_L2_h62 = polyline(z=0mm, xy in mm: (2.3247, -5.8856) (2.0644, -5.6253) (2.0644, -5.3747) (2.2117, -5.1719) (2.5753, -5.1144) (2.7781, -5.2617) (2.8555, -5.5) (2.7781, -5.7383) (2.45, -5.9055) (2.3247, -5.8856), closed, covered)
  P6_DCN_L2_h63 = polyline(z=0mm, xy in mm: (3.5247, -5.8856) (3.2644, -5.6253) (3.2644, -5.3747) (3.4117, -5.1719) (3.7753, -5.1144) (3.978, -5.2617) (4.0555, -5.5) (3.8883, -5.8281) (3.65, -5.9055) (3.5247, -5.8856), closed, covered)
  P6_DCN_L2_h64 = polyline(z=0mm, xy in mm: (4.7247, -5.8856) (4.4644, -5.6253) (4.4644, -5.3747) (4.6117, -5.1719) (4.9753, -5.1144) (5.1781, -5.2617) (5.2555, -5.5) (5.1781, -5.7383) (4.85, -5.9055) (4.7247, -5.8856), closed, covered)
  P6_DCN_L2_h65 = polyline(z=0mm, xy in mm: (5.9247, -5.8856) (5.6644, -5.6253) (5.6644, -5.3747) (5.8117, -5.1719) (6.1753, -5.1144) (6.3781, -5.2617) (6.4555, -5.5) (6.3781, -5.7383) (6.05, -5.9055) (5.9247, -5.8856), closed, covered)
  P6_DCN_L2_h66 = polyline(z=0mm, xy in mm: (8.2247, -5.8856) (8.0132, -5.7211) (7.9644, -5.3747) (8.1117, -5.1719) (8.4753, -5.1144) (8.6781, -5.2617) (8.7555, -5.5) (8.6781, -5.7383) (8.35, -5.9055) (8.2247, -5.8856), closed, covered)
  P6_DCN_L2_h67 = polyline(z=0mm, xy in mm: (9.4093, -5.8856) (9.1978, -5.7211) (9.149, -5.3747) (9.2963, -5.1719) (9.6599, -5.1144) (9.9203, -5.3747) (9.9203, -5.6253) (9.773, -5.8281) (9.5346, -5.9055) (9.4093, -5.8856), closed, covered)
  P6_DCN_L2_h68 = polyline(z=0mm, xy in mm: (10.5939, -5.8856) (10.3824, -5.7211) (10.3336, -5.3747) (10.4809, -5.1719) (10.8445, -5.1144) (11.1049, -5.3747) (11.1049, -5.6253) (10.9576, -5.8281) (10.7192, -5.9055) (10.5939, -5.8856), closed, covered)
  P6_DCN_L2_h69 = polyline(z=0mm, xy in mm: (11.7785, -5.8856) (11.567, -5.7211) (11.5182, -5.3747) (11.6655, -5.1719) (12.0291, -5.1144) (12.2895, -5.3747) (12.2895, -5.6253) (12.1422, -5.8281) (11.9038, -5.9055) (11.7785, -5.8856), closed, covered)
  P6_DCN_L2_h70 = polyline(z=0mm, xy in mm: (12.9632, -5.8856) (12.7516, -5.7211) (12.7028, -5.3747) (12.8501, -5.1719) (13.2138, -5.1144) (13.4165, -5.2617) (13.494, -5.5) (13.3268, -5.8281) (13.0885, -5.9055) (12.9632, -5.8856), closed, covered)
  P6_DCN_L2_h71 = polyline(z=0mm, xy in mm: (14.1478, -5.8856) (13.9362, -5.7211) (13.8874, -5.3747) (14.0347, -5.1719) (14.3984, -5.1144) (14.6011, -5.2617) (14.6786, -5.5) (14.5114, -5.8281) (14.2731, -5.9055) (14.1478, -5.8856), closed, covered)
  P6_DCN_L2_h72 = polyline(z=0mm, xy in mm: (15.3324, -5.8856) (15.072, -5.6253) (15.072, -5.3747) (15.2193, -5.1719) (15.583, -5.1144) (15.7857, -5.2617) (15.8632, -5.5) (15.696, -5.8281) (15.4577, -5.9055) (15.3324, -5.8856), closed, covered)
  P6_DCN_L2_h73 = polyline(z=0mm, xy in mm: (16.517, -5.8856) (16.3055, -5.7211) (16.2567, -5.3747) (16.404, -5.1719) (16.7676, -5.1144) (17.028, -5.3747) (17.028, -5.6253) (16.8806, -5.8281) (16.6423, -5.9055) (16.517, -5.8856), closed, covered)
  P6_DCN_L2_h74 = polyline(z=0mm, xy in mm: (17.7016, -5.8856) (17.4901, -5.7211) (17.4413, -5.3747) (17.5886, -5.1719) (17.9522, -5.1144) (18.2126, -5.3747) (18.2126, -5.6253) (18.0653, -5.8281) (17.8269, -5.9055) (17.7016, -5.8856), closed, covered)
  P6_DCN_L2_h75 = polyline(z=0mm, xy in mm: (18.8862, -5.8856) (18.6747, -5.7211) (18.6259, -5.3747) (18.7732, -5.1719) (19.1368, -5.1144) (19.3972, -5.3747) (19.3972, -5.6253) (19.2499, -5.8281) (19.0115, -5.9055) (18.8862, -5.8856), closed, covered)
  P6_DCN_L2_h76 = polyline(z=0mm, xy in mm: (20.0709, -5.8856) (19.8593, -5.7211) (19.8105, -5.3747) (19.9578, -5.1719) (20.3215, -5.1144) (20.5818, -5.3747) (20.5818, -5.6253) (20.4345, -5.8281) (20.1961, -5.9055) (20.0709, -5.8856), closed, covered)
  P6_DCN_L2_h77 = polyline(z=0mm, xy in mm: (21.2555, -5.8856) (21.0439, -5.7211) (20.9951, -5.3747) (21.1424, -5.1719) (21.5061, -5.1144) (21.7088, -5.2617) (21.7863, -5.5) (21.6191, -5.8281) (21.3808, -5.9055) (21.2555, -5.8856), closed, covered)
  P6_DCN_L2_h78 = polyline(z=0mm, xy in mm: (22.4401, -5.8856) (22.1797, -5.6253) (22.1797, -5.3747) (22.327, -5.1719) (22.6907, -5.1144) (22.8934, -5.2617) (22.9709, -5.5) (22.8037, -5.8281) (22.5654, -5.9055) (22.4401, -5.8856), closed, covered)
  P6_DCN_L2_h79 = polyline(z=0mm, xy in mm: (23.6247, -5.8856) (23.4132, -5.7211) (23.3644, -5.3747) (23.5117, -5.1719) (23.8753, -5.1144) (24.078, -5.2617) (24.1555, -5.5) (23.9883, -5.8281) (23.75, -5.9055) (23.6247, -5.8856), closed, covered)
  P6_DCN_L2_h80 = polyline(z=0mm, xy in mm: (24.8093, -5.8856) (24.5978, -5.7211) (24.549, -5.3747) (24.6963, -5.1719) (25.0599, -5.1144) (25.3203, -5.3747) (25.3203, -5.6253) (25.173, -5.8281) (24.9346, -5.9055) (24.8093, -5.8856), closed, covered)
  P6_DCN_L2_h81 = polyline(z=0mm, xy in mm: (25.9939, -5.8856) (25.7824, -5.7211) (25.7336, -5.3747) (25.8809, -5.1719) (26.2445, -5.1144) (26.5049, -5.3747) (26.5049, -5.6253) (26.3576, -5.8281) (26.1192, -5.9055) (25.9939, -5.8856), closed, covered)
  P6_DCN_L2_h82 = polyline(z=0mm, xy in mm: (27.1785, -5.8856) (26.967, -5.7211) (26.9182, -5.3747) (27.0655, -5.1719) (27.4291, -5.1144) (27.6895, -5.3747) (27.6895, -5.6253) (27.5422, -5.8281) (27.3038, -5.9055) (27.1785, -5.8856), closed, covered)
  P6_DCN_L2_h83 = polyline(z=0mm, xy in mm: (28.3632, -5.8856) (28.1516, -5.7211) (28.1028, -5.3747) (28.2501, -5.1719) (28.6138, -5.1144) (28.8165, -5.2617) (28.894, -5.5) (28.7268, -5.8281) (28.4885, -5.9055) (28.3632, -5.8856), closed, covered)
  P6_DCN_L2_h84 = polyline(z=0mm, xy in mm: (29.5478, -5.8856) (29.3362, -5.7211) (29.2874, -5.3747) (29.4347, -5.1719) (29.7984, -5.1144) (30.0011, -5.2617) (30.0786, -5.5) (29.9114, -5.8281) (29.6731, -5.9055) (29.5478, -5.8856), closed, covered)
  P6_DCN_L2_h85 = polyline(z=0mm, xy in mm: (30.7324, -5.8856) (30.472, -5.6253) (30.472, -5.3747) (30.6193, -5.1719) (30.983, -5.1144) (31.1857, -5.2617) (31.2632, -5.5) (31.096, -5.8281) (30.8577, -5.9055) (30.7324, -5.8856), closed, covered)
  P6_DCN_L2_h86 = polyline(z=0mm, xy in mm: (31.917, -5.8856) (31.7055, -5.7211) (31.6567, -5.3747) (31.804, -5.1719) (32.1676, -5.1144) (32.428, -5.3747) (32.428, -5.6253) (32.2806, -5.8281) (32.0423, -5.9055) (31.917, -5.8856), closed, covered)
  P6_DCN_L2_h87 = polyline(z=0mm, xy in mm: (33.1016, -5.8856) (32.8901, -5.7211) (32.8413, -5.3747) (32.9886, -5.1719) (33.3522, -5.1144) (33.6126, -5.3747) (33.6126, -5.6253) (33.4653, -5.8281) (33.2269, -5.9055) (33.1016, -5.8856), closed, covered)
  P6_DCN_L2_h88 = polyline(z=0mm, xy in mm: (34.2862, -5.8856) (34.0747, -5.7211) (34.0259, -5.3747) (34.1732, -5.1719) (34.5368, -5.1144) (34.7972, -5.3747) (34.7972, -5.6253) (34.6499, -5.8281) (34.4115, -5.9055) (34.2862, -5.8856), closed, covered)
  P6_DCN_L2_h89 = polyline(z=0mm, xy in mm: (35.4709, -5.8856) (35.2593, -5.7211) (35.2105, -5.3747) (35.3578, -5.1719) (35.7215, -5.1144) (35.9818, -5.3747) (35.9818, -5.6253) (35.8345, -5.8281) (35.5961, -5.9055) (35.4709, -5.8856), closed, covered)
  P6_DCN_L2_h90 = polyline(z=0mm, xy in mm: (36.6555, -5.8856) (36.4439, -5.7211) (36.3951, -5.3747) (36.5424, -5.1719) (36.9061, -5.1144) (37.1088, -5.2617) (37.1863, -5.5) (37.0191, -5.8281) (36.7808, -5.9055) (36.6555, -5.8856), closed, covered)
  P6_DCN_L2_h91 = polyline(z=0mm, xy in mm: (37.8401, -5.8856) (37.5797, -5.6253) (37.5797, -5.3747) (37.727, -5.1719) (38.0907, -5.1144) (38.2934, -5.2617) (38.3709, -5.5) (38.2037, -5.8281) (37.9654, -5.9055) (37.8401, -5.8856), closed, covered)
  P6_DCN_L2_h92 = polyline(z=0mm, xy in mm: (-34.5368, -13.0356) (-34.7972, -12.7753) (-34.7972, -12.5247) (-34.6499, -12.322) (-34.2862, -12.2644) (-34.0835, -12.4117) (-34.006, -12.65) (-34.0835, -12.8883) (-34.4115, -13.0555) (-34.5368, -13.0356), closed, covered)
  P6_DCN_L2_h93 = polyline(z=0mm, xy in mm: (-33.3522, -13.0356) (-33.6126, -12.7753) (-33.6126, -12.5247) (-33.4653, -12.322) (-33.1016, -12.2644) (-32.8989, -12.4117) (-32.8214, -12.65) (-32.8989, -12.8883) (-33.2269, -13.0555) (-33.3522, -13.0356), closed, covered)
  P6_DCN_L2_h94 = polyline(z=0mm, xy in mm: (-32.1676, -13.0356) (-32.428, -12.7753) (-32.428, -12.5247) (-32.2807, -12.322) (-31.917, -12.2644) (-31.7143, -12.4117) (-31.6368, -12.65) (-31.7143, -12.8883) (-32.0423, -13.0555) (-32.1676, -13.0356), closed, covered)
  P6_DCN_L2_h95 = polyline(z=0mm, xy in mm: (-30.983, -13.0356) (-31.2433, -12.7753) (-31.2433, -12.5247) (-30.983, -12.2644) (-30.7324, -12.2644) (-30.472, -12.5247) (-30.472, -12.7753) (-30.6193, -12.978) (-30.8577, -13.0555) (-30.983, -13.0356), closed, covered)
  P6_DCN_L2_h96 = polyline(z=0mm, xy in mm: (-29.7984, -13.0356) (-30.0587, -12.7753) (-30.0587, -12.5247) (-29.7984, -12.2644) (-29.5478, -12.2644) (-29.2874, -12.5247) (-29.2874, -12.7753) (-29.4347, -12.978) (-29.6731, -13.0555) (-29.7984, -13.0356), closed, covered)
  P6_DCN_L2_h97 = polyline(z=0mm, xy in mm: (-28.6138, -13.0356) (-28.8741, -12.7753) (-28.8741, -12.5247) (-28.6138, -12.2644) (-28.3632, -12.2644) (-28.1028, -12.5247) (-28.1028, -12.7753) (-28.2501, -12.978) (-28.4885, -13.0555) (-28.6138, -13.0356), closed, covered)
  P6_DCN_L2_h98 = polyline(z=0mm, xy in mm: (-27.4291, -13.0356) (-27.6895, -12.7753) (-27.6895, -12.5247) (-27.4292, -12.2644) (-27.1785, -12.2644) (-26.9182, -12.5247) (-26.9182, -12.7753) (-27.0655, -12.978) (-27.3038, -13.0555) (-27.4291, -13.0356), closed, covered)
  P6_DCN_L2_h99 = polyline(z=0mm, xy in mm: (-26.2445, -13.0356) (-26.5049, -12.7753) (-26.5049, -12.5247) (-26.3576, -12.322) (-25.9939, -12.2644) (-25.7912, -12.4117) (-25.7137, -12.65) (-25.7912, -12.8883) (-26.1192, -13.0555) (-26.2445, -13.0356), closed, covered)
  P6_DCN_L2_h100 = polyline(z=0mm, xy in mm: (-25.0599, -13.0356) (-25.3203, -12.7753) (-25.3203, -12.5247) (-25.173, -12.322) (-24.8093, -12.2644) (-24.6066, -12.4117) (-24.5291, -12.65) (-24.6066, -12.8883) (-24.9346, -13.0555) (-25.0599, -13.0356), closed, covered)
  P6_DCN_L2_h101 = polyline(z=0mm, xy in mm: (-23.8753, -13.0356) (-24.1356, -12.7753) (-24.1356, -12.5247) (-23.8753, -12.2644) (-23.6247, -12.2644) (-23.4219, -12.4117) (-23.3445, -12.65) (-23.4219, -12.8883) (-23.75, -13.0555) (-23.8753, -13.0356), closed, covered)
  P6_DCN_L2_h102 = polyline(z=0mm, xy in mm: (-22.6907, -13.0356) (-22.951, -12.7753) (-22.951, -12.5247) (-22.6907, -12.2644) (-22.4401, -12.2644) (-22.1797, -12.5247) (-22.1797, -12.7753) (-22.327, -12.978) (-22.5654, -13.0555) (-22.6907, -13.0356), closed, covered)
  P6_DCN_L2_h103 = polyline(z=0mm, xy in mm: (-21.5061, -13.0356) (-21.7664, -12.7753) (-21.7664, -12.5247) (-21.5061, -12.2644) (-21.2555, -12.2644) (-20.9951, -12.5247) (-20.9951, -12.7753) (-21.1424, -12.978) (-21.3808, -13.0555) (-21.5061, -13.0356), closed, covered)
  P6_DCN_L2_h104 = polyline(z=0mm, xy in mm: (-20.3215, -13.0356) (-20.5818, -12.7753) (-20.5818, -12.5247) (-20.3215, -12.2644) (-20.0708, -12.2644) (-19.8105, -12.5247) (-19.8105, -12.7753) (-19.9578, -12.978) (-20.1962, -13.0555) (-20.3215, -13.0356), closed, covered)
  P6_DCN_L2_h105 = polyline(z=0mm, xy in mm: (-19.1368, -13.0356) (-19.3972, -12.7753) (-19.3972, -12.5247) (-19.2499, -12.322) (-18.8862, -12.2644) (-18.6835, -12.4117) (-18.606, -12.65) (-18.6835, -12.8883) (-19.0115, -13.0555) (-19.1368, -13.0356), closed, covered)
  P6_DCN_L2_h106 = polyline(z=0mm, xy in mm: (-17.9522, -13.0356) (-18.2126, -12.7753) (-18.2126, -12.5247) (-18.0653, -12.322) (-17.7016, -12.2644) (-17.4989, -12.4117) (-17.4214, -12.65) (-17.4989, -12.8883) (-17.8269, -13.0555) (-17.9522, -13.0356), closed, covered)
  P6_DCN_L2_h107 = polyline(z=0mm, xy in mm: (-16.7676, -13.0356) (-17.028, -12.7753) (-17.028, -12.5247) (-16.8807, -12.322) (-16.517, -12.2644) (-16.3143, -12.4117) (-16.2368, -12.65) (-16.3143, -12.8883) (-16.6423, -13.0555) (-16.7676, -13.0356), closed, covered)
  P6_DCN_L2_h108 = polyline(z=0mm, xy in mm: (-15.583, -13.0356) (-15.8433, -12.7753) (-15.8433, -12.5247) (-15.583, -12.2644) (-15.3324, -12.2644) (-15.072, -12.5247) (-15.072, -12.7753) (-15.2193, -12.978) (-15.4577, -13.0555) (-15.583, -13.0356), closed, covered)
  P6_DCN_L2_h109 = polyline(z=0mm, xy in mm: (-14.3984, -13.0356) (-14.6587, -12.7753) (-14.6587, -12.5247) (-14.3984, -12.2644) (-14.1478, -12.2644) (-13.8874, -12.5247) (-13.8874, -12.7753) (-14.0347, -12.978) (-14.2731, -13.0555) (-14.3984, -13.0356), closed, covered)
  P6_DCN_L2_h110 = polyline(z=0mm, xy in mm: (-13.2138, -13.0356) (-13.4741, -12.7753) (-13.4741, -12.5247) (-13.2138, -12.2644) (-12.9632, -12.2644) (-12.7028, -12.5247) (-12.7028, -12.7753) (-12.8501, -12.978) (-13.0885, -13.0555) (-13.2138, -13.0356), closed, covered)
  P6_DCN_L2_h111 = polyline(z=0mm, xy in mm: (-12.0291, -13.0356) (-12.2895, -12.7753) (-12.2895, -12.5247) (-12.1422, -12.322) (-11.7785, -12.2644) (-11.5182, -12.5247) (-11.5182, -12.7753) (-11.6655, -12.978) (-11.9038, -13.0555) (-12.0291, -13.0356), closed, covered)
  P6_DCN_L2_h112 = polyline(z=0mm, xy in mm: (-10.8445, -13.0356) (-11.1049, -12.7753) (-11.1049, -12.5247) (-10.9576, -12.322) (-10.5939, -12.2644) (-10.3912, -12.4117) (-10.3137, -12.65) (-10.3912, -12.8883) (-10.7192, -13.0555) (-10.8445, -13.0356), closed, covered)
  P6_DCN_L2_h113 = polyline(z=0mm, xy in mm: (-9.6599, -13.0356) (-9.9203, -12.7753) (-9.9203, -12.5247) (-9.773, -12.322) (-9.4093, -12.2644) (-9.2066, -12.4117) (-9.1291, -12.65) (-9.2066, -12.8883) (-9.5346, -13.0555) (-9.6599, -13.0356), closed, covered)
  P6_DCN_L2_h114 = polyline(z=0mm, xy in mm: (-8.4753, -13.0356) (-8.7356, -12.7753) (-8.7356, -12.5247) (-8.4753, -12.2644) (-8.2247, -12.2644) (-8.0219, -12.4117) (-7.9445, -12.65) (-8.0219, -12.8883) (-8.35, -13.0555) (-8.4753, -13.0356), closed, covered)
  P6_DCN_L2_h115 = polyline(z=0mm, xy in mm: (-7.2753, -13.0356) (-7.5356, -12.7753) (-7.5356, -12.5247) (-7.2753, -12.2644) (-7.0247, -12.2644) (-6.8219, -12.4117) (-6.7445, -12.65) (-6.8219, -12.8883) (-7.15, -13.0555) (-7.2753, -13.0356), closed, covered)
  P6_DCN_L2_h116 = polyline(z=0mm, xy in mm: (-6.0753, -13.0356) (-6.3356, -12.7753) (-6.3356, -12.5247) (-6.0753, -12.2644) (-5.8247, -12.2644) (-5.6219, -12.4117) (-5.5445, -12.65) (-5.6219, -12.8883) (-5.95, -13.0555) (-6.0753, -13.0356), closed, covered)
  P6_DCN_L2_h117 = polyline(z=0mm, xy in mm: (-4.8753, -13.0356) (-5.1356, -12.7753) (-5.1356, -12.5247) (-4.8753, -12.2644) (-4.6247, -12.2644) (-4.422, -12.4117) (-4.3445, -12.65) (-4.422, -12.8883) (-4.75, -13.0555) (-4.8753, -13.0356), closed, covered)
  P6_DCN_L2_h118 = polyline(z=0mm, xy in mm: (-3.6753, -13.0356) (-3.9356, -12.7753) (-3.9356, -12.5247) (-3.6753, -12.2644) (-3.4247, -12.2644) (-3.2219, -12.4117) (-3.1445, -12.65) (-3.2219, -12.8883) (-3.55, -13.0555) (-3.6753, -13.0356), closed, covered)
  P6_DCN_L2_h119 = polyline(z=0mm, xy in mm: (-2.4753, -13.0356) (-2.7356, -12.7753) (-2.7356, -12.5247) (-2.4753, -12.2644) (-2.2247, -12.2644) (-2.0219, -12.4117) (-1.9445, -12.65) (-2.0219, -12.8883) (-2.35, -13.0555) (-2.4753, -13.0356), closed, covered)
  P6_DCN_L2_h120 = polyline(z=0mm, xy in mm: (-1.2753, -13.0356) (-1.5356, -12.7753) (-1.5356, -12.5247) (-1.2753, -12.2644) (-1.0247, -12.2644) (-0.8219, -12.4117) (-0.7445, -12.65) (-0.8219, -12.8883) (-1.15, -13.0555) (-1.2753, -13.0356), closed, covered)
  P6_DCN_L2_h121 = polyline(z=0mm, xy in mm: (-0.0753, -13.0356) (-0.3356, -12.7753) (-0.3356, -12.5247) (-0.0753, -12.2644) (0.1753, -12.2644) (0.3781, -12.4117) (0.4555, -12.65) (0.3781, -12.8883) (0.05, -13.0555) (-0.0753, -13.0356), closed, covered)
  P6_DCN_L2_h122 = polyline(z=0mm, xy in mm: (1.1247, -13.0356) (0.8644, -12.7753) (0.8644, -12.5247) (1.1247, -12.2644) (1.3753, -12.2644) (1.578, -12.4117) (1.6555, -12.65) (1.578, -12.8883) (1.25, -13.0555) (1.1247, -13.0356), closed, covered)
  P6_DCN_L2_h123 = polyline(z=0mm, xy in mm: (2.3247, -13.0356) (2.0644, -12.7753) (2.0644, -12.5247) (2.3247, -12.2644) (2.5753, -12.2644) (2.7781, -12.4117) (2.8555, -12.65) (2.7781, -12.8883) (2.45, -13.0555) (2.3247, -13.0356), closed, covered)
  P6_DCN_L2_h124 = polyline(z=0mm, xy in mm: (3.5247, -13.0356) (3.2644, -12.7753) (3.2644, -12.5247) (3.5247, -12.2644) (3.7753, -12.2644) (3.978, -12.4117) (4.0555, -12.65) (3.978, -12.8883) (3.65, -13.0555) (3.5247, -13.0356), closed, covered)
  P6_DCN_L2_h125 = polyline(z=0mm, xy in mm: (4.7247, -13.0356) (4.4644, -12.7753) (4.4644, -12.5247) (4.7247, -12.2644) (4.9753, -12.2644) (5.1781, -12.4117) (5.2555, -12.65) (5.1781, -12.8883) (4.85, -13.0555) (4.7247, -13.0356), closed, covered)
  P6_DCN_L2_h126 = polyline(z=0mm, xy in mm: (5.9247, -13.0356) (5.6644, -12.7753) (5.6644, -12.5247) (5.9247, -12.2644) (6.1753, -12.2644) (6.3781, -12.4117) (6.4555, -12.65) (6.3781, -12.8883) (6.05, -13.0555) (5.9247, -13.0356), closed, covered)
  P6_DCN_L2_h127 = polyline(z=0mm, xy in mm: (8.2247, -13.0356) (7.9644, -12.7753) (7.9644, -12.5247) (8.2247, -12.2644) (8.4753, -12.2644) (8.6781, -12.4117) (8.7555, -12.65) (8.6781, -12.8883) (8.35, -13.0555) (8.2247, -13.0356), closed, covered)
  P6_DCN_L2_h128 = polyline(z=0mm, xy in mm: (9.4093, -13.0356) (9.149, -12.7753) (9.149, -12.5247) (9.4093, -12.2644) (9.6599, -12.2644) (9.9203, -12.5247) (9.9203, -12.7753) (9.773, -12.978) (9.5346, -13.0555) (9.4093, -13.0356), closed, covered)
  P6_DCN_L2_h129 = polyline(z=0mm, xy in mm: (10.5939, -13.0356) (10.3336, -12.7753) (10.3336, -12.5247) (10.5939, -12.2644) (10.8445, -12.2644) (11.1049, -12.5247) (11.1049, -12.7753) (10.9576, -12.978) (10.7192, -13.0555) (10.5939, -13.0356), closed, covered)
  P6_DCN_L2_h130 = polyline(z=0mm, xy in mm: (11.7785, -13.0356) (11.5182, -12.7753) (11.5182, -12.5247) (11.7785, -12.2644) (12.0291, -12.2644) (12.2895, -12.5247) (12.2895, -12.7753) (12.1422, -12.978) (11.9038, -13.0555) (11.7785, -13.0356), closed, covered)
  P6_DCN_L2_h131 = polyline(z=0mm, xy in mm: (12.9632, -13.0356) (12.7028, -12.7753) (12.7028, -12.5247) (12.8501, -12.322) (13.2138, -12.2644) (13.4165, -12.4117) (13.494, -12.65) (13.4165, -12.8883) (13.0885, -13.0555) (12.9632, -13.0356), closed, covered)
  P6_DCN_L2_h132 = polyline(z=0mm, xy in mm: (14.1478, -13.0356) (13.8874, -12.7753) (13.8874, -12.5247) (14.0347, -12.322) (14.3984, -12.2644) (14.6011, -12.4117) (14.6786, -12.65) (14.6011, -12.8883) (14.2731, -13.0555) (14.1478, -13.0356), closed, covered)
  P6_DCN_L2_h133 = polyline(z=0mm, xy in mm: (15.3324, -13.0356) (15.072, -12.7753) (15.072, -12.5247) (15.2193, -12.322) (15.583, -12.2644) (15.7857, -12.4117) (15.8632, -12.65) (15.7857, -12.8883) (15.4577, -13.0555) (15.3324, -13.0356), closed, covered)
  P6_DCN_L2_h134 = polyline(z=0mm, xy in mm: (16.517, -13.0356) (16.2567, -12.7753) (16.2567, -12.5247) (16.517, -12.2644) (16.7676, -12.2644) (17.028, -12.5247) (17.028, -12.7753) (16.8807, -12.978) (16.6423, -13.0555) (16.517, -13.0356), closed, covered)
  P6_DCN_L2_h135 = polyline(z=0mm, xy in mm: (17.7016, -13.0356) (17.4413, -12.7753) (17.4413, -12.5247) (17.7016, -12.2644) (17.9522, -12.2644) (18.2126, -12.5247) (18.2126, -12.7753) (18.0653, -12.978) (17.8269, -13.0555) (17.7016, -13.0356), closed, covered)
  P6_DCN_L2_h136 = polyline(z=0mm, xy in mm: (18.8862, -13.0356) (18.6259, -12.7753) (18.6259, -12.5247) (18.8862, -12.2644) (19.1368, -12.2644) (19.3972, -12.5247) (19.3972, -12.7753) (19.2499, -12.978) (19.0115, -13.0555) (18.8862, -13.0356), closed, covered)
  P6_DCN_L2_h137 = polyline(z=0mm, xy in mm: (20.0709, -13.0356) (19.8105, -12.7753) (19.8105, -12.5247) (20.0708, -12.2644) (20.3215, -12.2644) (20.5818, -12.5247) (20.5818, -12.7753) (20.4345, -12.978) (20.1961, -13.0555) (20.0709, -13.0356), closed, covered)
  P6_DCN_L2_h138 = polyline(z=0mm, xy in mm: (21.2555, -13.0356) (20.9951, -12.7753) (20.9951, -12.5247) (21.1424, -12.322) (21.5061, -12.2644) (21.7088, -12.4117) (21.7863, -12.65) (21.7088, -12.8883) (21.3808, -13.0555) (21.2555, -13.0356), closed, covered)
  P6_DCN_L2_h139 = polyline(z=0mm, xy in mm: (22.4401, -13.0356) (22.1797, -12.7753) (22.1797, -12.5247) (22.327, -12.322) (22.6907, -12.2644) (22.8934, -12.4117) (22.9709, -12.65) (22.8934, -12.8883) (22.5654, -13.0555) (22.4401, -13.0356), closed, covered)
  P6_DCN_L2_h140 = polyline(z=0mm, xy in mm: (23.6247, -13.0356) (23.3644, -12.7753) (23.3644, -12.5247) (23.6247, -12.2644) (23.8753, -12.2644) (24.078, -12.4117) (24.1555, -12.65) (24.078, -12.8883) (23.75, -13.0555) (23.6247, -13.0356), closed, covered)
  P6_DCN_L2_h141 = polyline(z=0mm, xy in mm: (24.8093, -13.0356) (24.549, -12.7753) (24.549, -12.5247) (24.8093, -12.2644) (25.0599, -12.2644) (25.3203, -12.5247) (25.3203, -12.7753) (25.173, -12.978) (24.9346, -13.0555) (24.8093, -13.0356), closed, covered)
  P6_DCN_L2_h142 = polyline(z=0mm, xy in mm: (25.9939, -13.0356) (25.7336, -12.7753) (25.7336, -12.5247) (25.9939, -12.2644) (26.2445, -12.2644) (26.5049, -12.5247) (26.5049, -12.7753) (26.3576, -12.978) (26.1192, -13.0555) (25.9939, -13.0356), closed, covered)
  P6_DCN_L2_h143 = polyline(z=0mm, xy in mm: (27.1785, -13.0356) (26.9182, -12.7753) (26.9182, -12.5247) (27.1785, -12.2644) (27.4291, -12.2644) (27.6895, -12.5247) (27.6895, -12.7753) (27.5422, -12.978) (27.3038, -13.0555) (27.1785, -13.0356), closed, covered)
  P6_DCN_L2_h144 = polyline(z=0mm, xy in mm: (28.3632, -13.0356) (28.1028, -12.7753) (28.1028, -12.5247) (28.2501, -12.322) (28.6138, -12.2644) (28.8165, -12.4117) (28.894, -12.65) (28.8165, -12.8883) (28.4885, -13.0555) (28.3632, -13.0356), closed, covered)
  P6_DCN_L2_h145 = polyline(z=0mm, xy in mm: (29.5478, -13.0356) (29.2874, -12.7753) (29.2874, -12.5247) (29.4347, -12.322) (29.7984, -12.2644) (30.0011, -12.4117) (30.0786, -12.65) (30.0011, -12.8883) (29.6731, -13.0555) (29.5478, -13.0356), closed, covered)
  P6_DCN_L2_h146 = polyline(z=0mm, xy in mm: (30.7324, -13.0356) (30.472, -12.7753) (30.472, -12.5247) (30.6193, -12.322) (30.983, -12.2644) (31.1857, -12.4117) (31.2632, -12.65) (31.1857, -12.8883) (30.8577, -13.0555) (30.7324, -13.0356), closed, covered)
  P6_DCN_L2_h147 = polyline(z=0mm, xy in mm: (31.917, -13.0356) (31.6567, -12.7753) (31.6567, -12.5247) (31.917, -12.2644) (32.1676, -12.2644) (32.428, -12.5247) (32.428, -12.7753) (32.2807, -12.978) (32.0423, -13.0555) (31.917, -13.0356), closed, covered)
  P6_DCN_L2_h148 = polyline(z=0mm, xy in mm: (33.1016, -13.0356) (32.8413, -12.7753) (32.8413, -12.5247) (33.1016, -12.2644) (33.3522, -12.2644) (33.6126, -12.5247) (33.6126, -12.7753) (33.4653, -12.978) (33.2269, -13.0555) (33.1016, -13.0356), closed, covered)
  P6_DCN_L2_h149 = polyline(z=0mm, xy in mm: (34.2862, -13.0356) (34.0259, -12.7753) (34.0259, -12.5247) (34.2862, -12.2644) (34.5368, -12.2644) (34.7972, -12.5247) (34.7972, -12.7753) (34.6499, -12.978) (34.4115, -13.0555) (34.2862, -13.0356), closed, covered)
  P6_DCN_L2_h150 = polyline(z=0mm, xy in mm: (-9.3368, -17.6253) (-9.8378, -17.4287) (-10.4268, -16.8821) (-10.7204, -16.1341) (-10.7204, -15.5959) (-10.4268, -14.8479) (-9.8378, -14.3013) (-9.3368, -14.1047) (-8.5332, -14.1047) (-8.0322, -14.3013) (-7.4432, -14.8479) (-7.1496, -15.5959) (-7.1496, -16.1341) (-7.4432, -16.8821) (-7.8093, -17.2766) (-8.5332, -17.6253) (-9.0699, -17.6655) (-9.3368, -17.6253), closed, covered)
  P6_DCN_L2_h151 = polyline(z=0mm, xy in mm: (-3.4668, -17.6253) (-3.9678, -17.4287) (-4.5568, -16.8821) (-4.8504, -16.1341) (-4.8504, -15.5959) (-4.5568, -14.8479) (-3.9678, -14.3013) (-3.4668, -14.1047) (-2.6632, -14.1047) (-2.1622, -14.3013) (-1.5732, -14.8479) (-1.2796, -15.5959) (-1.2796, -16.1341) (-1.5732, -16.8821) (-1.9393, -17.2766) (-2.6632, -17.6253) (-3.1999, -17.6655) (-3.4668, -17.6253), closed, covered)
  P6_DCN_L2_h152 = polyline(z=0mm, xy in mm: (-12.9025, -21.263) (-13.4168, -20.9446) (-13.6306, -20.5993) (-13.7052, -20.2) (-13.6306, -19.8007) (-13.4168, -19.4554) (-13.0926, -19.2107) (-12.702, -19.0995) (-12.2975, -19.137) (-11.934, -19.318) (-11.6603, -19.6182) (-11.5136, -19.9969) (-11.5136, -20.4031) (-11.6603, -20.7818) (-11.934, -21.082) (-12.2975, -21.263) (-12.702, -21.3005) (-12.9025, -21.263), closed, covered)
  P6_DCN_L2.subtract(P6_DCN_L2_h0..P6_DCN_L2_h152)
  P6_DCN_L2.sweep_along_vector((0mm, 0mm, 0.07mm))
  P7_DCN_L4 = polyline(z=-1.44mm, xy in mm: (-28.4908, -1.1811) (-28.45, 0.851) (-28.5184, 0.9452) (-37.951, 0.95) (-38.0452, 0.8816) (-38.05, -1.101) (-37.9816, -1.1952) (-28.549, -1.2) (-28.4908, -1.1811), closed, covered)
  P7_DCN_L4.sweep_along_vector((0mm, 0mm, 0.07mm))
  P8_DCN_L4 = polyline(z=-1.44mm, xy in mm: (-9.4908, -1.1811) (-9.45, 0.851) (-9.5184, 0.9452) (-18.951, 0.95) (-19.0452, 0.8816) (-19.05, -1.101) (-18.9816, -1.1952) (-9.549, -1.2) (-9.4908, -1.1811), closed, covered)
  P8_DCN_L4.sweep_along_vector((0mm, 0mm, 0.07mm))
  P9_DCN_L4 = polyline(z=-1.44mm, xy in mm: (19.0092, -1.1811) (19.05, 0.851) (18.9816, 0.9452) (9.549, 0.95) (9.4548, 0.8816) (9.45, -1.101) (9.5184, -1.1952) (18.951, -1.2) (19.0092, -1.1811), closed, covered)
  P9_DCN_L4.sweep_along_vector((0mm, 0mm, 0.07mm))
  P10_DCN_L4 = polyline(z=-1.44mm, xy in mm: (38.0092, -1.1811) (38.05, 0.851) (37.9816, 0.9452) (28.549, 0.95) (28.4548, 0.8816) (28.45, -1.101) (28.5184, -1.1952) (37.951, -1.2) (38.0092, -1.1811), closed, covered)
  P10_DCN_L4.sweep_along_vector((0mm, 0mm, 0.07mm))
  P11_DCN_L4 = polyline(z=-1.44mm, xy in mm: (35.7092, -23.3811) (35.75, -16.699) (35.651, -16.6) (-0.4974, -16.6) (-0.9209, -17.345) (-1.5407, -17.9984) (-1.5445, -19.5745) (-1.1149, -20.0074) (-0.7582, -20.5243) (-0.4787, -21.421) (-0.5355, -22.3585) (-0.9615, -23.2974) (-0.8626, -23.4) (35.651, -23.4) (35.7092, -23.3811), closed, covered)
  P11_DCN_L4.sweep_along_vector((0mm, 0mm, 0.07mm))
  P12_DCP_L1 [copper] = polyline(z=0.17mm, xy in mm: (-28.7908, 1.5189) (-28.7689, 3.2087) (-29.621, 3.2495) (-29.9469, 2.9953) (-30.4106, 2.8995) (-31.5175, 2.9494) (-31.6465, 3.1377) (-31.6495, 4.501) (-31.7179, 4.5952) (-32.2005, 4.6) (-32.2947, 4.5316) (-32.2995, 3.1388) (-32.3736, 2.9736) (-32.5389, 2.8995) (-33.1886, 2.9149) (-33.3351, 3.0614) (-33.3505, 4.501) (-33.4189, 4.5952) (-33.9005, 4.6) (-33.9947, 4.5316) (-33.9995, 3.1388) (-34.0736, 2.9736) (-34.2389, 2.8995) (-34.8886, 2.9149) (-35.0351, 3.0614) (-35.0505, 4.501) (-35.1189, 4.5952) (-37.7092, 4.5811) (-37.75, 2.8602) (-39.2322, 4.6759) (-39.4259, 4.5178) (-37.75, 2.4648) (-37.75, 1.599) (-37.6816, 1.5048) (-28.849, 1.5) (-28.7908, 1.5189), closed, covered)
  P12_DCP_L1.sweep_along_vector((0mm, 0mm, 0.07mm))
  P13_DCP_L1 = polyline(z=0.17mm, xy in mm: (-9.7908, 1.5189) (-9.75, 2.4648) (-8.0741, 4.5178) (-8.2678, 4.6759) (-9.75, 2.8602) (-9.75, 4.501) (-9.8184, 4.5952) (-12.4087, 4.5811) (-12.4495, 3.1388) (-12.5236, 2.9736) (-12.6889, 2.8995) (-13.2612, 2.8995) (-13.4264, 2.9736) (-13.5005, 3.1389) (-13.5194, 4.5592) (-14.1087, 4.5811) (-14.1649, 3.0614) (-14.3114, 2.9149) (-14.9612, 2.8995) (-15.1264, 2.9736) (-15.2005, 3.1389) (-15.2194, 4.5592) (-15.7515, 4.6) (-15.8966, 4.38) (-15.8505, 3.1636) (-15.9825, 2.9494) (-17.0894, 2.8995) (-17.3427, 3.0439) (-17.7478, 2.8659) (-18.6827, 2.8868) (-18.75, 2.793) (-18.75, 1.599) (-18.651, 1.5) (-9.849, 1.5) (-9.7908, 1.5189), closed, covered)
  P13_DCP_L1.sweep_along_vector((0mm, 0mm, 0.07mm))
  P14_DCP_L1 = polyline(z=0.17mm, xy in mm: (18.7092, 1.5189) (18.7311, 3.2087) (17.879, 3.2495) (17.5531, 2.9953) (17.0894, 2.8995) (15.9825, 2.9494) (15.8535, 3.1377) (15.8505, 4.501) (15.7821, 4.5952) (15.2995, 4.6) (15.2053, 4.5316) (15.2005, 3.1388) (15.1264, 2.9736) (14.9611, 2.8995) (14.3114, 2.9149) (14.1649, 3.0614) (14.1495, 4.501) (14.0811, 4.5952) (13.5995, 4.6) (13.5053, 4.5316) (13.5005, 3.1388) (13.4264, 2.9736) (13.2611, 2.8995) (12.6114, 2.9149) (12.4649, 3.0614) (12.4495, 4.501) (12.3811, 4.5952) (9.7908, 4.5811) (9.75, 2.8602) (8.2678, 4.6759) (8.0741, 4.5178) (9.75, 2.4648) (9.75, 1.599) (9.8184, 1.5048) (18.651, 1.5) (18.7092, 1.5189), closed, covered)
  P14_DCP_L1.sweep_along_vector((0mm, 0mm, 0.07mm))
  P15_DCP_L1 = polyline(z=0.17mm, xy in mm: (37.7092, 1.5189) (37.75, 2.4648) (39.4259, 4.5178) (39.2322, 4.6759) (37.75, 2.8602) (37.75, 4.501) (37.6816, 4.5952) (35.0913, 4.5811) (35.0505, 3.1388) (34.9764, 2.9736) (34.8111, 2.8995) (34.2388, 2.8995) (34.0736, 2.9736) (33.9995, 3.1389) (33.9806, 4.5592) (33.3913, 4.5811) (33.3351, 3.0614) (33.1886, 2.9149) (32.5388, 2.8995) (32.3736, 2.9736) (32.2995, 3.1389) (32.2806, 4.5592) (31.7485, 4.6) (31.6034, 4.38) (31.6495, 3.1636) (31.5175, 2.9494) (30.4106, 2.8995) (30.1573, 3.0439) (29.7522, 2.8659) (28.8173, 2.8868) (28.75, 2.793) (28.75, 1.599) (28.849, 1.5) (37.651, 1.5) (37.7092, 1.5189), closed, covered)
  P15_DCP_L1.sweep_along_vector((0mm, 0mm, 0.07mm))
  P16_DCP_L1 = polyline(z=0.17mm, xy in mm: (-35.5025, -7.9996) (39.651, -7.9945) (39.75, -7.8955) (39.75, -7.25) (42.3, -7.25) (42.3, -6.95) (39.75, -6.95) (39.75, -4.899) (39.651, -4.8) (-39.651, -4.8) (-39.75, -4.899) (-39.7311, -7.9537) (-35.51, -8) (-35.5025, -7.9996), closed, covered)
  P16_DCP_L1.sweep_along_vector((0mm, 0mm, 0.07mm))
  P17_DCP_L1 = polyline(z=0.17mm, xy in mm: (0.9208, -23.3811) (0.9567, -23.2704) (0.629, -22.6588) (0.4787, -22.049) (0.5354, -21.1115) (0.9209, -20.255) (1.3374, -19.7849) (1.8543, -19.4282) (2.4415, -19.2054) (3.379, -19.1487) (3.9888, -19.299) (4.7926, -19.7849) (5.3718, -20.5243) (5.6513, -21.421) (5.5945, -22.3585) (5.1853, -23.3563) (6.7326, -23.4) (6.8267, -23.2704) (6.499, -22.6588) (6.3297, -21.735) (6.4055, -21.1115) (6.6282, -20.5243) (6.9849, -20.0074) (7.455, -19.5909) (8.3115, -19.2054) (8.935, -19.1297) (9.5585, -19.2054) (10.415, -19.5909) (10.8851, -20.0074) (11.2418, -20.5243) (11.4645, -21.1115) (11.5403, -21.735) (11.371, -22.6588) (11.0385, -23.2974) (11.1374, -23.4) (35.651, -23.4) (35.75, -23.301) (35.75, -16) (39.7092, -15.9811) (39.75, -12.099) (39.6816, -12.0048) (-39.651, -12) (-39.7452, -12.0684) (-39.7311, -15.9592) (-35.75, -16) (-35.75, -23.301) (-35.6816, -23.3952) (0.8626, -23.4) (0.9208, -23.3811), closed, covered)
  P17_DCP_L1_h0 = polyline(z=0.17mm, xy in mm: (2.751, -18.4513) (2.1412, -18.301) (1.585, -18.0091) (0.9209, -17.345) (0.5354, -16.4885) (0.4787, -15.551) (0.629, -14.9412) (0.9209, -14.385) (1.585, -13.7209) (2.4415, -13.3354) (3.379, -13.2787) (4.2757, -13.5582) (5.0151, -14.1374) (5.501, -14.9412) (5.6703, -15.865) (5.501, -16.7888) (5.0151, -17.5926) (4.545, -18.0091) (3.9888, -18.301) (3.065, -18.4703) (2.751, -18.4513), closed, covered)
  P17_DCP_L1_h1 = polyline(z=0.17mm, xy in mm: (8.621, -18.4513) (8.0112, -18.301) (7.455, -18.0091) (6.7909, -17.345) (6.4055, -16.4885) (6.3487, -15.551) (6.499, -14.9412) (6.7909, -14.385) (7.455, -13.7209) (8.3115, -13.3354) (9.249, -13.2787) (10.1457, -13.5582) (10.8851, -14.1374) (11.371, -14.9412) (11.5403, -15.865) (11.371, -16.7888) (10.8851, -17.5926) (10.415, -18.0091) (9.8588, -18.301) (8.935, -18.4703) (8.621, -18.4513), closed, covered)
  P17_DCP_L1_h2 = polyline(z=0.17mm, xy in mm: (12.255, -20.1623) (11.6482, -19.8339) (11.3641, -19.4688) (11.1947, -18.8) (11.2708, -18.3437) (11.491, -17.9368) (11.8314, -17.6235) (12.255, -17.4377) (12.945, -17.4377) (13.3686, -17.6235) (13.709, -17.9368) (13.9292, -18.3437) (13.9861, -19.0313) (13.709, -19.6632) (13.3686, -19.9765) (12.945, -20.1623) (12.484, -20.2005) (12.255, -20.1623), closed, covered)
  P17_DCP_L1.subtract(P17_DCP_L1_h0, P17_DCP_L1_h1, P17_DCP_L1_h2)
  P17_DCP_L1.sweep_along_vector((0mm, 0mm, 0.07mm))
  P18_DCP_L3 = polyline(z=-1.27mm, xy in mm: (1.9759, -23.3803) (2.0026, -23.1948) (1.5732, -22.7521) (1.3397, -22.2672) (1.2595, -21.735) (1.3397, -21.2028) (1.5732, -20.7179) (1.9393, -20.3234) (2.4054, -20.0543) (2.9301, -19.9345) (3.4668, -19.9747) (3.9678, -20.1713) (4.3886, -20.5069) (4.7903, -21.2028) (4.8705, -21.735) (4.7903, -22.2672) (4.5568, -22.7521) (4.107, -23.2276) (4.1296, -23.3597) (4.2211, -23.4) (7.8459, -23.3803) (7.8726, -23.1948) (7.4432, -22.7521) (7.2097, -22.2672) (7.1295, -21.735) (7.2097, -21.2028) (7.4432, -20.7179) (7.8093, -20.3234) (8.2754, -20.0543) (8.8001, -19.9345) (9.3368, -19.9747) (9.8378, -20.1713) (10.2586, -20.5069) (10.6603, -21.2028) (10.7405, -21.735) (10.6603, -22.2672) (10.4268, -22.7521) (9.977, -23.2276) (9.9996, -23.3597) (10.0911, -23.4) (35.693, -23.3803) (35.75, -23.276) (35.75, -13.4) (39.626, -13.4) (39.75, -13.276) (39.7303, -10.9041) (39.6084, -10.8484) (39.3883, -11.0781) (39.15, -11.1555) (38.9117, -11.0781) (38.7445, -10.75) (38.8219, -10.5117) (39.0247, -10.3644) (39.2753, -10.3644) (39.6313, -10.6528) (39.75, -10.5289) (39.75, -0.7211) (39.6084, -0.5984) (39.2753, -0.8856) (39.0247, -0.8856) (38.8219, -0.7383) (38.7445, -0.5) (38.8219, -0.2617) (39.0247, -0.1144) (39.2753, -0.1144) (39.6313, -0.4028) (39.75, -0.2789) (39.75, 4.476) (39.6775, 4.5888) (-39.626, 4.6) (-39.7388, 4.5275) (-39.75, -0.2789) (-39.6084, -0.4016) (-39.2753, -0.1144) (-39.0247, -0.1144) (-38.822, -0.2617) (-38.7445, -0.5) (-38.822, -0.7383) (-39.0247, -0.8856) (-39.2753, -0.8856) (-39.6313, -0.5972) (-39.75, -0.7211) (-39.75, -10.5289) (-39.6084, -10.6516) (-39.2753, -10.3644) (-39.0247, -10.3644) (-38.822, -10.5117) (-38.7445, -10.75) (-38.822, -10.9883) (-39.0247, -11.1356) (-39.2753, -11.1356) (-39.5635, -10.864) (-39.7409, -10.9245) (-39.75, -13.276) (-39.626, -13.4) (-35.75, -13.4) (-35.75, -23.276) (-35.6775, -23.3888) (1.9089, -23.4) (1.9759, -23.3803), closed, covered)
  P18_DCP_L3_h0 = polyline(z=-1.27mm, xy in mm: (-17.5375, 3.3084) (-17.7276, 3.4465) (-17.7816, 3.7875) (-17.6435, 3.9776) (-17.3025, 4.0316) (-17.1124, 3.8935) (-17.0584, 3.5525) (-17.1965, 3.3624) (-17.42, 3.2898) (-17.5375, 3.3084), closed, covered)
  P18_DCP_L3_h1 = polyline(z=-1.27mm, xy in mm: (29.9625, 3.3084) (29.7724, 3.4465) (29.7184, 3.7875) (29.8565, 3.9776) (30.1975, 4.0316) (30.3876, 3.8935) (30.4416, 3.5525) (30.3035, 3.3624) (30.08, 3.2898) (29.9625, 3.3084), closed, covered)
  P18_DCP_L3_h2 = polyline(z=-1.27mm, xy in mm: (-25.6675, 3.2384) (-25.8576, 3.3765) (-25.9116, 3.7175) (-25.7735, 3.9076) (-25.4325, 3.9616) (-25.2424, 3.8235) (-25.1884, 3.4825) (-25.3265, 3.2924) (-25.55, 3.2198) (-25.6675, 3.2384), closed, covered)
  P18_DCP_L3_h3 = polyline(z=-1.27mm, xy in mm: (21.8325, 3.2384) (21.6424, 3.3765) (21.5884, 3.7175) (21.7265, 3.9076) (22.0675, 3.9616) (22.2576, 3.8235) (22.3116, 3.4825) (22.1735, 3.2924) (21.95, 3.2198) (21.8325, 3.2384), closed, covered)
  P18_DCP_L3_h4 = polyline(z=-1.27mm, xy in mm: (-30.1975, 3.0434) (-30.3876, 3.1815) (-30.4416, 3.5225) (-30.3035, 3.7126) (-29.9625, 3.7666) (-29.7724, 3.6285) (-29.7184, 3.2875) (-29.8565, 3.0974) (-30.08, 3.0248) (-30.1975, 3.0434), closed, covered)
  P18_DCP_L3_h5 = polyline(z=-1.27mm, xy in mm: (17.3025, 3.0434) (17.1124, 3.1815) (17.0584, 3.5225) (17.1965, 3.7126) (17.5375, 3.7666) (17.7276, 3.6285) (17.7816, 3.2875) (17.6435, 3.0974) (17.42, 3.0248) (17.3025, 3.0434), closed, covered)
  P18_DCP_L3_h6 = polyline(z=-1.27mm, xy in mm: (-38.0907, -0.8856) (-38.3022, -0.7211) (-38.351, -0.3747) (-38.2037, -0.1719) (-37.8401, -0.1144) (-37.5797, -0.3747) (-37.5797, -0.6253) (-37.727, -0.8281) (-37.9654, -0.9055) (-38.0907, -0.8856), closed, covered)
  P18_DCP_L3_h7 = polyline(z=-1.27mm, xy in mm: (-36.9061, -0.8856) (-37.1176, -0.7211) (-37.1664, -0.3747) (-37.0191, -0.1719) (-36.6555, -0.1144) (-36.3951, -0.3747) (-36.3951, -0.6253) (-36.5424, -0.8281) (-36.7808, -0.9055) (-36.9061, -0.8856), closed, covered)
  P18_DCP_L3_h8 = polyline(z=-1.27mm, xy in mm: (-35.7215, -0.8856) (-35.933, -0.7211) (-35.9818, -0.3747) (-35.8345, -0.1719) (-35.4708, -0.1144) (-35.2105, -0.3747) (-35.2105, -0.6253) (-35.3578, -0.8281) (-35.5962, -0.9055) (-35.7215, -0.8856), closed, covered)
  P18_DCP_L3_h9 = polyline(z=-1.27mm, xy in mm: (-34.5368, -0.8856) (-34.7484, -0.7211) (-34.7972, -0.3747) (-34.6499, -0.1719) (-34.2862, -0.1144) (-34.0835, -0.2617) (-34.006, -0.5) (-34.1732, -0.8281) (-34.4115, -0.9055) (-34.5368, -0.8856), closed, covered)
  P18_DCP_L3_h10 = polyline(z=-1.27mm, xy in mm: (-33.3522, -0.8856) (-33.5638, -0.7211) (-33.6126, -0.3747) (-33.4653, -0.1719) (-33.1016, -0.1144) (-32.8989, -0.2617) (-32.8214, -0.5) (-32.9886, -0.8281) (-33.2269, -0.9055) (-33.3522, -0.8856), closed, covered)
  P18_DCP_L3_h11 = polyline(z=-1.27mm, xy in mm: (-32.1676, -0.8856) (-32.428, -0.6253) (-32.428, -0.3747) (-32.2806, -0.1719) (-31.917, -0.1144) (-31.7143, -0.2617) (-31.6368, -0.5) (-31.804, -0.8281) (-32.0423, -0.9055) (-32.1676, -0.8856), closed, covered)
  P18_DCP_L3_h12 = polyline(z=-1.27mm, xy in mm: (-30.983, -0.8856) (-31.1945, -0.7211) (-31.2433, -0.3747) (-31.096, -0.1719) (-30.7324, -0.1144) (-30.472, -0.3747) (-30.472, -0.6253) (-30.6193, -0.8281) (-30.8577, -0.9055) (-30.983, -0.8856), closed, covered)
  P18_DCP_L3_h13 = polyline(z=-1.27mm, xy in mm: (-29.7984, -0.8856) (-30.0099, -0.7211) (-30.0587, -0.3747) (-29.9114, -0.1719) (-29.5478, -0.1144) (-29.2874, -0.3747) (-29.2874, -0.6253) (-29.4347, -0.8281) (-29.6731, -0.9055) (-29.7984, -0.8856), closed, covered)
  P18_DCP_L3_h14 = polyline(z=-1.27mm, xy in mm: (-28.6138, -0.8856) (-28.8253, -0.7211) (-28.8741, -0.3747) (-28.7268, -0.1719) (-28.3632, -0.1144) (-28.1028, -0.3747) (-28.1028, -0.6253) (-28.2501, -0.8281) (-28.4885, -0.9055) (-28.6138, -0.8856), closed, covered)
  P18_DCP_L3_h15 = polyline(z=-1.27mm, xy in mm: (-27.4291, -0.8856) (-27.6407, -0.7211) (-27.6895, -0.3747) (-27.5422, -0.1719) (-27.1785, -0.1144) (-26.9182, -0.3747) (-26.9182, -0.6253) (-27.0655, -0.8281) (-27.3038, -0.9055) (-27.4291, -0.8856), closed, covered)
  P18_DCP_L3_h16 = polyline(z=-1.27mm, xy in mm: (-26.2445, -0.8856) (-26.4561, -0.7211) (-26.5049, -0.3747) (-26.3576, -0.1719) (-25.9939, -0.1144) (-25.7912, -0.2617) (-25.7137, -0.5) (-25.8809, -0.8281) (-26.1192, -0.9055) (-26.2445, -0.8856), closed, covered)
  P18_DCP_L3_h17 = polyline(z=-1.27mm, xy in mm: (-25.0599, -0.8856) (-25.3203, -0.6253) (-25.3203, -0.3747) (-25.173, -0.1719) (-24.8093, -0.1144) (-24.6066, -0.2617) (-24.5291, -0.5) (-24.6963, -0.8281) (-24.9346, -0.9055) (-25.0599, -0.8856), closed, covered)
  P18_DCP_L3_h18 = polyline(z=-1.27mm, xy in mm: (-23.8753, -0.8856) (-24.0781, -0.7383) (-24.1356, -0.3747) (-23.9883, -0.1719) (-23.6247, -0.1144) (-23.4219, -0.2617) (-23.3445, -0.5) (-23.4219, -0.7383) (-23.75, -0.9055) (-23.8753, -0.8856), closed, covered)
  P18_DCP_L3_h19 = polyline(z=-1.27mm, xy in mm: (-22.6907, -0.8856) (-22.9022, -0.7211) (-22.951, -0.3747) (-22.8037, -0.1719) (-22.4401, -0.1144) (-22.1797, -0.3747) (-22.1797, -0.6253) (-22.327, -0.8281) (-22.5654, -0.9055) (-22.6907, -0.8856), closed, covered)
  P18_DCP_L3_h20 = polyline(z=-1.27mm, xy in mm: (-21.5061, -0.8856) (-21.7176, -0.7211) (-21.7664, -0.3747) (-21.6191, -0.1719) (-21.2555, -0.1144) (-20.9951, -0.3747) (-20.9951, -0.6253) (-21.1424, -0.8281) (-21.3808, -0.9055) (-21.5061, -0.8856), closed, covered)
  P18_DCP_L3_h21 = polyline(z=-1.27mm, xy in mm: (-20.3215, -0.8856) (-20.533, -0.7211) (-20.5818, -0.3747) (-20.4345, -0.1719) (-20.0708, -0.1144) (-19.8105, -0.3747) (-19.8105, -0.6253) (-19.9578, -0.8281) (-20.1962, -0.9055) (-20.3215, -0.8856), closed, covered)
  P18_DCP_L3_h22 = polyline(z=-1.27mm, xy in mm: (-19.1368, -0.8856) (-19.3484, -0.7211) (-19.3972, -0.3747) (-19.2499, -0.1719) (-18.8862, -0.1144) (-18.6835, -0.2617) (-18.606, -0.5) (-18.7732, -0.8281) (-19.0115, -0.9055) (-19.1368, -0.8856), closed, covered)
  P18_DCP_L3_h23 = polyline(z=-1.27mm, xy in mm: (-17.9522, -0.8856) (-18.1638, -0.7211) (-18.2126, -0.3747) (-18.0653, -0.1719) (-17.7016, -0.1144) (-17.4989, -0.2617) (-17.4214, -0.5) (-17.5886, -0.8281) (-17.8269, -0.9055) (-17.9522, -0.8856), closed, covered)
  P18_DCP_L3_h24 = polyline(z=-1.27mm, xy in mm: (-16.7676, -0.8856) (-17.028, -0.6253) (-17.028, -0.3747) (-16.8806, -0.1719) (-16.517, -0.1144) (-16.3143, -0.2617) (-16.2368, -0.5) (-16.404, -0.8281) (-16.6423, -0.9055) (-16.7676, -0.8856), closed, covered)
  P18_DCP_L3_h25 = polyline(z=-1.27mm, xy in mm: (-15.583, -0.8856) (-15.7945, -0.7211) (-15.8433, -0.3747) (-15.696, -0.1719) (-15.3324, -0.1144) (-15.072, -0.3747) (-15.072, -0.6253) (-15.2193, -0.8281) (-15.4577, -0.9055) (-15.583, -0.8856), closed, covered)
  P18_DCP_L3_h26 = polyline(z=-1.27mm, xy in mm: (-14.3984, -0.8856) (-14.6099, -0.7211) (-14.6587, -0.3747) (-14.5114, -0.1719) (-14.1478, -0.1144) (-13.8874, -0.3747) (-13.8874, -0.6253) (-14.0347, -0.8281) (-14.2731, -0.9055) (-14.3984, -0.8856), closed, covered)
  P18_DCP_L3_h27 = polyline(z=-1.27mm, xy in mm: (-13.2138, -0.8856) (-13.4253, -0.7211) (-13.4741, -0.3747) (-13.3268, -0.1719) (-12.9632, -0.1144) (-12.7028, -0.3747) (-12.7028, -0.6253) (-12.8501, -0.8281) (-13.0885, -0.9055) (-13.2138, -0.8856), closed, covered)
  P18_DCP_L3_h28 = polyline(z=-1.27mm, xy in mm: (-12.0291, -0.8856) (-12.2407, -0.7211) (-12.2895, -0.3747) (-12.1422, -0.1719) (-11.7785, -0.1144) (-11.5182, -0.3747) (-11.5182, -0.6253) (-11.6655, -0.8281) (-11.9038, -0.9055) (-12.0291, -0.8856), closed, covered)
  P18_DCP_L3_h29 = polyline(z=-1.27mm, xy in mm: (-10.8445, -0.8856) (-11.0561, -0.7211) (-11.1049, -0.3747) (-10.9576, -0.1719) (-10.5939, -0.1144) (-10.3912, -0.2617) (-10.3137, -0.5) (-10.4809, -0.8281) (-10.7192, -0.9055) (-10.8445, -0.8856), closed, covered)
  P18_DCP_L3_h30 = polyline(z=-1.27mm, xy in mm: (-9.6599, -0.8856) (-9.9203, -0.6253) (-9.9203, -0.3747) (-9.773, -0.1719) (-9.4093, -0.1144) (-9.2066, -0.2617) (-9.1291, -0.5) (-9.2963, -0.8281) (-9.5346, -0.9055) (-9.6599, -0.8856), closed, covered)
  P18_DCP_L3_h31 = polyline(z=-1.27mm, xy in mm: (-8.4753, -0.8856) (-8.6868, -0.7211) (-8.7356, -0.3747) (-8.5883, -0.1719) (-8.2247, -0.1144) (-8.0219, -0.2617) (-7.9445, -0.5) (-8.0219, -0.7383) (-8.35, -0.9055) (-8.4753, -0.8856), closed, covered)
  P18_DCP_L3_h32 = polyline(z=-1.27mm, xy in mm: (-7.2753, -0.8856) (-7.5356, -0.6253) (-7.5356, -0.3747) (-7.3883, -0.1719) (-7.0247, -0.1144) (-6.8219, -0.2617) (-6.7445, -0.5) (-6.9117, -0.8281) (-7.15, -0.9055) (-7.2753, -0.8856), closed, covered)
  P18_DCP_L3_h33 = polyline(z=-1.27mm, xy in mm: (-6.0753, -0.8856) (-6.3356, -0.6253) (-6.3356, -0.3747) (-6.1883, -0.1719) (-5.8247, -0.1144) (-5.6219, -0.2617) (-5.5445, -0.5) (-5.6219, -0.7383) (-5.95, -0.9055) (-6.0753, -0.8856), closed, covered)
  P18_DCP_L3_h34 = polyline(z=-1.27mm, xy in mm: (-4.8753, -0.8856) (-5.1356, -0.6253) (-5.1356, -0.3747) (-4.9883, -0.1719) (-4.6247, -0.1144) (-4.422, -0.2617) (-4.3445, -0.5) (-4.5117, -0.8281) (-4.75, -0.9055) (-4.8753, -0.8856), closed, covered)
  P18_DCP_L3_h35 = polyline(z=-1.27mm, xy in mm: (-3.6753, -0.8856) (-3.9356, -0.6253) (-3.9356, -0.3747) (-3.7883, -0.1719) (-3.4247, -0.1144) (-3.2219, -0.2617) (-3.1445, -0.5) (-3.2219, -0.7383) (-3.55, -0.9055) (-3.6753, -0.8856), closed, covered)
  P18_DCP_L3_h36 = polyline(z=-1.27mm, xy in mm: (-2.4753, -0.8856) (-2.7356, -0.6253) (-2.7356, -0.3747) (-2.5883, -0.1719) (-2.2247, -0.1144) (-2.0219, -0.2617) (-1.9445, -0.5) (-2.0219, -0.7383) (-2.35, -0.9055) (-2.4753, -0.8856), closed, covered)
  P18_DCP_L3_h37 = polyline(z=-1.27mm, xy in mm: (-1.2753, -0.8856) (-1.5356, -0.6253) (-1.5356, -0.3747) (-1.3883, -0.1719) (-1.0247, -0.1144) (-0.8219, -0.2617) (-0.7445, -0.5) (-0.8219, -0.7383) (-1.15, -0.9055) (-1.2753, -0.8856), closed, covered)
  P18_DCP_L3_h38 = polyline(z=-1.27mm, xy in mm: (-0.0753, -0.8856) (-0.3356, -0.6253) (-0.3356, -0.3747) (-0.1883, -0.1719) (0.1753, -0.1144) (0.3781, -0.2617) (0.4555, -0.5) (0.3781, -0.7383) (0.05, -0.9055) (-0.0753, -0.8856), closed, covered)
  P18_DCP_L3_h39 = polyline(z=-1.27mm, xy in mm: (1.1247, -0.8856) (0.8644, -0.6253) (0.8644, -0.3747) (1.0117, -0.1719) (1.3753, -0.1144) (1.578, -0.2617) (1.6555, -0.5) (1.4883, -0.8281) (1.25, -0.9055) (1.1247, -0.8856), closed, covered)
  P18_DCP_L3_h40 = polyline(z=-1.27mm, xy in mm: (2.3247, -0.8856) (2.0644, -0.6253) (2.0644, -0.3747) (2.2117, -0.1719) (2.5753, -0.1144) (2.7781, -0.2617) (2.8555, -0.5) (2.7781, -0.7383) (2.45, -0.9055) (2.3247, -0.8856), closed, covered)
  P18_DCP_L3_h41 = polyline(z=-1.27mm, xy in mm: (3.5247, -0.8856) (3.2644, -0.6253) (3.2644, -0.3747) (3.4117, -0.1719) (3.7753, -0.1144) (3.978, -0.2617) (4.0555, -0.5) (3.8883, -0.8281) (3.65, -0.9055) (3.5247, -0.8856), closed, covered)
  P18_DCP_L3_h42 = polyline(z=-1.27mm, xy in mm: (4.7247, -0.8856) (4.4644, -0.6253) (4.4644, -0.3747) (4.6117, -0.1719) (4.9753, -0.1144) (5.1781, -0.2617) (5.2555, -0.5) (5.0883, -0.8281) (4.85, -0.9055) (4.7247, -0.8856), closed, covered)
  P18_DCP_L3_h43 = polyline(z=-1.27mm, xy in mm: (5.9247, -0.8856) (5.6644, -0.6253) (5.6644, -0.3747) (5.8117, -0.1719) (6.1753, -0.1144) (6.3781, -0.2617) (6.4555, -0.5) (6.3781, -0.7383) (6.05, -0.9055) (5.9247, -0.8856), closed, covered)
  P18_DCP_L3_h44 = polyline(z=-1.27mm, xy in mm: (8.2247, -0.8856) (8.0132, -0.7211) (7.9644, -0.3747) (8.1117, -0.1719) (8.4753, -0.1144) (8.6781, -0.2617) (8.7555, -0.5) (8.6781, -0.7383) (8.35, -0.9055) (8.2247, -0.8856), closed, covered)
  P18_DCP_L3_h45 = polyline(z=-1.27mm, xy in mm: (9.4093, -0.8856) (9.1978, -0.7211) (9.149, -0.3747) (9.2963, -0.1719) (9.6599, -0.1144) (9.9203, -0.3747) (9.9203, -0.6253) (9.773, -0.8281) (9.5346, -0.9055) (9.4093, -0.8856), closed, covered)
  P18_DCP_L3_h46 = polyline(z=-1.27mm, xy in mm: (10.5939, -0.8856) (10.3824, -0.7211) (10.3336, -0.3747) (10.4809, -0.1719) (10.8445, -0.1144) (11.1049, -0.3747) (11.1049, -0.6253) (10.9576, -0.8281) (10.7192, -0.9055) (10.5939, -0.8856), closed, covered)
  P18_DCP_L3_h47 = polyline(z=-1.27mm, xy in mm: (11.7785, -0.8856) (11.567, -0.7211) (11.5182, -0.3747) (11.6655, -0.1719) (12.0291, -0.1144) (12.2895, -0.3747) (12.2895, -0.6253) (12.1422, -0.8281) (11.9038, -0.9055) (11.7785, -0.8856), closed, covered)
  P18_DCP_L3_h48 = polyline(z=-1.27mm, xy in mm: (12.9632, -0.8856) (12.7516, -0.7211) (12.7028, -0.3747) (12.8501, -0.1719) (13.2138, -0.1144) (13.4165, -0.2617) (13.494, -0.5) (13.3268, -0.8281) (13.0885, -0.9055) (12.9632, -0.8856), closed, covered)
  P18_DCP_L3_h49 = polyline(z=-1.27mm, xy in mm: (14.1478, -0.8856) (13.9362, -0.7211) (13.8874, -0.3747) (14.0347, -0.1719) (14.3984, -0.1144) (14.6011, -0.2617) (14.6786, -0.5) (14.5114, -0.8281) (14.2731, -0.9055) (14.1478, -0.8856), closed, covered)
  P18_DCP_L3_h50 = polyline(z=-1.27mm, xy in mm: (15.3324, -0.8856) (15.072, -0.6253) (15.072, -0.3747) (15.2193, -0.1719) (15.583, -0.1144) (15.7857, -0.2617) (15.8632, -0.5) (15.696, -0.8281) (15.4577, -0.9055) (15.3324, -0.8856), closed, covered)
  P18_DCP_L3_h51 = polyline(z=-1.27mm, xy in mm: (16.517, -0.8856) (16.3055, -0.7211) (16.2567, -0.3747) (16.404, -0.1719) (16.7676, -0.1144) (17.028, -0.3747) (17.028, -0.6253) (16.8806, -0.8281) (16.6423, -0.9055) (16.517, -0.8856), closed, covered)
  P18_DCP_L3_h52 = polyline(z=-1.27mm, xy in mm: (17.7016, -0.8856) (17.4901, -0.7211) (17.4413, -0.3747) (17.5886, -0.1719) (17.9522, -0.1144) (18.2126, -0.3747) (18.2126, -0.6253) (18.0653, -0.8281) (17.8269, -0.9055) (17.7016, -0.8856), closed, covered)
  P18_DCP_L3_h53 = polyline(z=-1.27mm, xy in mm: (18.8862, -0.8856) (18.6747, -0.7211) (18.6259, -0.3747) (18.7732, -0.1719) (19.1368, -0.1144) (19.3972, -0.3747) (19.3972, -0.6253) (19.2499, -0.8281) (19.0115, -0.9055) (18.8862, -0.8856), closed, covered)
  P18_DCP_L3_h54 = polyline(z=-1.27mm, xy in mm: (20.0709, -0.8856) (19.8593, -0.7211) (19.8105, -0.3747) (19.9578, -0.1719) (20.3215, -0.1144) (20.5818, -0.3747) (20.5818, -0.6253) (20.4345, -0.8281) (20.1961, -0.9055) (20.0709, -0.8856), closed, covered)
  P18_DCP_L3_h55 = polyline(z=-1.27mm, xy in mm: (21.2555, -0.8856) (21.0439, -0.7211) (20.9951, -0.3747) (21.1424, -0.1719) (21.5061, -0.1144) (21.7088, -0.2617) (21.7863, -0.5) (21.6191, -0.8281) (21.3808, -0.9055) (21.2555, -0.8856), closed, covered)
  P18_DCP_L3_h56 = polyline(z=-1.27mm, xy in mm: (22.4401, -0.8856) (22.1797, -0.6253) (22.1797, -0.3747) (22.327, -0.1719) (22.6907, -0.1144) (22.8934, -0.2617) (22.9709, -0.5) (22.8037, -0.8281) (22.5654, -0.9055) (22.4401, -0.8856), closed, covered)
  P18_DCP_L3_h57 = polyline(z=-1.27mm, xy in mm: (23.6247, -0.8856) (23.4132, -0.7211) (23.3644, -0.3747) (23.5117, -0.1719) (23.8753, -0.1144) (24.078, -0.2617) (24.1555, -0.5) (23.9883, -0.8281) (23.75, -0.9055) (23.6247, -0.8856), closed, covered)
  P18_DCP_L3_h58 = polyline(z=-1.27mm, xy in mm: (24.8093, -0.8856) (24.5978, -0.7211) (24.549, -0.3747) (24.6963, -0.1719) (25.0599, -0.1144) (25.3203, -0.3747) (25.3203, -0.6253) (25.173, -0.8281) (24.9346, -0.9055) (24.8093, -0.8856), closed, covered)
  P18_DCP_L3_h59 = polyline(z=-1.27mm, xy in mm: (25.9939, -0.8856) (25.7824, -0.7211) (25.7336, -0.3747) (25.8809, -0.1719) (26.2445, -0.1144) (26.5049, -0.3747) (26.5049, -0.6253) (26.3576, -0.8281) (26.1192, -0.9055) (25.9939, -0.8856), closed, covered)
  P18_DCP_L3_h60 = polyline(z=-1.27mm, xy in mm: (27.1785, -0.8856) (26.967, -0.7211) (26.9182, -0.3747) (27.0655, -0.1719) (27.4291, -0.1144) (27.6895, -0.3747) (27.6895, -0.6253) (27.5422, -0.8281) (27.3038, -0.9055) (27.1785, -0.8856), closed, covered)
  P18_DCP_L3_h61 = polyline(z=-1.27mm, xy in mm: (28.3632, -0.8856) (28.1516, -0.7211) (28.1028, -0.3747) (28.2501, -0.1719) (28.6138, -0.1144) (28.8165, -0.2617) (28.894, -0.5) (28.7268, -0.8281) (28.4885, -0.9055) (28.3632, -0.8856), closed, covered)
  P18_DCP_L3_h62 = polyline(z=-1.27mm, xy in mm: (29.5478, -0.8856) (29.3362, -0.7211) (29.2874, -0.3747) (29.4347, -0.1719) (29.7984, -0.1144) (30.0011, -0.2617) (30.0786, -0.5) (29.9114, -0.8281) (29.6731, -0.9055) (29.5478, -0.8856), closed, covered)
  P18_DCP_L3_h63 = polyline(z=-1.27mm, xy in mm: (30.7324, -0.8856) (30.472, -0.6253) (30.472, -0.3747) (30.6193, -0.1719) (30.983, -0.1144) (31.1857, -0.2617) (31.2632, -0.5) (31.096, -0.8281) (30.8577, -0.9055) (30.7324, -0.8856), closed, covered)
  P18_DCP_L3_h64 = polyline(z=-1.27mm, xy in mm: (31.917, -0.8856) (31.7055, -0.7211) (31.6567, -0.3747) (31.804, -0.1719) (32.1676, -0.1144) (32.428, -0.3747) (32.428, -0.6253) (32.2806, -0.8281) (32.0423, -0.9055) (31.917, -0.8856), closed, covered)
  P18_DCP_L3_h65 = polyline(z=-1.27mm, xy in mm: (33.1016, -0.8856) (32.8901, -0.7211) (32.8413, -0.3747) (32.9886, -0.1719) (33.3522, -0.1144) (33.6126, -0.3747) (33.6126, -0.6253) (33.4653, -0.8281) (33.2269, -0.9055) (33.1016, -0.8856), closed, covered)
  P18_DCP_L3_h66 = polyline(z=-1.27mm, xy in mm: (34.2862, -0.8856) (34.0747, -0.7211) (34.0259, -0.3747) (34.1732, -0.1719) (34.5368, -0.1144) (34.7972, -0.3747) (34.7972, -0.6253) (34.6499, -0.8281) (34.4115, -0.9055) (34.2862, -0.8856), closed, covered)
  P18_DCP_L3_h67 = polyline(z=-1.27mm, xy in mm: (35.4709, -0.8856) (35.2593, -0.7211) (35.2105, -0.3747) (35.3578, -0.1719) (35.7215, -0.1144) (35.9818, -0.3747) (35.9818, -0.6253) (35.8345, -0.8281) (35.5961, -0.9055) (35.4709, -0.8856), closed, covered)
  P18_DCP_L3_h68 = polyline(z=-1.27mm, xy in mm: (36.6555, -0.8856) (36.4439, -0.7211) (36.3951, -0.3747) (36.5424, -0.1719) (36.9061, -0.1144) (37.1088, -0.2617) (37.1863, -0.5) (37.0191, -0.8281) (36.7808, -0.9055) (36.6555, -0.8856), closed, covered)
  P18_DCP_L3_h69 = polyline(z=-1.27mm, xy in mm: (37.8401, -0.8856) (37.5797, -0.6253) (37.5797, -0.3747) (37.727, -0.1719) (38.0907, -0.1144) (38.2934, -0.2617) (38.3709, -0.5) (38.2037, -0.8281) (37.9654, -0.9055) (37.8401, -0.8856), closed, covered)
  P18_DCP_L3_h70 = polyline(z=-1.27mm, xy in mm: (-38.0907, -11.1356) (-38.3022, -10.9711) (-38.351, -10.6247) (-38.2037, -10.4219) (-37.8401, -10.3644) (-37.5797, -10.6247) (-37.5797, -10.8753) (-37.727, -11.0781) (-37.9654, -11.1555) (-38.0907, -11.1356), closed, covered)
  P18_DCP_L3_h71 = polyline(z=-1.27mm, xy in mm: (-36.9061, -11.1356) (-37.1176, -10.9711) (-37.1664, -10.6247) (-37.0191, -10.4219) (-36.6555, -10.3644) (-36.3951, -10.6247) (-36.3951, -10.8753) (-36.5424, -11.0781) (-36.7808, -11.1555) (-36.9061, -11.1356), closed, covered)
  P18_DCP_L3_h72 = polyline(z=-1.27mm, xy in mm: (-35.7215, -11.1356) (-35.933, -10.9711) (-35.9818, -10.6247) (-35.8345, -10.4219) (-35.4708, -10.3644) (-35.2105, -10.6247) (-35.2105, -10.8753) (-35.3578, -11.0781) (-35.5962, -11.1555) (-35.7215, -11.1356), closed, covered)
  P18_DCP_L3_h73 = polyline(z=-1.27mm, xy in mm: (-34.5368, -11.1356) (-34.7484, -10.9711) (-34.7972, -10.6247) (-34.6499, -10.4219) (-34.2862, -10.3644) (-34.0835, -10.5117) (-34.006, -10.75) (-34.1732, -11.0781) (-34.4115, -11.1555) (-34.5368, -11.1356), closed, covered)
  P18_DCP_L3_h74 = polyline(z=-1.27mm, xy in mm: (-33.3522, -11.1356) (-33.5638, -10.9711) (-33.6126, -10.6247) (-33.4653, -10.4219) (-33.1016, -10.3644) (-32.8989, -10.5117) (-32.8214, -10.75) (-32.9886, -11.0781) (-33.2269, -11.1555) (-33.3522, -11.1356), closed, covered)
  P18_DCP_L3_h75 = polyline(z=-1.27mm, xy in mm: (-32.1676, -11.1356) (-32.428, -10.8753) (-32.428, -10.6247) (-32.2806, -10.4219) (-31.917, -10.3644) (-31.7143, -10.5117) (-31.6368, -10.75) (-31.804, -11.0781) (-32.0423, -11.1555) (-32.1676, -11.1356), closed, covered)
  P18_DCP_L3_h76 = polyline(z=-1.27mm, xy in mm: (-30.983, -11.1356) (-31.1945, -10.9711) (-31.2433, -10.6247) (-31.096, -10.4219) (-30.7324, -10.3644) (-30.472, -10.6247) (-30.472, -10.8753) (-30.6193, -11.0781) (-30.8577, -11.1555) (-30.983, -11.1356), closed, covered)
  P18_DCP_L3_h77 = polyline(z=-1.27mm, xy in mm: (-29.7984, -11.1356) (-30.0099, -10.9711) (-30.0587, -10.6247) (-29.9114, -10.4219) (-29.5478, -10.3644) (-29.2874, -10.6247) (-29.2874, -10.8753) (-29.4347, -11.0781) (-29.6731, -11.1555) (-29.7984, -11.1356), closed, covered)
  P18_DCP_L3_h78 = polyline(z=-1.27mm, xy in mm: (-28.6138, -11.1356) (-28.8253, -10.9711) (-28.8741, -10.6247) (-28.7268, -10.4219) (-28.3632, -10.3644) (-28.1028, -10.6247) (-28.1028, -10.8753) (-28.2501, -11.0781) (-28.4885, -11.1555) (-28.6138, -11.1356), closed, covered)
  P18_DCP_L3_h79 = polyline(z=-1.27mm, xy in mm: (-27.4291, -11.1356) (-27.6407, -10.9711) (-27.6895, -10.6247) (-27.5422, -10.4219) (-27.1785, -10.3644) (-26.9182, -10.6247) (-26.9182, -10.8753) (-27.0655, -11.0781) (-27.3038, -11.1555) (-27.4291, -11.1356), closed, covered)
  P18_DCP_L3_h80 = polyline(z=-1.27mm, xy in mm: (-26.2445, -11.1356) (-26.4561, -10.9711) (-26.5049, -10.6247) (-26.3576, -10.4219) (-25.9939, -10.3644) (-25.7912, -10.5117) (-25.7137, -10.75) (-25.8809, -11.0781) (-26.1192, -11.1555) (-26.2445, -11.1356), closed, covered)
  P18_DCP_L3_h81 = polyline(z=-1.27mm, xy in mm: (-25.0599, -11.1356) (-25.3203, -10.8753) (-25.3203, -10.6247) (-25.173, -10.4219) (-24.8093, -10.3644) (-24.6066, -10.5117) (-24.5291, -10.75) (-24.6963, -11.0781) (-24.9346, -11.1555) (-25.0599, -11.1356), closed, covered)
  P18_DCP_L3_h82 = polyline(z=-1.27mm, xy in mm: (-23.8753, -11.1356) (-24.0781, -10.9883) (-24.1356, -10.6247) (-23.9883, -10.4219) (-23.6247, -10.3644) (-23.4219, -10.5117) (-23.3445, -10.75) (-23.4219, -10.9883) (-23.75, -11.1555) (-23.8753, -11.1356), closed, covered)
  P18_DCP_L3_h83 = polyline(z=-1.27mm, xy in mm: (-22.6907, -11.1356) (-22.9022, -10.9711) (-22.951, -10.6247) (-22.8037, -10.4219) (-22.4401, -10.3644) (-22.1797, -10.6247) (-22.1797, -10.8753) (-22.327, -11.0781) (-22.5654, -11.1555) (-22.6907, -11.1356), closed, covered)
  P18_DCP_L3_h84 = polyline(z=-1.27mm, xy in mm: (-21.5061, -11.1356) (-21.7176, -10.9711) (-21.7664, -10.6247) (-21.6191, -10.4219) (-21.2555, -10.3644) (-20.9951, -10.6247) (-20.9951, -10.8753) (-21.1424, -11.0781) (-21.3808, -11.1555) (-21.5061, -11.1356), closed, covered)
  P18_DCP_L3_h85 = polyline(z=-1.27mm, xy in mm: (-20.3215, -11.1356) (-20.533, -10.9711) (-20.5818, -10.6247) (-20.4345, -10.4219) (-20.0708, -10.3644) (-19.8105, -10.6247) (-19.8105, -10.8753) (-19.9578, -11.0781) (-20.1962, -11.1555) (-20.3215, -11.1356), closed, covered)
  P18_DCP_L3_h86 = polyline(z=-1.27mm, xy in mm: (-19.1368, -11.1356) (-19.3484, -10.9711) (-19.3972, -10.6247) (-19.2499, -10.4219) (-18.8862, -10.3644) (-18.6835, -10.5117) (-18.606, -10.75) (-18.7732, -11.0781) (-19.0115, -11.1555) (-19.1368, -11.1356), closed, covered)
  P18_DCP_L3_h87 = polyline(z=-1.27mm, xy in mm: (-17.9522, -11.1356) (-18.1638, -10.9711) (-18.2126, -10.6247) (-18.0653, -10.4219) (-17.7016, -10.3644) (-17.4989, -10.5117) (-17.4214, -10.75) (-17.5886, -11.0781) (-17.8269, -11.1555) (-17.9522, -11.1356), closed, covered)
  P18_DCP_L3_h88 = polyline(z=-1.27mm, xy in mm: (-16.7676, -11.1356) (-17.028, -10.8753) (-17.028, -10.6247) (-16.8806, -10.4219) (-16.517, -10.3644) (-16.3143, -10.5117) (-16.2368, -10.75) (-16.404, -11.0781) (-16.6423, -11.1555) (-16.7676, -11.1356), closed, covered)
  P18_DCP_L3_h89 = polyline(z=-1.27mm, xy in mm: (-15.583, -11.1356) (-15.7945, -10.9711) (-15.8433, -10.6247) (-15.696, -10.4219) (-15.3324, -10.3644) (-15.072, -10.6247) (-15.072, -10.8753) (-15.2193, -11.0781) (-15.4577, -11.1555) (-15.583, -11.1356), closed, covered)
  P18_DCP_L3_h90 = polyline(z=-1.27mm, xy in mm: (-14.3984, -11.1356) (-14.6099, -10.9711) (-14.6587, -10.6247) (-14.5114, -10.4219) (-14.1478, -10.3644) (-13.8874, -10.6247) (-13.8874, -10.8753) (-14.0347, -11.0781) (-14.2731, -11.1555) (-14.3984, -11.1356), closed, covered)
  P18_DCP_L3_h91 = polyline(z=-1.27mm, xy in mm: (-13.2138, -11.1356) (-13.4253, -10.9711) (-13.4741, -10.6247) (-13.3268, -10.4219) (-12.9632, -10.3644) (-12.7028, -10.6247) (-12.7028, -10.8753) (-12.8501, -11.0781) (-13.0885, -11.1555) (-13.2138, -11.1356), closed, covered)
  P18_DCP_L3_h92 = polyline(z=-1.27mm, xy in mm: (-12.0291, -11.1356) (-12.2407, -10.9711) (-12.2895, -10.6247) (-12.1422, -10.4219) (-11.7785, -10.3644) (-11.5182, -10.6247) (-11.5182, -10.8753) (-11.6655, -11.0781) (-11.9038, -11.1555) (-12.0291, -11.1356), closed, covered)
  P18_DCP_L3_h93 = polyline(z=-1.27mm, xy in mm: (-10.8445, -11.1356) (-11.0561, -10.9711) (-11.1049, -10.6247) (-10.9576, -10.4219) (-10.5939, -10.3644) (-10.3912, -10.5117) (-10.3137, -10.75) (-10.4809, -11.0781) (-10.7192, -11.1555) (-10.8445, -11.1356), closed, covered)
  P18_DCP_L3_h94 = polyline(z=-1.27mm, xy in mm: (-9.6599, -11.1356) (-9.9203, -10.8753) (-9.9203, -10.6247) (-9.773, -10.4219) (-9.4093, -10.3644) (-9.2066, -10.5117) (-9.1291, -10.75) (-9.2963, -11.0781) (-9.5346, -11.1555) (-9.6599, -11.1356), closed, covered)
  P18_DCP_L3_h95 = polyline(z=-1.27mm, xy in mm: (-8.4753, -11.1356) (-8.6868, -10.9711) (-8.7356, -10.6247) (-8.5883, -10.4219) (-8.2247, -10.3644) (-8.0219, -10.5117) (-7.9445, -10.75) (-8.0219, -10.9883) (-8.35, -11.1555) (-8.4753, -11.1356), closed, covered)
  P18_DCP_L3_h96 = polyline(z=-1.27mm, xy in mm: (-7.2753, -11.1356) (-7.5356, -10.8753) (-7.5356, -10.6247) (-7.3883, -10.4219) (-7.0247, -10.3644) (-6.8219, -10.5117) (-6.7445, -10.75) (-6.8219, -10.9883) (-7.15, -11.1555) (-7.2753, -11.1356), closed, covered)
  P18_DCP_L3_h97 = polyline(z=-1.27mm, xy in mm: (-6.0753, -11.1356) (-6.3356, -10.8753) (-6.3356, -10.6247) (-6.1883, -10.4219) (-5.8247, -10.3644) (-5.6219, -10.5117) (-5.5445, -10.75) (-5.6219, -10.9883) (-5.95, -11.1555) (-6.0753, -11.1356), closed, covered)
  P18_DCP_L3_h98 = polyline(z=-1.27mm, xy in mm: (-4.8753, -11.1356) (-5.1356, -10.8753) (-5.1356, -10.6247) (-4.9883, -10.4219) (-4.6247, -10.3644) (-4.422, -10.5117) (-4.3445, -10.75) (-4.5117, -11.0781) (-4.75, -11.1555) (-4.8753, -11.1356), closed, covered)
  P18_DCP_L3_h99 = polyline(z=-1.27mm, xy in mm: (-3.6753, -11.1356) (-3.9356, -10.8753) (-3.9356, -10.6247) (-3.7883, -10.4219) (-3.4247, -10.3644) (-3.2219, -10.5117) (-3.1445, -10.75) (-3.2219, -10.9883) (-3.55, -11.1555) (-3.6753, -11.1356), closed, covered)
  P18_DCP_L3_h100 = polyline(z=-1.27mm, xy in mm: (-2.4753, -11.1356) (-2.7356, -10.8753) (-2.7356, -10.6247) (-2.5883, -10.4219) (-2.2247, -10.3644) (-2.0219, -10.5117) (-1.9445, -10.75) (-2.0219, -10.9883) (-2.35, -11.1555) (-2.4753, -11.1356), closed, covered)
  P18_DCP_L3_h101 = polyline(z=-1.27mm, xy in mm: (-1.2753, -11.1356) (-1.5356, -10.8753) (-1.5356, -10.6247) (-1.3883, -10.4219) (-1.0247, -10.3644) (-0.8219, -10.5117) (-0.7445, -10.75) (-0.8219, -10.9883) (-1.15, -11.1555) (-1.2753, -11.1356), closed, covered)
  P18_DCP_L3_h102 = polyline(z=-1.27mm, xy in mm: (-0.0753, -11.1356) (-0.3356, -10.8753) (-0.3356, -10.6247) (-0.1883, -10.4219) (0.1753, -10.3644) (0.3781, -10.5117) (0.4555, -10.75) (0.3781, -10.9883) (0.05, -11.1555) (-0.0753, -11.1356), closed, covered)
  P18_DCP_L3_h103 = polyline(z=-1.27mm, xy in mm: (1.1247, -11.1356) (0.8644, -10.8753) (0.8644, -10.6247) (1.0117, -10.4219) (1.3753, -10.3644) (1.578, -10.5117) (1.6555, -10.75) (1.4883, -11.0781) (1.25, -11.1555) (1.1247, -11.1356), closed, covered)
  P18_DCP_L3_h104 = polyline(z=-1.27mm, xy in mm: (2.3247, -11.1356) (2.0644, -10.8753) (2.0644, -10.6247) (2.2117, -10.4219) (2.5753, -10.3644) (2.7781, -10.5117) (2.8555, -10.75) (2.7781, -10.9883) (2.45, -11.1555) (2.3247, -11.1356), closed, covered)
  P18_DCP_L3_h105 = polyline(z=-1.27mm, xy in mm: (3.5247, -11.1356) (3.2644, -10.8753) (3.2644, -10.6247) (3.4117, -10.4219) (3.7753, -10.3644) (3.978, -10.5117) (4.0555, -10.75) (3.8883, -11.0781) (3.65, -11.1555) (3.5247, -11.1356), closed, covered)
  P18_DCP_L3_h106 = polyline(z=-1.27mm, xy in mm: (4.7247, -11.1356) (4.4644, -10.8753) (4.4644, -10.6247) (4.6117, -10.4219) (4.9753, -10.3644) (5.1781, -10.5117) (5.2555, -10.75) (5.1781, -10.9883) (4.85, -11.1555) (4.7247, -11.1356), closed, covered)
  P18_DCP_L3_h107 = polyline(z=-1.27mm, xy in mm: (5.9247, -11.1356) (5.6644, -10.8753) (5.6644, -10.6247) (5.8117, -10.4219) (6.1753, -10.3644) (6.3781, -10.5117) (6.4555, -10.75) (6.3781, -10.9883) (6.05, -11.1555) (5.9247, -11.1356), closed, covered)
  P18_DCP_L3_h108 = polyline(z=-1.27mm, xy in mm: (8.2247, -11.1356) (8.0132, -10.9711) (7.9644, -10.6247) (8.1117, -10.4219) (8.4753, -10.3644) (8.6781, -10.5117) (8.7555, -10.75) (8.6781, -10.9883) (8.35, -11.1555) (8.2247, -11.1356), closed, covered)
  P18_DCP_L3_h109 = polyline(z=-1.27mm, xy in mm: (9.4093, -11.1356) (9.1978, -10.9711) (9.149, -10.6247) (9.2963, -10.4219) (9.6599, -10.3644) (9.9203, -10.6247) (9.9203, -10.8753) (9.773, -11.0781) (9.5346, -11.1555) (9.4093, -11.1356), closed, covered)
  P18_DCP_L3_h110 = polyline(z=-1.27mm, xy in mm: (10.5939, -11.1356) (10.3824, -10.9711) (10.3336, -10.6247) (10.4809, -10.4219) (10.8445, -10.3644) (11.1049, -10.6247) (11.1049, -10.8753) (10.9576, -11.0781) (10.7192, -11.1555) (10.5939, -11.1356), closed, covered)
  P18_DCP_L3_h111 = polyline(z=-1.27mm, xy in mm: (11.7785, -11.1356) (11.567, -10.9711) (11.5182, -10.6247) (11.6655, -10.4219) (12.0291, -10.3644) (12.2895, -10.6247) (12.2895, -10.8753) (12.1422, -11.0781) (11.9038, -11.1555) (11.7785, -11.1356), closed, covered)
  P18_DCP_L3_h112 = polyline(z=-1.27mm, xy in mm: (12.9632, -11.1356) (12.7516, -10.9711) (12.7028, -10.6247) (12.8501, -10.4219) (13.2138, -10.3644) (13.4165, -10.5117) (13.494, -10.75) (13.3268, -11.0781) (13.0885, -11.1555) (12.9632, -11.1356), closed, covered)
  P18_DCP_L3_h113 = polyline(z=-1.27mm, xy in mm: (14.1478, -11.1356) (13.9362, -10.9711) (13.8874, -10.6247) (14.0347, -10.4219) (14.3984, -10.3644) (14.6011, -10.5117) (14.6786, -10.75) (14.5114, -11.0781) (14.2731, -11.1555) (14.1478, -11.1356), closed, covered)
  P18_DCP_L3_h114 = polyline(z=-1.27mm, xy in mm: (15.3324, -11.1356) (15.072, -10.8753) (15.072, -10.6247) (15.2193, -10.4219) (15.583, -10.3644) (15.7857, -10.5117) (15.8632, -10.75) (15.696, -11.0781) (15.4577, -11.1555) (15.3324, -11.1356), closed, covered)
  P18_DCP_L3_h115 = polyline(z=-1.27mm, xy in mm: (16.517, -11.1356) (16.3055, -10.9711) (16.2567, -10.6247) (16.404, -10.4219) (16.7676, -10.3644) (17.028, -10.6247) (17.028, -10.8753) (16.8806, -11.0781) (16.6423, -11.1555) (16.517, -11.1356), closed, covered)
  P18_DCP_L3_h116 = polyline(z=-1.27mm, xy in mm: (17.7016, -11.1356) (17.4901, -10.9711) (17.4413, -10.6247) (17.5886, -10.4219) (17.9522, -10.3644) (18.2126, -10.6247) (18.2126, -10.8753) (18.0653, -11.0781) (17.8269, -11.1555) (17.7016, -11.1356), closed, covered)
  P18_DCP_L3_h117 = polyline(z=-1.27mm, xy in mm: (18.8862, -11.1356) (18.6747, -10.9711) (18.6259, -10.6247) (18.7732, -10.4219) (19.1368, -10.3644) (19.3972, -10.6247) (19.3972, -10.8753) (19.2499, -11.0781) (19.0115, -11.1555) (18.8862, -11.1356), closed, covered)
  P18_DCP_L3_h118 = polyline(z=-1.27mm, xy in mm: (20.0709, -11.1356) (19.8593, -10.9711) (19.8105, -10.6247) (19.9578, -10.4219) (20.3215, -10.3644) (20.5818, -10.6247) (20.5818, -10.8753) (20.4345, -11.0781) (20.1961, -11.1555) (20.0709, -11.1356), closed, covered)
  P18_DCP_L3_h119 = polyline(z=-1.27mm, xy in mm: (21.2555, -11.1356) (21.0439, -10.9711) (20.9951, -10.6247) (21.1424, -10.4219) (21.5061, -10.3644) (21.7088, -10.5117) (21.7863, -10.75) (21.6191, -11.0781) (21.3808, -11.1555) (21.2555, -11.1356), closed, covered)
  P18_DCP_L3_h120 = polyline(z=-1.27mm, xy in mm: (22.4401, -11.1356) (22.1797, -10.8753) (22.1797, -10.6247) (22.327, -10.4219) (22.6907, -10.3644) (22.8934, -10.5117) (22.9709, -10.75) (22.8037, -11.0781) (22.5654, -11.1555) (22.4401, -11.1356), closed, covered)
  P18_DCP_L3_h121 = polyline(z=-1.27mm, xy in mm: (23.6247, -11.1356) (23.4132, -10.9711) (23.3644, -10.6247) (23.5117, -10.4219) (23.8753, -10.3644) (24.078, -10.5117) (24.1555, -10.75) (23.9883, -11.0781) (23.75, -11.1555) (23.6247, -11.1356), closed, covered)
  P18_DCP_L3_h122 = polyline(z=-1.27mm, xy in mm: (24.8093, -11.1356) (24.5978, -10.9711) (24.549, -10.6247) (24.6963, -10.4219) (25.0599, -10.3644) (25.3203, -10.6247) (25.3203, -10.8753) (25.173, -11.0781) (24.9346, -11.1555) (24.8093, -11.1356), closed, covered)
  P18_DCP_L3_h123 = polyline(z=-1.27mm, xy in mm: (25.9939, -11.1356) (25.7824, -10.9711) (25.7336, -10.6247) (25.8809, -10.4219) (26.2445, -10.3644) (26.5049, -10.6247) (26.5049, -10.8753) (26.3576, -11.0781) (26.1192, -11.1555) (25.9939, -11.1356), closed, covered)
  P18_DCP_L3_h124 = polyline(z=-1.27mm, xy in mm: (27.1785, -11.1356) (26.967, -10.9711) (26.9182, -10.6247) (27.0655, -10.4219) (27.4291, -10.3644) (27.6895, -10.6247) (27.6895, -10.8753) (27.5422, -11.0781) (27.3038, -11.1555) (27.1785, -11.1356), closed, covered)
  P18_DCP_L3_h125 = polyline(z=-1.27mm, xy in mm: (28.3632, -11.1356) (28.1516, -10.9711) (28.1028, -10.6247) (28.2501, -10.4219) (28.6138, -10.3644) (28.8165, -10.5117) (28.894, -10.75) (28.7268, -11.0781) (28.4885, -11.1555) (28.3632, -11.1356), closed, covered)
  P18_DCP_L3_h126 = polyline(z=-1.27mm, xy in mm: (29.5478, -11.1356) (29.3362, -10.9711) (29.2874, -10.6247) (29.4347, -10.4219) (29.7984, -10.3644) (30.0011, -10.5117) (30.0786, -10.75) (29.9114, -11.0781) (29.6731, -11.1555) (29.5478, -11.1356), closed, covered)
  P18_DCP_L3_h127 = polyline(z=-1.27mm, xy in mm: (30.7324, -11.1356) (30.472, -10.8753) (30.472, -10.6247) (30.6193, -10.4219) (30.983, -10.3644) (31.1857, -10.5117) (31.2632, -10.75) (31.096, -11.0781) (30.8577, -11.1555) (30.7324, -11.1356), closed, covered)
  P18_DCP_L3_h128 = polyline(z=-1.27mm, xy in mm: (31.917, -11.1356) (31.7055, -10.9711) (31.6567, -10.6247) (31.804, -10.4219) (32.1676, -10.3644) (32.428, -10.6247) (32.428, -10.8753) (32.2806, -11.0781) (32.0423, -11.1555) (31.917, -11.1356), closed, covered)
  P18_DCP_L3_h129 = polyline(z=-1.27mm, xy in mm: (33.1016, -11.1356) (32.8901, -10.9711) (32.8413, -10.6247) (32.9886, -10.4219) (33.3522, -10.3644) (33.6126, -10.6247) (33.6126, -10.8753) (33.4653, -11.0781) (33.2269, -11.1555) (33.1016, -11.1356), closed, covered)
  P18_DCP_L3_h130 = polyline(z=-1.27mm, xy in mm: (34.2862, -11.1356) (34.0747, -10.9711) (34.0259, -10.6247) (34.1732, -10.4219) (34.5368, -10.3644) (34.7972, -10.6247) (34.7972, -10.8753) (34.6499, -11.0781) (34.4115, -11.1555) (34.2862, -11.1356), closed, covered)
  P18_DCP_L3_h131 = polyline(z=-1.27mm, xy in mm: (35.4709, -11.1356) (35.2593, -10.9711) (35.2105, -10.6247) (35.3578, -10.4219) (35.7215, -10.3644) (35.9818, -10.6247) (35.9818, -10.8753) (35.8345, -11.0781) (35.5961, -11.1555) (35.4709, -11.1356), closed, covered)
  P18_DCP_L3_h132 = polyline(z=-1.27mm, xy in mm: (36.6555, -11.1356) (36.4439, -10.9711) (36.3951, -10.6247) (36.5424, -10.4219) (36.9061, -10.3644) (37.1088, -10.5117) (37.1863, -10.75) (37.0191, -11.0781) (36.7808, -11.1555) (36.6555, -11.1356), closed, covered)
  P18_DCP_L3_h133 = polyline(z=-1.27mm, xy in mm: (37.8401, -11.1356) (37.5797, -10.8753) (37.5797, -10.6247) (37.727, -10.4219) (38.0907, -10.3644) (38.2934, -10.5117) (38.3709, -10.75) (38.2037, -11.0781) (37.9654, -11.1555) (37.8401, -11.1356), closed, covered)
  P18_DCP_L3_h134 = polyline(z=-1.27mm, xy in mm: (2.6632, -17.6253) (2.1622, -17.4287) (1.5732, -16.8821) (1.2796, -16.1341) (1.2796, -15.5959) (1.5732, -14.8479) (2.1622, -14.3013) (2.6632, -14.1047) (3.4668, -14.1047) (3.9678, -14.3013) (4.5568, -14.8479) (4.8504, -15.5959) (4.8504, -16.1341) (4.5568, -16.8821) (4.1907, -17.2766) (3.4668, -17.6253) (2.9301, -17.6655) (2.6632, -17.6253), closed, covered)
  P18_DCP_L3_h135 = polyline(z=-1.27mm, xy in mm: (8.5332, -17.6253) (8.0322, -17.4287) (7.4432, -16.8821) (7.1496, -16.1341) (7.1496, -15.5959) (7.4432, -14.8479) (8.0322, -14.3013) (8.5332, -14.1047) (9.3368, -14.1047) (9.8378, -14.3013) (10.4268, -14.8479) (10.7204, -15.5959) (10.7204, -16.1341) (10.4268, -16.8821) (10.0607, -17.2766) (9.3368, -17.6253) (8.8001, -17.6655) (8.5332, -17.6253), closed, covered)
  P18_DCP_L3_h136 = polyline(z=-1.27mm, xy in mm: (12.2975, -19.863) (11.7832, -19.5446) (11.5694, -19.1993) (11.4948, -18.8) (11.5694, -18.4007) (11.7832, -18.0554) (12.1074, -17.8107) (12.498, -17.6995) (12.9025, -17.737) (13.266, -17.918) (13.5397, -18.2182) (13.6864, -18.5969) (13.6864, -19.0031) (13.5397, -19.3818) (13.266, -19.682) (12.9025, -19.863) (12.498, -19.9005) (12.2975, -19.863), closed, covered)
  P18_DCP_L3.subtract(P18_DCP_L3_h0..P18_DCP_L3_h136)
  P18_DCP_L3.sweep_along_vector((0mm, 0mm, 0.07mm))
  P19_DCP_L4 = polyline(z=-1.44mm, xy in mm: (-28.4908, 1.4689) (-28.45, 3.201) (-28.5184, 3.2952) (-29.5953, 3.3) (-29.8268, 3.0565) (-30.08, 2.9742) (-30.3332, 3.0565) (-30.5647, 3.3) (-37.951, 3.3) (-38.0452, 3.2316) (-38.05, 1.549) (-37.9816, 1.4548) (-28.549, 1.45) (-28.4908, 1.4689), closed, covered)
  P19_DCP_L4.sweep_along_vector((0mm, 0mm, 0.07mm))
  P20_DCP_L4 = polyline(z=-1.44mm, xy in mm: (-11.8361, 1.4689) (-11.8843, 2.6203) (-12.3943, 2.7352) (-12.7843, 3.1043) (-12.8973, 3.0768) (-13.0898, 2.8395) (-13.3978, 2.7009) (-14.0522, 2.7009) (-14.5345, 2.9871) (-15.0478, 2.7009) (-15.6316, 2.6945) (-16.0102, 2.8395) (-16.3508, 3.3) (-17.0013, 3.3) (-17.4653, 2.9712) (-17.85, 2.8947) (-18.2347, 2.9712) (-18.6737, 3.2968) (-18.951, 3.3) (-19.0452, 3.2316) (-19.05, 1.549) (-18.9816, 1.4548) (-11.8943, 1.45) (-11.8361, 1.4689), closed, covered)
  P20_DCP_L4.sweep_along_vector((0mm, 0mm, 0.07mm))
  P21_DCP_L4 = polyline(z=-1.44mm, xy in mm: (19.0092, 1.4689) (19.05, 3.201) (18.9816, 3.2952) (17.9047, 3.3) (17.6732, 3.0565) (17.42, 2.9742) (17.1668, 3.0565) (16.9353, 3.3) (9.549, 3.3) (9.4548, 3.2316) (9.45, 1.549) (9.5184, 1.4548) (18.951, 1.45) (19.0092, 1.4689), closed, covered)
  P21_DCP_L4.sweep_along_vector((0mm, 0mm, 0.07mm))
  P22_DCP_L4 = polyline(z=-1.44mm, xy in mm: (35.6639, 1.4689) (35.6157, 2.6203) (35.1057, 2.7352) (34.7157, 3.1043) (34.6027, 3.0768) (34.4102, 2.8395) (34.1022, 2.7009) (33.4478, 2.7009) (32.9655, 2.9871) (32.4522, 2.7009) (31.8684, 2.6945) (31.4898, 2.8395) (31.1492, 3.3) (30.4987, 3.3) (30.0347, 2.9712) (29.65, 2.8947) (29.2653, 2.9712) (28.8263, 3.2968) (28.549, 3.3) (28.4548, 3.2316) (28.45, 1.549) (28.5184, 1.4548) (35.6057, 1.45) (35.6639, 1.4689), closed, covered)
  P22_DCP_L4.sweep_along_vector((0mm, 0mm, 0.07mm))
  P23_DCP_L4 = polyline(z=-1.44mm, xy in mm: (-1.7908, -23.0311) (-1.7689, -14.5908) (-10.2092, -14.5689) (-10.25, -21.0487) (-12.667, -20.0364) (-12.7636, -20.267) (-10.25, -21.3198) (-10.2311, -23.0092) (-1.849, -23.05) (-1.7908, -23.0311), closed, covered)
  P23_DCP_L4.sweep_along_vector((0mm, 0mm, 0.07mm))
  P24_LSRC1_L1 [copper] = polyline(z=0.17mm, xy in mm: (-36.3943, 9.5189) (-36.3505, 10.9623) (-36.1153, 11.1975) (-35.1146, 11.2005) (-34.9004, 11.0685) (-34.8505, 9.599) (-34.7515, 9.5) (-34.2995, 9.5) (-34.2053, 9.5684) (-34.2005, 10.9612) (-34.1264, 11.1264) (-33.9611, 11.2005) (-33.3114, 11.1851) (-33.1495, 10.9611) (-33.1306, 9.5408) (-32.5995, 9.5) (-32.5005, 9.599) (-32.5005, 10.9612) (-32.4264, 11.1264) (-32.2611, 11.2005) (-30.4106, 11.2005) (-30.2785, 11.1506) (-30.0687, 10.8591) (-29.6565, 10.9405) (-28.8335, 10.8877) (-28.7512, 10.97) (-28.75, 11.2) (-28.65, 11.299) (-28.6689, 12.3592) (-43.6092, 12.3811) (-43.65, 11.299) (-43.5816, 11.2048) (-37.75, 11.2) (-37.7311, 9.5408) (-36.4525, 9.5) (-36.3943, 9.5189), closed, covered)
  P24_LSRC1_L1.sweep_along_vector((0mm, 0mm, 0.07mm))
  P25_LSRC1_L4 = polyline(z=-1.44mm, xy in mm: (-37.025, 11.875) (-34.675, 11.875) (-34.675, 12.125) (-37.025, 12.125) (-37.025, 18.87) (-38.55, 18.87) (-38.55, 18.47) (-37.425, 18.47) (-37.425, 15.49) (-38.55, 15.49) (-38.55, 15.09) (-37.425, 15.09) (-37.425, 11.6) (-37.025, 11.6) (-37.025, 11.875), closed, covered)
  P25_LSRC1_L4.sweep_along_vector((0mm, 0mm, 0.07mm))
  P26_LSRC2_L1 [copper] = polyline(z=0.17mm, xy in mm: (-14.3913, 9.5189) (-14.3505, 10.9612) (-14.1886, 11.1851) (-13.5389, 11.2005) (-13.3149, 11.0386) (-13.2995, 9.599) (-13.2311, 9.5048) (-12.7485, 9.5) (-12.6543, 9.5684) (-12.6495, 10.9364) (-12.5175, 11.1506) (-11.4106, 11.2005) (-11.2785, 11.1506) (-11.1495, 10.9623) (-11.1276, 9.5408) (-9.849, 9.5) (-9.75, 9.599) (-9.75, 11.2) (-3.949, 11.2) (-3.85, 11.299) (-3.85, 12.301) (-3.949, 12.4) (-18.751, 12.4) (-18.85, 12.301) (-18.85, 11.299) (-18.75, 11.2) (-18.6816, 10.8553) (-17.879, 10.8505) (-17.5531, 11.1047) (-17.0894, 11.2005) (-15.1614, 11.1851) (-14.9995, 10.9611) (-14.9806, 9.5408) (-14.4495, 9.5) (-14.3913, 9.5189), closed, covered)
  P26_LSRC2_L1.sweep_along_vector((0mm, 0mm, 0.07mm))
  P27_LSRC2_L4 = polyline(z=-1.44mm, xy in mm: (-10.075, 13.225) (-10.075, 15.09) (-8.95, 15.09) (-8.95, 15.49) (-10.075, 15.49) (-10.075, 18.47) (-8.95, 18.47) (-8.95, 18.87) (-10.475, 18.87) (-10.475, 11.6) (-10.075, 11.6) (-10.075, 13.225), closed, covered)
  P27_LSRC2_L4.sweep_along_vector((0mm, 0mm, 0.07mm))
  P28_LSRC3_L1 [copper] = polyline(z=0.17mm, xy in mm: (11.1057, 9.5189) (11.1495, 10.9623) (11.3847, 11.1975) (12.3854, 11.2005) (12.5996, 11.0685) (12.6495, 9.599) (12.7485, 9.5) (13.2005, 9.5) (13.2947, 9.5684) (13.2995, 10.9612) (13.3736, 11.1264) (13.5389, 11.2005) (14.1886, 11.1851) (14.3505, 10.9611) (14.3694, 9.5408) (14.9005, 9.5) (14.9995, 9.599) (14.9995, 10.9612) (15.0736, 11.1264) (15.2389, 11.2005) (17.0894, 11.2005) (17.2215, 11.1506) (17.4313, 10.8591) (17.8435, 10.9405) (18.6665, 10.8877) (18.7488, 10.97) (18.75, 11.2) (18.85, 11.299) (18.8311, 12.3592) (3.8908, 12.3811) (3.85, 11.299) (3.9184, 11.2048) (9.75, 11.2) (9.7689, 9.5408) (11.0475, 9.5) (11.1057, 9.5189), closed, covered)
  P28_LSRC3_L1.sweep_along_vector((0mm, 0mm, 0.07mm))
  P29_LSRC3_L4 = polyline(z=-1.44mm, xy in mm: (10.475, 11.875) (12.825, 11.875) (12.825, 12.125) (10.475, 12.125) (10.475, 18.87) (8.95, 18.87) (8.95, 18.47) (10.075, 18.47) (10.075, 15.49) (8.95, 15.49) (8.95, 15.09) (10.075, 15.09) (10.075, 11.6) (10.475, 11.6) (10.475, 11.875), closed, covered)
  P29_LSRC3_L4.sweep_along_vector((0mm, 0mm, 0.07mm))
  P30_LSRC4_L1 [copper] = polyline(z=0.17mm, xy in mm: (33.1087, 9.5189) (33.1495, 10.9612) (33.3114, 11.1851) (33.9611, 11.2005) (34.1851, 11.0386) (34.2005, 9.599) (34.2689, 9.5048) (34.7515, 9.5) (34.8457, 9.5684) (34.8505, 10.9364) (34.9825, 11.1506) (36.0894, 11.2005) (36.2215, 11.1506) (36.3505, 10.9623) (36.3724, 9.5408) (37.651, 9.5) (37.75, 9.599) (37.75, 11.2) (43.551, 11.2) (43.65, 11.299) (43.65, 12.301) (43.551, 12.4) (28.749, 12.4) (28.65, 12.301) (28.65, 11.299) (28.75, 11.2) (28.8184, 10.8553) (29.621, 10.8505) (29.9469, 11.1047) (30.4106, 11.2005) (32.3386, 11.1851) (32.5005, 10.9611) (32.5194, 9.5408) (33.0505, 9.5) (33.1087, 9.5189), closed, covered)
  P30_LSRC4_L1.sweep_along_vector((0mm, 0mm, 0.07mm))
  P31_LSRC4_L4 = polyline(z=-1.44mm, xy in mm: (37.425, 13.225) (37.425, 15.09) (38.55, 15.09) (38.55, 15.49) (37.425, 15.49) (37.425, 18.47) (38.55, 18.47) (38.55, 18.87) (37.025, 18.87) (37.025, 11.6) (37.425, 11.6) (37.425, 13.225), closed, covered)
  P31_LSRC4_L4.sweep_along_vector((0mm, 0mm, 0.07mm))
  P32_AC_L1 [copper] = polyline(z=0.17mm, xy in mm: (-40.3908, 20.8189) (-40.35, 44.5) (-29.444, 44.5005) (-7.15, 44.5) (-7.15, 20.899) (-7.051, 20.8) (-3.949, 20.8) (-3.85, 20.899) (-3.85, 44.5) (3.85, 44.5) (3.85, 20.899) (3.949, 20.8) (7.051, 20.8) (7.15, 20.899) (7.15, 38.5097) (6.7694, 39.0507) (6.6948, 39.45) (6.7694, 39.8493) (7.15, 40.3903) (7.15, 44.5) (40.35, 44.5) (40.35, 20.899) (40.449, 20.8) (43.6092, 20.8189) (43.65, 44.5) (43.9092, 44.5189) (43.95, 44.599) (43.9311, 57.655) (43.7709, 57.655) (43.2937, 57.1012) (42.6011, 56.8143) (41.8539, 56.8731) (41.2148, 57.2648) (40.8231, 57.9039) (40.7643, 58.6511) (41.0512, 59.3437) (41.6382, 59.8631) (41.5468, 60) (-41.605, 59.9811) (-41.605, 59.8209) (-41.0512, 59.3437) (-40.7643, 58.6511) (-40.8231, 57.9039) (-41.2148, 57.2648) (-41.8539, 56.8731) (-42.6011, 56.8143) (-43.2937, 57.1012) (-43.8131, 57.6882) (-43.9497, 57.6045) (-43.95, 44.599) (-43.8816, 44.5048) (-43.65, 44.5) (-43.65, 20.899) (-43.551, 20.8) (-40.449, 20.8) (-40.3908, 20.8189), closed, covered)
  P32_AC_L1.sweep_along_vector((0mm, 0mm, 0.07mm))
  P33_AC_L1 = polyline(z=0.17mm, xy in mm: (-36.3943, 5.2189) (-36.3505, 6.6623) (-36.1153, 6.8975) (-35.1146, 6.9005) (-34.9004, 6.7685) (-34.8505, 5.299) (-34.7515, 5.2) (-34.2995, 5.2) (-34.2053, 5.2684) (-34.2005, 6.6612) (-34.1264, 6.8264) (-33.9611, 6.9005) (-33.3114, 6.8851) (-33.1495, 6.6611) (-33.1306, 5.2408) (-32.5995, 5.2) (-32.5005, 5.299) (-32.5005, 6.6612) (-32.3386, 6.8851) (-30.4106, 6.9005) (-30.2785, 6.8506) (-30.0687, 6.5591) (-29.6565, 6.6405) (-28.8335, 6.5877) (-28.75, 6.6854) (-28.7689, 7.5087) (-29.621, 7.5495) (-29.9469, 7.2953) (-30.3847, 7.2025) (-31.4113, 7.2025) (-31.6465, 7.4377) (-31.6684, 8.8592) (-32.2005, 8.9) (-32.2995, 8.801) (-32.3149, 7.3614) (-32.5389, 7.1995) (-33.1886, 7.2149) (-33.3505, 7.4389) (-33.3694, 8.8592) (-33.9005, 8.9) (-33.9995, 8.801) (-34.0149, 7.3614) (-34.2389, 7.1995) (-34.8886, 7.2149) (-35.0505, 7.4389) (-35.0505, 8.801) (-35.1189, 8.8952) (-38.05, 8.9) (-38.05, 10.501) (-38.1184, 10.5952) (-43.6092, 10.5811) (-43.6311, 5.6408) (-37.75, 5.6) (-37.75, 5.299) (-37.6816, 5.2048) (-36.4525, 5.2) (-36.3943, 5.2189), closed, covered)
  P33_AC_L1.sweep_along_vector((0mm, 0mm, 0.07mm))
  P34_AC_L1 = polyline(z=0.17mm, xy in mm: (-14.3913, 5.2189) (-14.3505, 6.6612) (-14.2764, 6.8264) (-14.1111, 6.9005) (-13.4614, 6.8851) (-13.3149, 6.7386) (-13.2995, 5.299) (-13.2005, 5.2) (-12.7485, 5.2) (-12.6543, 5.2684) (-12.6465, 6.6623) (-12.5175, 6.8506) (-12.3854, 6.9005) (-11.4106, 6.9005) (-11.1964, 6.7685) (-11.1465, 5.299) (-11.0475, 5.2) (-9.849, 5.2) (-9.7548, 5.2684) (-9.75, 5.6) (-3.8908, 5.6189) (-3.8689, 10.5592) (-9.4092, 10.5811) (-9.45, 8.9) (-12.4087, 8.8811) (-12.4495, 7.4388) (-12.5236, 7.2736) (-12.6889, 7.1995) (-13.3386, 7.2149) (-13.4851, 7.3614) (-13.5005, 8.801) (-13.5995, 8.9) (-14.0505, 8.9) (-14.1447, 8.8316) (-14.1495, 7.4388) (-14.2236, 7.2736) (-14.3889, 7.1995) (-15.0386, 7.2149) (-15.2005, 7.4389) (-15.2194, 8.8592) (-15.8097, 8.8811) (-15.9029, 8.6191) (-15.8505, 7.4636) (-15.9825, 7.2494) (-17.0894, 7.1995) (-17.3427, 7.3439) (-17.7478, 7.1659) (-18.6827, 7.1868) (-18.75, 7.093) (-18.7311, 6.5913) (-17.879, 6.5505) (-17.5531, 6.8047) (-17.0894, 6.9005) (-15.1614, 6.8851) (-14.9995, 6.6611) (-14.9806, 5.2408) (-14.4495, 5.2) (-14.3913, 5.2189), closed, covered)
  P34_AC_L1.sweep_along_vector((0mm, 0mm, 0.07mm))
  P35_AC_L1 = polyline(z=0.17mm, xy in mm: (11.1057, 5.2189) (11.1495, 6.6623) (11.3847, 6.8975) (12.3854, 6.9005) (12.5996, 6.7685) (12.6495, 5.299) (12.7485, 5.2) (13.2005, 5.2) (13.2947, 5.2684) (13.2995, 6.6612) (13.3736, 6.8264) (13.5389, 6.9005) (14.1886, 6.8851) (14.3505, 6.6611) (14.3694, 5.2408) (14.9005, 5.2) (14.9995, 5.299) (14.9995, 6.6612) (15.1614, 6.8851) (17.0894, 6.9005) (17.2215, 6.8506) (17.4313, 6.5591) (17.8435, 6.6405) (18.6665, 6.5877) (18.75, 6.6854) (18.7311, 7.5087) (17.879, 7.5495) (17.5531, 7.2953) (17.1153, 7.2025) (16.0887, 7.2025) (15.8535, 7.4377) (15.8316, 8.8592) (15.2995, 8.9) (15.2005, 8.801) (15.1851, 7.3614) (14.9611, 7.1995) (14.3114, 7.2149) (14.1495, 7.4389) (14.1306, 8.8592) (13.5995, 8.9) (13.5005, 8.801) (13.4851, 7.3614) (13.2611, 7.1995) (12.6114, 7.2149) (12.4495, 7.4389) (12.4495, 8.801) (12.3811, 8.8952) (9.45, 8.9) (9.45, 10.501) (9.3816, 10.5952) (3.8908, 10.5811) (3.8689, 5.6408) (9.75, 5.6) (9.75, 5.299) (9.8184, 5.2048) (11.0475, 5.2) (11.1057, 5.2189), closed, covered)
  P35_AC_L1.sweep_along_vector((0mm, 0mm, 0.07mm))
  P36_AC_L1 = polyline(z=0.17mm, xy in mm: (33.1087, 5.2189) (33.1495, 6.6612) (33.2236, 6.8264) (33.3889, 6.9005) (34.0386, 6.8851) (34.1851, 6.7386) (34.2005, 5.299) (34.2995, 5.2) (34.7515, 5.2) (34.8457, 5.2684) (34.8535, 6.6623) (34.9825, 6.8506) (35.1146, 6.9005) (36.0894, 6.9005) (36.3036, 6.7685) (36.3535, 5.299) (36.4525, 5.2) (37.651, 5.2) (37.7452, 5.2684) (37.75, 5.6) (43.6092, 5.6189) (43.6311, 10.5592) (38.0908, 10.5811) (38.05, 8.9) (35.0913, 8.8811) (35.0505, 7.4388) (34.9764, 7.2736) (34.8111, 7.1995) (34.1614, 7.2149) (34.0149, 7.3614) (33.9995, 8.801) (33.9005, 8.9) (33.4495, 8.9) (33.3553, 8.8316) (33.3505, 7.4388) (33.2764, 7.2736) (33.1111, 7.1995) (32.4614, 7.2149) (32.2995, 7.4389) (32.2806, 8.8592) (31.6903, 8.8811) (31.5971, 8.6191) (31.6495, 7.4636) (31.5175, 7.2494) (30.4106, 7.1995) (30.1573, 7.3439) (29.7522, 7.1659) (28.8173, 7.1868) (28.75, 7.093) (28.7689, 6.5913) (29.621, 6.5505) (29.9469, 6.8047) (30.4106, 6.9005) (32.3386, 6.8851) (32.5005, 6.6611) (32.5194, 5.2408) (33.0505, 5.2) (33.1087, 5.2189), closed, covered)
  P36_AC_L1.sweep_along_vector((0mm, 0mm, 0.07mm))
  P37_AC_L2 = polyline(z=0mm, xy in mm: (-40.4125, 20.8197) (-40.3555, 20.924) (-40.35, 44.5) (-7.15, 44.5) (-7.1445, 20.924) (-7.0205, 20.8) (-3.974, 20.8) (-3.85, 20.924) (-3.85, 44.5) (3.85, 44.5) (3.85, 20.9295) (3.974, 20.8055) (7.0205, 20.8055) (7.1445, 20.9295) (7.1445, 38.5037) (6.7694, 39.0507) (6.6948, 39.45) (6.7694, 39.8493) (7.15, 40.4014) (7.15, 44.5) (40.35, 44.5) (40.3555, 20.924) (40.4795, 20.8) (43.593, 20.8197) (43.65, 20.924) (43.65, 44.5) (43.893, 44.5197) (43.95, 44.624) (43.9303, 57.5752) (43.7448, 57.6018) (43.2937, 57.1012) (42.6012, 56.8143) (41.8539, 56.8731) (41.2148, 57.2648) (40.8231, 57.9039) (40.7643, 58.6512) (41.0512, 59.3437) (41.5698, 59.8221) (41.5536, 59.9552) (41.4581, 60) (-41.5252, 59.9803) (-41.5518, 59.7948) (-41.0512, 59.3437) (-40.7643, 58.6511) (-40.8231, 57.9039) (-41.2148, 57.2648) (-41.8539, 56.8731) (-42.6012, 56.8143) (-43.2937, 57.1012) (-43.7721, 57.6198) (-43.9052, 57.6036) (-43.95, 57.5081) (-43.95, 44.624) (-43.8775, 44.5112) (-43.65, 44.5) (-43.65, 20.924) (-43.526, 20.8) (-40.4795, 20.8) (-40.4125, 20.8197), closed, covered)
  P37_AC_L2.sweep_along_vector((0mm, 0mm, 0.07mm))
  P38_AC_L3 = polyline(z=-1.27mm, xy in mm: (-29.207, 5.2197) (-29.15, 5.324) (-29.1697, 12.9556) (-29.6553, 13.3499) (-29.9117, 13.072) (-30.15, 12.9945) (-30.3883, 13.072) (-30.6553, 13.3499) (-30.9117, 13.072) (-31.15, 12.9945) (-31.3883, 13.072) (-31.6553, 13.3499) (-31.9117, 13.072) (-32.15, 12.9945) (-32.3883, 13.072) (-32.6553, 13.3499) (-32.9117, 13.072) (-33.15, 12.9945) (-33.3883, 13.072) (-33.6553, 13.3499) (-33.9117, 13.072) (-34.15, 12.9945) (-34.3883, 13.072) (-34.6553, 13.3499) (-34.9117, 13.072) (-35.15, 12.9945) (-35.3883, 13.072) (-35.6553, 13.3499) (-35.9117, 13.072) (-36.15, 12.9945) (-36.3883, 13.072) (-36.5356, 13.2747) (-36.5356, 13.5253) (-36.4206, 13.7236) (-36.5555, 14.1) (-36.4206, 14.4236) (-36.5555, 14.8) (-36.4206, 15.1236) (-36.5555, 15.5) (-36.478, 15.7383) (-36.2753, 15.8856) (-36.0247, 15.8856) (-35.6447, 15.5501) (-35.2753, 15.8856) (-35.0247, 15.8856) (-34.8504, 15.7946) (-34.7003, 15.9069) (-34.7, 18.5842) (-34.8416, 18.707) (-35.0247, 18.6144) (-35.2753, 18.6144) (-35.478, 18.7617) (-35.5555, 19) (-35.3956, 19.3486) (-35.5555, 19.75) (-35.478, 19.9883) (-35.15, 20.1555) (-34.7807, 20.0496) (-34.7003, 20.1569) (-34.7197, 20.4925) (-34.824, 20.5495) (-36.5198, 20.5495) (-36.6446, 20.6054) (-36.7005, 20.7302) (-36.7005, 22.4698) (-36.5198, 22.6505) (-34.824, 22.6505) (-34.7, 22.7745) (-34.7, 33.276) (-34.824, 33.4) (-40.35, 33.4) (-40.35, 44.5) (-7.15, 44.5) (-7.15, 33.4) (-12.676, 33.4) (-12.8, 33.276) (-12.8, 22.4415) (-12.6584, 22.3188) (-12.0559, 22.6353) (-11.446, 22.5752) (-10.9723, 22.1864) (-10.7944, 21.6) (-10.9723, 21.0135) (-11.446, 20.6248) (-12.0559, 20.5647) (-12.6616, 20.8817) (-12.7821, 20.8227) (-12.7803, 20.0987) (-12.6584, 20.043) (-12.4753, 20.1356) (-12.2247, 20.1356) (-11.9644, 19.8753) (-11.9644, 19.6247) (-12.1044, 19.4014) (-11.9445, 19) (-12.022, 18.7617) (-12.2247, 18.6144) (-12.4753, 18.6144) (-12.6496, 18.7054) (-12.7997, 18.5931) (-12.8, 15.9158) (-12.6584, 15.793) (-12.4753, 15.8856) (-12.2247, 15.8856) (-11.8447, 15.5501) (-11.4753, 15.8856) (-11.2247, 15.8856) (-11.022, 15.7383) (-10.9445, 15.5) (-11.0744, 15.1067) (-10.9445, 14.8) (-11.0794, 14.4764) (-10.9445, 14.1) (-11.0794, 13.7764) (-10.9644, 13.5253) (-10.9644, 13.2747) (-11.1117, 13.072) (-11.35, 12.9945) (-11.5883, 13.072) (-11.8553, 13.3499) (-12.1117, 13.072) (-12.35, 12.9945) (-12.5883, 13.072) (-12.8553, 13.3499) (-13.1117, 13.072) (-13.35, 12.9945) (-13.5883, 13.072) (-13.8553, 13.3499) (-14.1117, 13.072) (-14.35, 12.9945) (-14.5883, 13.072) (-14.8553, 13.3499) (-15.1117, 13.072) (-15.35, 12.9945) (-15.5883, 13.072) (-15.8553, 13.3499) (-16.1117, 13.072) (-16.35, 12.9945) (-16.5883, 13.072) (-16.8553, 13.3499) (-17.1117, 13.072) (-17.35, 12.9945) (-17.5883, 13.072) (-17.8553, 13.3499) (-18.1117, 13.072) (-18.3085, 12.9811) (-18.35, 5.324) (-18.226, 5.2) (-3.974, 5.2) (-3.8612, 5.2725) (-3.85, 44.5) (3.85, 44.5) (3.85, 5.324) (3.974, 5.2) (18.226, 5.2) (18.35, 5.324) (18.3303, 12.9556) (17.8447, 13.3499) (17.5883, 13.072) (17.35, 12.9945) (17.1117, 13.072) (16.8447, 13.3499) (16.5883, 13.072) (16.35, 12.9945) (16.1117, 13.072) (15.8447, 13.3499) (15.5883, 13.072) (15.35, 12.9945) (15.1117, 13.072) (14.8447, 13.3499) (14.5883, 13.072) (14.35, 12.9945) (14.1117, 13.072) (13.8447, 13.3499) (13.5883, 13.072) (13.35, 12.9945) (13.1117, 13.072) (12.8447, 13.3499) (12.5883, 13.072) (12.35, 12.9945) (12.1117, 13.072) (11.8447, 13.3499) (11.5883, 13.072) (11.35, 12.9945) (11.1117, 13.072) (10.9644, 13.2747) (10.9644, 13.5253) (11.0794, 13.7236) (10.9445, 14.1) (11.0794, 14.4236) (10.9445, 14.8) (11.0794, 15.1236) (10.9445, 15.5) (11.022, 15.7383) (11.2247, 15.8856) (11.4753, 15.8856) (11.8553, 15.5501) (12.2247, 15.8856) (12.4753, 15.8856) (12.6496, 15.7946) (12.7997, 15.9069) (12.8, 18.5842) (12.6584, 18.707) (12.4753, 18.6144) (12.2247, 18.6144) (12.022, 18.7617) (11.9445, 19) (12.1044, 19.3486) (11.9445, 19.75) (12.022, 19.9883) (12.35, 20.1555) (12.7193, 20.0496) (12.7997, 20.1569) (12.7803, 20.4925) (12.676, 20.5495) (10.9802, 20.5495) (10.8554, 20.6054) (10.7995, 20.7302) (10.7995, 22.4698) (10.9802, 22.6505) (12.676, 22.6505) (12.8, 22.7745) (12.8, 33.276) (12.676, 33.4) (7.15, 33.4) (7.15, 38.4986) (6.7694, 39.0507) (6.6948, 39.45) (6.7694, 39.8493) (7.15, 40.4014) (7.15, 44.5) (40.35, 44.5) (40.35, 33.4) (34.824, 33.4) (34.7, 33.276) (34.7, 22.4415) (34.8416, 22.3188) (35.4441, 22.6353) (36.054, 22.5752) (36.5277, 22.1864) (36.7056, 21.6) (36.5277, 21.0135) (36.054, 20.6248) (35.4441, 20.5647) (34.8384, 20.8817) (34.7179, 20.8227) (34.7197, 20.0987) (34.8416, 20.043) (35.0247, 20.1356) (35.2753, 20.1356) (35.5356, 19.8753) (35.5356, 19.6247) (35.3956, 19.4014) (35.5555, 19) (35.478, 18.7617) (35.2753, 18.6144) (35.0247, 18.6144) (34.8504, 18.7054) (34.7003, 18.5931) (34.7, 15.9158) (34.8416, 15.793) (35.0247, 15.8856) (35.2753, 15.8856) (35.6553, 15.5501) (36.0247, 15.8856) (36.2753, 15.8856) (36.478, 15.7383) (36.5555, 15.5) (36.4256, 15.1067) (36.5555, 14.8) (36.4206, 14.4764) (36.5555, 14.1) (36.4206, 13.7764) (36.5356, 13.5253) (36.5356, 13.2747) (36.3883, 13.072) (36.15, 12.9945) (35.9117, 13.072) (35.6447, 13.3499) (35.3883, 13.072) (35.15, 12.9945) (34.9117, 13.072) (34.6447, 13.3499) (34.3883, 13.072) (34.15, 12.9945) (33.9117, 13.072) (33.6447, 13.3499) (33.3883, 13.072) (33.15, 12.9945) (32.9117, 13.072) (32.6447, 13.3499) (32.3883, 13.072) (32.15, 12.9945) (31.9117, 13.072) (31.6447, 13.3499) (31.3883, 13.072) (31.15, 12.9945) (30.9117, 13.072) (30.6447, 13.3499) (30.3883, 13.072)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, closed, covered)
  P38_AC_L3_h0 = polyline(z=-1.27mm, xy in mm: (-38.9025, 25.337) (-39.4168, 25.6554) (-39.6306, 26.0007) (-39.7052, 26.4) (-39.6306, 26.7993) (-39.4168, 27.1446) (-39.0926, 27.3893) (-38.702, 27.5005) (-38.2975, 27.463) (-37.934, 27.282) (-37.6603, 26.9818) (-37.5136, 26.6031) (-37.5136, 26.1969) (-37.6603, 25.8182) (-37.934, 25.518) (-38.2975, 25.337) (-38.702, 25.2995) (-38.9025, 25.337), closed, covered)
  P38_AC_L3_h1 = polyline(z=-1.27mm, xy in mm: (8.5975, 25.337) (8.0832, 25.6554) (7.8694, 26.0007) (7.7948, 26.4) (7.8694, 26.7993) (8.0832, 27.1446) (8.4074, 27.3893) (8.798, 27.5005) (9.2025, 27.463) (9.566, 27.282) (9.8397, 26.9818) (9.9864, 26.6031) (9.9864, 26.1969) (9.8397, 25.8182) (9.566, 25.518) (9.2025, 25.337) (8.798, 25.2995) (8.5975, 25.337), closed, covered)
  P38_AC_L3_h2 = polyline(z=-1.27mm, xy in mm: (-9.0725, 25.287) (-9.5868, 25.6054) (-9.8006, 25.9507) (-9.8752, 26.35) (-9.8006, 26.7493) (-9.5868, 27.0946) (-9.2626, 27.3393) (-8.872, 27.4505) (-8.4675, 27.413) (-8.104, 27.232) (-7.8303, 26.9318) (-7.6836, 26.5531) (-7.6836, 26.1469) (-7.8303, 25.7682) (-8.104, 25.468) (-8.4675, 25.287) (-8.872, 25.2495) (-9.0725, 25.287), closed, covered)
  P38_AC_L3_h3 = polyline(z=-1.27mm, xy in mm: (-38.3959, 20.5647) (-38.7765, 20.7223) (-39.0677, 21.0135) (-39.2253, 21.3941) (-39.2253, 21.8059) (-39.0677, 22.1865) (-38.7764, 22.4777) (-38.3959, 22.6353) (-37.9841, 22.6353) (-37.4436, 22.3464) (-37.2148, 22.004) (-37.1344, 21.6) (-37.2148, 21.196) (-37.4436, 20.8536) (-37.786, 20.6248) (-38.19, 20.5444) (-38.3959, 20.5647), closed, covered)
  P38_AC_L3_h4 = polyline(z=-1.27mm, xy in mm: (9.1041, 20.5647) (8.7235, 20.7223) (8.4323, 21.0135) (8.2747, 21.3941) (8.2747, 21.8059) (8.4323, 22.1865) (8.7235, 22.4777) (9.1041, 22.6353) (9.5159, 22.6353) (10.0564, 22.3464) (10.2852, 22.004) (10.3656, 21.6) (10.2852, 21.196) (10.0564, 20.8536) (9.714, 20.6248) (9.31, 20.5444) (9.1041, 20.5647), closed, covered)
  P38_AC_L3_h5 = polyline(z=-1.27mm, xy in mm: (-10.2382, 20.5611) (-10.3605, 20.7302) (-10.3605, 22.4698) (-10.3046, 22.5946) (-10.1798, 22.6505) (-8.4402, 22.6505) (-8.3154, 22.5946) (-8.2595, 22.4698) (-8.2595, 20.7302) (-8.3154, 20.6054) (-8.4402, 20.5495) (-10.1798, 20.5495) (-10.2382, 20.5611), closed, covered)
  P38_AC_L3_h6 = polyline(z=-1.27mm, xy in mm: (37.2618, 20.5611) (37.1395, 20.7302) (37.1395, 22.4698) (37.1954, 22.5946) (37.3202, 22.6505) (39.0598, 22.6505) (39.1846, 22.5946) (39.2405, 22.4698) (39.2405, 20.7302) (39.1846, 20.6054) (39.0598, 20.5495) (37.3202, 20.5495) (37.2618, 20.5611), closed, covered)
  P38_AC_L3_h7 = polyline(z=-1.27mm, xy in mm: (-42.2753, 13.0144) (-42.478, 13.1617) (-42.5555, 13.4) (-42.478, 13.6383) (-42.15, 13.8055) (-41.9117, 13.728) (-41.6447, 13.4501) (-41.3883, 13.728) (-41.15, 13.8055) (-40.9117, 13.728) (-40.6447, 13.4501) (-40.3883, 13.728) (-40.15, 13.8055) (-39.9117, 13.728) (-39.6447, 13.4501) (-39.3883, 13.728) (-39.0247, 13.7856) (-38.6447, 13.4501) (-38.3883, 13.728) (-38.15, 13.8055) (-37.9117, 13.728) (-37.7445, 13.4) (-37.822, 13.1617) (-38.15, 12.9945) (-38.3883, 13.072) (-38.6553, 13.3499) (-38.9117, 13.072) (-39.15, 12.9945) (-39.3883, 13.072) (-39.6553, 13.3499) (-39.9117, 13.072) (-40.15, 12.9945) (-40.3883, 13.072) (-40.6553, 13.3499) (-40.9117, 13.072) (-41.2753, 13.0144) (-41.6553, 13.3499) (-41.9117, 13.072) (-42.15, 12.9945) (-42.2753, 13.0144), closed, covered)
  P38_AC_L3_h8 = polyline(z=-1.27mm, xy in mm: (-9.4753, 13.0144) (-9.6781, 13.1617) (-9.7555, 13.4) (-9.6781, 13.6383) (-9.35, 13.8055) (-9.1117, 13.728) (-8.8447, 13.4501) (-8.5883, 13.728) (-8.35, 13.8055) (-8.1117, 13.728) (-7.8447, 13.4501) (-7.5883, 13.728) (-7.35, 13.8055) (-7.1117, 13.728) (-6.8447, 13.4501) (-6.4753, 13.7856) (-6.1117, 13.728) (-5.8447, 13.4501) (-5.5883, 13.728) (-5.35, 13.8055) (-5.1117, 13.728) (-4.9445, 13.4) (-5.022, 13.1617) (-5.35, 12.9945) (-5.5883, 13.072) (-5.8553, 13.3499) (-6.1117, 13.072) (-6.35, 12.9945) (-6.5883, 13.072) (-6.8553, 13.3499) (-7.1117, 13.072) (-7.35, 12.9945) (-7.5883, 13.072) (-7.8553, 13.3499) (-8.1117, 13.072) (-8.4753, 13.0144) (-8.8553, 13.3499) (-9.1117, 13.072) (-9.35, 12.9945) (-9.4753, 13.0144), closed, covered)
  P38_AC_L3_h9 = polyline(z=-1.27mm, xy in mm: (5.2247, 13.0144) (5.022, 13.1617) (4.9445, 13.4) (5.022, 13.6383) (5.35, 13.8055) (5.5883, 13.728) (5.8553, 13.4501) (6.1117, 13.728) (6.35, 13.8055) (6.5883, 13.728) (6.8553, 13.4501) (7.1117, 13.728) (7.35, 13.8055) (7.5883, 13.728) (7.8553, 13.4501) (8.1117, 13.728) (8.4753, 13.7856) (8.8553, 13.4501) (9.1117, 13.728) (9.35, 13.8055) (9.6781, 13.6383) (9.7555, 13.4) (9.6781, 13.1617) (9.35, 12.9945) (9.1117, 13.072) (8.8447, 13.3499) (8.5883, 13.072) (8.35, 12.9945) (8.1117, 13.072) (7.8447, 13.3499) (7.5883, 13.072) (7.35, 12.9945) (7.1117, 13.072) (6.8447, 13.3499) (6.5883, 13.072) (6.2247, 13.0144) (5.8447, 13.3499) (5.5883, 13.072) (5.35, 12.9945) (5.2247, 13.0144), closed, covered)
  P38_AC_L3_h10 = polyline(z=-1.27mm, xy in mm: (38.0247, 13.0144) (37.8219, 13.1617) (37.7445, 13.4) (37.8219, 13.6383) (38.15, 13.8055) (38.3883, 13.728) (38.6553, 13.4501) (38.9117, 13.728) (39.15, 13.8055) (39.3883, 13.728) (39.6553, 13.4501) (39.9117, 13.728) (40.15, 13.8055) (40.3883, 13.728) (40.6553, 13.4501) (40.9117, 13.728) (41.2753, 13.7856) (41.6553, 13.4501) (41.9117, 13.728) (42.15, 13.8055) (42.3883, 13.728) (42.5555, 13.4) (42.478, 13.1617) (42.15, 12.9945) (41.9117, 13.072) (41.6447, 13.3499) (41.3883, 13.072) (41.15, 12.9945) (40.9117, 13.072) (40.6447, 13.3499) (40.3883, 13.072) (40.15, 12.9945) (39.9117, 13.072) (39.6447, 13.3499) (39.3883, 13.072) (39.0247, 13.0144) (38.6447, 13.3499) (38.3883, 13.072) (38.15, 12.9945) (38.0247, 13.0144), closed, covered)
  P38_AC_L3_h11 = polyline(z=-1.27mm, xy in mm: (-37.3503, 11.4144) (-37.6106, 11.6747) (-37.6106, 11.9253) (-37.4633, 12.1281) (-37.0997, 12.1856) (-36.897, 12.0383) (-36.8195, 11.8) (-36.897, 11.5617) (-37.225, 11.3945) (-37.3503, 11.4144), closed, covered)
  P38_AC_L3_h12 = polyline(z=-1.27mm, xy in mm: (-10.4003, 11.4144) (-10.6606, 11.6747) (-10.6606, 11.9253) (-10.5133, 12.1281) (-10.1497, 12.1856) (-9.9469, 12.0383) (-9.8695, 11.8) (-9.9469, 11.5617) (-10.275, 11.3945) (-10.4003, 11.4144), closed, covered)
  P38_AC_L3_h13 = polyline(z=-1.27mm, xy in mm: (10.1497, 11.4144) (9.8894, 11.6747) (9.8894, 11.9253) (10.0367, 12.1281) (10.4003, 12.1856) (10.603, 12.0383) (10.6805, 11.8) (10.603, 11.5617) (10.275, 11.3945) (10.1497, 11.4144), closed, covered)
  P38_AC_L3_h14 = polyline(z=-1.27mm, xy in mm: (37.0997, 11.4144) (36.8394, 11.6747) (36.8394, 11.9253) (36.9867, 12.1281) (37.3503, 12.1856) (37.5531, 12.0383) (37.6305, 11.8) (37.5531, 11.5617) (37.225, 11.3945) (37.0997, 11.4144), closed, covered)
  P38_AC_L3_h15 = polyline(z=-1.27mm, xy in mm: (-17.5375, 10.3334) (-17.7276, 10.4715) (-17.7816, 10.8125) (-17.6435, 11.0026) (-17.3025, 11.0566) (-17.1124, 10.9185) (-17.0584, 10.5775) (-17.1965, 10.3874) (-17.42, 10.3148) (-17.5375, 10.3334), closed, covered)
  P38_AC_L3_h16 = polyline(z=-1.27mm, xy in mm: (29.9625, 10.3334) (29.7724, 10.4715) (29.7184, 10.8125) (29.8565, 11.0026) (30.1975, 11.0566) (30.3876, 10.9185) (30.4416, 10.5775) (30.3035, 10.3874) (30.08, 10.3148) (29.9625, 10.3334), closed, covered)
  P38_AC_L3_h17 = polyline(z=-1.27mm, xy in mm: (-30.1975, 10.0684) (-30.3876, 10.2065) (-30.4416, 10.5475) (-30.3035, 10.7376) (-29.9625, 10.7916) (-29.7724, 10.6535) (-29.7184, 10.3125) (-29.8565, 10.1224) (-30.08, 10.0498) (-30.1975, 10.0684), closed, covered)
  P38_AC_L3_h18 = polyline(z=-1.27mm, xy in mm: (17.3025, 10.0684) (17.1124, 10.2065) (17.0584, 10.5475) (17.1965, 10.7376) (17.5375, 10.7916) (17.7276, 10.6535) (17.7816, 10.3125) (17.6435, 10.1224) (17.42, 10.0498) (17.3025, 10.0684), closed, covered)
  P38_AC_L3_h19 = polyline(z=-1.27mm, xy in mm: (-17.5375, 7.6084) (-17.7276, 7.7465) (-17.7816, 8.0875) (-17.6435, 8.2776) (-17.3025, 8.3316) (-17.1124, 8.1935) (-17.0584, 7.8525) (-17.1965, 7.6624) (-17.42, 7.5898) (-17.5375, 7.6084), closed, covered)
  P38_AC_L3_h20 = polyline(z=-1.27mm, xy in mm: (29.9625, 7.6084) (29.7724, 7.7465) (29.7184, 8.0875) (29.8565, 8.2776) (30.1975, 8.3316) (30.3876, 8.1935) (30.4416, 7.8525) (30.3035, 7.6624) (30.08, 7.5898) (29.9625, 7.6084), closed, covered)
  P38_AC_L3_h21 = polyline(z=-1.27mm, xy in mm: (-30.1975, 7.3434) (-30.3876, 7.4815) (-30.4416, 7.8225) (-30.3035, 8.0126) (-29.9625, 8.0666) (-29.7724, 7.9285) (-29.7184, 7.5875) (-29.8565, 7.3974) (-30.08, 7.3248) (-30.1975, 7.3434), closed, covered)
  P38_AC_L3_h22 = polyline(z=-1.27mm, xy in mm: (17.3025, 7.3434) (17.1124, 7.4815) (17.0584, 7.8225) (17.1965, 8.0126) (17.5375, 8.0666) (17.7276, 7.9285) (17.7816, 7.5875) (17.6435, 7.3974) (17.42, 7.3248) (17.3025, 7.3434), closed, covered)
  P38_AC_L3_h23 = polyline(z=-1.27mm, xy in mm: (-17.5375, 6.0334) (-17.7276, 6.1715) (-17.7816, 6.5125) (-17.6435, 6.7026) (-17.3025, 6.7566) (-17.1124, 6.6185) (-17.0584, 6.2775) (-17.1965, 6.0874) (-17.42, 6.0148) (-17.5375, 6.0334), closed, covered)
  P38_AC_L3_h24 = polyline(z=-1.27mm, xy in mm: (29.9625, 6.0334) (29.7724, 6.1715) (29.7184, 6.5125) (29.8565, 6.7026) (30.1975, 6.7566) (30.3876, 6.6185) (30.4416, 6.2775) (30.3035, 6.0874) (30.08, 6.0148) (29.9625, 6.0334), closed, covered)
  P38_AC_L3_h25 = polyline(z=-1.27mm, xy in mm: (-30.1975, 5.7684) (-30.3876, 5.9065) (-30.4416, 6.2475) (-30.3035, 6.4376) (-29.9625, 6.4916) (-29.7724, 6.3535) (-29.7184, 6.0125) (-29.8565, 5.8224) (-30.08, 5.7498) (-30.1975, 5.7684), closed, covered)
  P38_AC_L3_h26 = polyline(z=-1.27mm, xy in mm: (17.3025, 5.7684) (17.1124, 5.9065) (17.0584, 6.2475) (17.1965, 6.4376) (17.5375, 6.4916) (17.7276, 6.3535) (17.7816, 6.0125) (17.6435, 5.8224) (17.42, 5.7498) (17.3025, 5.7684), closed, covered)
  P38_AC_L3.subtract(P38_AC_L3_h0..P38_AC_L3_h26)
  P38_AC_L3.sweep_along_vector((0mm, 0mm, 0.07mm))
  P39_AC_L4 = polyline(z=-1.44mm, xy in mm: (-38.5663, 4.6189) (-38.5226, 5.0147) (-38.3971, 5.2522) (-38.1597, 5.3776) (-37.7245, 5.3805) (-37.6255, 5.4795) (-37.6444, 6.8387) (-38.2879, 6.9272) (-38.5226, 7.2453) (-38.4778, 8.0929) (-38.1293, 8.3305) (-36.1621, 8.2828) (-35.9245, 7.9343) (-35.9274, 7.2453) (-36.0862, 6.8982) (-35.9923, 6.8305) (-35.2121, 6.7828) (-34.9603, 6.4731) (-34.3987, 6.4744) (-34.1003, 6.7906) (-33.5435, 6.8055) (-33.3367, 6.7331) (-33.1745, 6.4365) (-33.1745, 5.8235) (-33.3169, 5.52) (-33.2191, 5.4055) (-32.6809, 5.4055) (-32.5867, 5.4739) (-32.7255, 5.8235) (-32.7255, 6.4365) (-32.5633, 6.7331) (-32.3565, 6.8055) (-31.7997, 6.7906) (-31.5013, 6.4744) (-31.2085, 6.4555) (-30.9782, 6.7679) (-30.7002, 6.9598) (-30.1998, 6.9598) (-29.8252, 6.6279) (-29.6703, 6.2631) (-29.6703, 5.9969) (-29.8268, 5.7815) (-30.3604, 5.6006) (-30.4354, 5.5117) (-30.374, 5.4128) (-30.0226, 5.4055) (-29.8268, 5.2925) (-29.7545, 5.1374) (-29.7356, 4.6408) (-27.0908, 4.6189) (-27.0689, 5.5587) (-28.4924, 5.5995) (-28.7779, 5.6752) (-29.1098, 6.0498) (-29.1505, 6.3851) (-28.9252, 6.82) (-28.6189, 6.9851) (-27.149, 7.0005) (-27.0548, 7.0689) (-27.05, 9.901) (-27.149, 10) (-28.35, 10) (-28.35, 14.901) (-28.4184, 14.9952) (-28.5589, 15) (-28.653, 14.9316) (-28.7587, 14.4585) (-28.6444, 14.1) (-28.7587, 13.7585) (-28.6648, 13.5425) (-28.6648, 13.2575) (-28.9399, 12.94) (-29.3601, 12.94) (-29.6276, 13.158) (-29.9399, 12.94) (-30.222, 12.8995) (-30.6276, 13.158) (-30.9399, 12.94) (-31.222, 12.8995) (-31.6276, 13.158) (-31.9399, 12.94) (-32.3581, 12.9198) (-32.4238, 12.8237) (-32.1966, 12.532) (-32.0559, 12.1523) (-32.139, 11.4408) (-31.7978, 11.3991) (-31.4898, 11.2605) (-31.1461, 10.7562) (-30.3971, 10.7555) (-29.9469, 10.8397) (-29.7315, 10.6832) (-29.6303, 10.3744) (-29.2018, 9.8066) (-28.6539, 9.786) (-28.1391, 9.5109) (-27.864, 8.9961) (-27.9097, 8.3881) (-27.4968, 8.2485) (-27.3403, 8.0331) (-27.4015, 7.6468) (-27.6169, 7.4903) (-28.0032, 7.5515) (-28.2593, 7.9585) (-28.6539, 7.814) (-29.0461, 7.814) (-29.6305, 8.1441) (-29.7545, 8.0484) (-29.6492, 7.705) (-29.7315, 7.4518) (-30.08, 7.2742) (-30.4285, 7.4518) (-30.5193, 7.7723) (-30.623, 7.8251) (-34.5524, 7.8149) (-34.9245, 7.9746) (-35.2035, 8.268) (-35.3441, 8.6477) (-35.3505, 9.0009) (-35.4385, 9.0545) (-38.7255, 9.0545) (-38.8197, 8.9861) (-38.835, 8.5272) (-38.9823, 8.2113) (-39.4222, 7.94) (-41.4278, 7.94) (-41.7437, 8.0873) (-41.9598, 8.3607) (-42.0255, 8.63) (-41.9598, 9.5493) (-41.5943, 9.9148) (-40.8663, 9.9994) (-40.8255, 10.7805) (-40.8939, 10.8747) (-41.5943, 10.9452) (-41.9598, 11.3107) (-42.0255, 11.58) (-42.015, 12.3328) (-41.8677, 12.6487) (-41.4763, 12.976) (-41.6276, 13.158) (-41.9399, 12.94) (-42.3601, 12.94) (-42.6352, 13.2575) (-42.5754, 13.6734) (-42.222, 13.9005) (-41.9399, 13.86) (-41.6724, 13.642) (-41.222, 13.9005) (-40.9399, 13.86) (-40.6724, 13.642) (-40.222, 13.9005) (-39.9399, 13.86) (-39.6724, 13.642) (-39.222, 13.9005) (-38.9399, 13.86) (-38.6724, 13.642) (-38.222, 13.9005) (-37.9399, 13.86) (-37.7469, 13.728) (-37.6255, 13.8244) (-37.6255, 14.2899) (-37.6939, 14.384) (-41.6348, 14.3889) (-42.0046, 14.5779) (-42.1161, 14.8686) (-42.1161, 16.4899) (-41.9827, 16.8) (-40.3038, 16.8) (-40.0042, 16.3934) (-39.4913, 16.2113) (-38.9958, 16.3934) (-38.5014, 17.0058) (-38.9958, 17.6066) (-39.4913, 17.7887) (-40.0042, 17.6066) (-40.3066, 17.2) (-41.9854, 17.2) (-42.1161, 17.5086) (-42.1161, 19.1299) (-42.0252, 19.3946) (-41.8249, 19.5638) (-37.3651, 19.6111) (-37.1004, 19.5202) (-36.9129, 19.2757) (-36.8195, 18.67) (-36.8245, 15.683) (-36.7561, 15.5888) (-36.6454, 15.6248) (-36.4811, 15.8821) (-36.222, 16.0005) (-35.9399, 15.96) (-35.6724, 15.742) (-35.222, 16.0005) (-34.9399, 15.96) (-34.6724, 15.742) (-34.222, 16.0005) (-33.9399, 15.96) (-33.6724, 15.742) (-33.222, 16.0005) (-32.9399, 15.96) (-32.6724, 15.742) (-32.222, 16.0005) (-31.9399, 15.96) (-31.6724, 15.742) (-31.222, 16.0005) (-30.9399, 15.96) (-30.6724, 15.742) (-30.3601, 15.96) (-30.078, 16.0005) (-29.6724, 15.742) (-29.15, 16.0929) (-29.15, 17.801) (-29.2184, 17.8952) (-34.7, 17.9) (-34.7189, 18.5711) (-34.8296, 18.6071) (-35.078, 18.4995) (-35.3601, 18.54) (-35.5754, 18.7266) (-35.6556, 19) (-35.5197, 19.3665) (-35.6556, 19.75) (-35.5754, 20.0234) (-35.222, 20.2505) (-34.7363, 20.1604) (-34.7189, 20.5087) (-36.5198, 20.5495) (-36.6889, 20.6718) (-36.7005, 22.4698) (-36.6446, 22.5946) (-36.5198, 22.6505) (-34.799, 22.6505) (-34.7048, 22.7189) (-34.7, 33.301) (-34.799, 33.4) (-36.8337, 33.3811) (-36.8556, 33.2219) (-36.6718, 33.0679) (-36.5149, 32.7689) (-36.5149, 32.4311) (-36.7991, 32.0193) (-37.2851, 31.8995) (-37.6009, 32.0193) (-37.8851, 32.4311) (-37.8248, 32.9279) (-37.5358, 33.2363) (-37.5939, 33.3952) (-40.35, 33.4) (-40.35, 44.5) (-7.15, 44.5) (-7.15, 33.4) (-12.701, 33.4) (-12.8, 33.301) (-12.7811, 22.7154) (-12.6704, 22.6795) (-12.0854, 22.9351) (-11.6146, 22.9351) (-11.1722, 22.774) (-10.7695, 22.4562) (-10.6658, 22.509) (-10.5175, 22.8075) (-10.2675, 22.9441) (-8.4121, 22.9505) (-8.2177, 22.8938) (-8.0162, 22.6923) (-7.9595, 22.4979) (-7.9595, 20.7021) (-8.0162, 20.5077) (-8.3525, 20.2559) (-10.2079, 20.2495) (-10.5175, 20.3924) (-10.7337, 20.7429) (-11.3863, 20.3261) (-11.954, 20.2345) (-11.9995, 20.1273) (-11.8444, 19.75) (-11.9803, 19.3835) (-11.8648, 19.1425) (-11.8648, 18.8575) (-12.1399, 18.54) (-12.422, 18.4995) (-12.7637, 18.5896) (-12.8, 17.9) (-18.3092, 17.8811) (-18.35, 16.0957) (-17.8724, 15.742) (-17.422, 16.0005) (-17.1399, 15.96) (-16.8724, 15.742) (-16.422, 16.0005) (-16.1399, 15.96) (-15.8724, 15.742) (-15.422, 16.0005) (-15.1399, 15.96) (-14.8724, 15.742) (-14.422, 16.0005) (-14.1399, 15.96) (-13.8724, 15.742) (-13.422, 16.0005)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, closed, covered)
  P39_AC_L4_h0 = polyline(z=-1.44mm, xy in mm: (-9.115, 24.9877) (-9.7218, 25.3161) (-10.0059, 25.6812) (-10.1753, 26.35) (-10.0992, 26.8063) (-9.879, 27.2132) (-9.5386, 27.5265) (-9.115, 27.7123) (-8.425, 27.7123) (-8.0014, 27.5265) (-7.661, 27.2132) (-7.4408, 26.8063) (-7.3839, 26.1187) (-7.661, 25.4868) (-8.0014, 25.1735) (-8.425, 24.9877) (-8.886, 24.9495) (-9.115, 24.9877), closed, covered)
  P39_AC_L4_h1 = polyline(z=-1.44mm, xy in mm: (-38.9025, 25.337) (-39.4168, 25.6554) (-39.6306, 26.0007) (-39.7052, 26.4) (-39.6306, 26.7993) (-39.4168, 27.1446) (-39.0926, 27.3893) (-38.702, 27.5005) (-38.2975, 27.463) (-37.934, 27.282) (-37.6603, 26.9818) (-37.5136, 26.6031) (-37.5136, 26.1969) (-37.6603, 25.8182) (-37.934, 25.518) (-38.2975, 25.337) (-38.702, 25.2995) (-38.9025, 25.337), closed, covered)
  P39_AC_L4_h2 = polyline(z=-1.44mm, xy in mm: (8.5975, 25.337) (8.0832, 25.6554) (7.8694, 26.0007) (7.7948, 26.4) (7.8694, 26.7993) (8.0832, 27.1446) (8.4074, 27.3893) (8.798, 27.5005) (9.2025, 27.463) (9.566, 27.282) (9.8397, 26.9818) (9.9864, 26.6031) (9.9864, 26.1969) (9.8397, 25.8182) (9.566, 25.518) (9.2025, 25.337) (8.798, 25.2995) (8.5975, 25.337), closed, covered)
  P39_AC_L4_h3 = polyline(z=-1.44mm, xy in mm: (-38.3959, 20.5647) (-38.7765, 20.7223) (-39.0677, 21.0135) (-39.2253, 21.3941) (-39.2253, 21.8059) (-39.0677, 22.1865) (-38.7765, 22.4777) (-38.3959, 22.6353) (-37.9841, 22.6353) (-37.4436, 22.3464) (-37.2148, 22.004) (-37.1344, 21.6) (-37.2148, 21.196) (-37.4436, 20.8536) (-37.786, 20.6248) (-38.19, 20.5444) (-38.3959, 20.5647), closed, covered)
  P39_AC_L4_h4 = polyline(z=-1.44mm, xy in mm: (9.1041, 20.5647) (8.7235, 20.7223) (8.4323, 21.0135) (8.2747, 21.3941) (8.2747, 21.8059) (8.4323, 22.1865) (8.7235, 22.4777) (9.1041, 22.6353) (9.5159, 22.6353) (10.0564, 22.3464) (10.2852, 22.004) (10.3656, 21.6) (10.2852, 21.196) (10.0564, 20.8536) (9.714, 20.6248) (9.31, 20.5444) (9.1041, 20.5647), closed, covered)
  P39_AC_L4.subtract(P39_AC_L4_h0..P39_AC_L4_h4)
  P39_AC_L4.sweep_along_vector((0mm, 0mm, 0.07mm))
  V0_DCP = cylinder(axis=Z, base_centre=(-19.0115mm, -5.5mm, -1.44mm), radius=0.15mm, height=1.68mm)
  V1_DCP = cylinder(axis=Z, base_centre=(-15.6mm, 2.5mm, -1.44mm), radius=0.15mm, height=1.68mm)
  V2_DCP = cylinder(axis=Z, base_centre=(-34.4115mm, -12.65mm, -1.44mm), radius=0.15mm, height=1.68mm)
  V3_DCP = cylinder(axis=Z, base_centre=(-18.3mm, 2.5mm, -1.44mm), radius=0.15mm, height=1.68mm)
  V4_DCP = cylinder(axis=Z, base_centre=(-7.15mm, -12.65mm, -1.44mm), radius=0.15mm, height=1.68mm)
  V5_DCP = cylinder(axis=Z, base_centre=(24.9346mm, -12.65mm, -1.44mm), radius=0.15mm, height=1.68mm)
  V6_DCP = cylinder(axis=Z, base_centre=(-12.9mm, 2.5mm, -1.44mm), radius=0.15mm, height=1.68mm)
  V7_DCP = cylinder(axis=Z, base_centre=(4.85mm, -5.5mm, -1.44mm), radius=0.15mm, height=1.68mm)
  V8_DCP = cylinder(axis=Z, base_centre=(27.3038mm, -5.5mm, -1.44mm), radius=0.15mm, height=1.68mm)
  V9_DCP = cylinder(axis=Z, base_centre=(28.4885mm, -5.5mm, -1.44mm), radius=0.15mm, height=1.68mm)
  V10_DCP = cylinder(axis=Z, base_centre=(-26.1192mm, -5.5mm, -1.44mm), radius=0.15mm, height=1.68mm)
  V11_DCP = cylinder(axis=Z, base_centre=(-15.4577mm, -12.65mm, -1.44mm), radius=0.15mm, height=1.68mm)
  V12_DCP = cylinder(axis=Z, base_centre=(-36.7808mm, -5.5mm, -1.44mm), radius=0.15mm, height=1.68mm)
  V13_DCP = cylinder(axis=Z, base_centre=(-23.75mm, -12.65mm, -1.44mm), radius=0.15mm, height=1.68mm)
  V14_DCP = cylinder(axis=Z, base_centre=(-9.5346mm, -5.5mm, -1.44mm), radius=0.15mm, height=1.68mm)
  V15_DCP = cylinder(axis=Z, base_centre=(30.8577mm, -5.5mm, -1.44mm), radius=0.15mm, height=1.68mm)
  V16_DCP = cylinder(axis=Z, base_centre=(29.6731mm, -5.5mm, -1.44mm), radius=0.15mm, height=1.68mm)
  V17_DCP = cylinder(axis=Z, base_centre=(-34.4115mm, -5.5mm, -1.44mm), radius=0.15mm, height=1.68mm)
  V18_DCP = cylinder(axis=Z, base_centre=(-24.9346mm, -12.65mm, -1.44mm), radius=0.15mm, height=1.68mm)
  V19_DCP = cylinder(axis=Z, base_centre=(32.8mm, 2.5mm, -1.44mm), radius=0.15mm, height=1.68mm)
  V20_DCP = cylinder(axis=Z, base_centre=(20.1962mm, -5.5mm, -1.44mm), radius=0.15mm, height=1.68mm)
  V21_DCP = cylinder(axis=Z, base_centre=(-26.1192mm, -12.65mm, -1.44mm), radius=0.15mm, height=1.68mm)
  V22_DCP = cylinder(axis=Z, base_centre=(10.7192mm, -12.65mm, -1.44mm), radius=0.15mm, height=1.68mm)
  V23_DCP = cylinder(axis=Z, base_centre=(29.2mm, 2.5mm, -1.44mm), radius=0.15mm, height=1.68mm)
  V24_DCP = cylinder(axis=Z, base_centre=(-37.9654mm, -12.65mm, -1.44mm), radius=0.15mm, height=1.68mm)
  V25_DCP = cylinder(axis=Z, base_centre=(12mm, 2.5mm, -1.44mm), radius=0.15mm, height=1.68mm)
  V26_DCP = cylinder(axis=Z, base_centre=(8.35mm, -5.5mm, -1.44mm), radius=0.15mm, height=1.68mm)
  V27_DCP = cylinder(axis=Z, base_centre=(-31.9mm, 2.5mm, -1.44mm), radius=0.15mm, height=1.68mm)
  V28_DCP = cylinder(axis=Z, base_centre=(17.8269mm, -12.65mm, -1.44mm), radius=0.15mm, height=1.68mm)
  V29_DCP = cylinder(axis=Z, base_centre=(-29.6731mm, -12.65mm, -1.44mm), radius=0.15mm, height=1.68mm)
  V30_DCP = cylinder(axis=Z, base_centre=(31.9mm, 2.5mm, -1.44mm), radius=0.15mm, height=1.68mm)
  V31_DCP = cylinder(axis=Z, base_centre=(-2.35mm, -12.65mm, -1.44mm), radius=0.15mm, height=1.68mm)
  V32_DCP = cylinder(axis=Z, base_centre=(-11.9038mm, -5.5mm, -1.44mm), radius=0.15mm, height=1.68mm)
  V33_DCP = cylinder(axis=Z, base_centre=(-23.75mm, -5.5mm, -1.44mm), radius=0.15mm, height=1.68mm)
  V34_DCP = cylinder(axis=Z, base_centre=(15.6mm, 2.5mm, -1.44mm), radius=0.15mm, height=1.68mm)
  V35_DCP = cylinder(axis=Z, base_centre=(13.8mm, 2.5mm, -1.44mm), radius=0.15mm, height=1.68mm)
  V36_DCP = cylinder(axis=Z, base_centre=(27.3038mm, -12.65mm, -1.44mm), radius=0.15mm, height=1.68mm)
  V37_DCP = cylinder(axis=Z, base_centre=(-8.35mm, -5.5mm, -1.44mm), radius=0.15mm, height=1.68mm)
  V38_DCP = cylinder(axis=Z, base_centre=(-12mm, 2.5mm, -1.44mm), radius=0.15mm, height=1.68mm)
  V39_DCP = cylinder(axis=Z, base_centre=(14.2731mm, -12.65mm, -1.44mm), radius=0.15mm, height=1.68mm)
  V40_DCP = cylinder(axis=Z, base_centre=(-3.55mm, -5.5mm, -1.44mm), radius=0.15mm, height=1.68mm)
  V41_DCP = cylinder(axis=Z, base_centre=(13.0885mm, -12.65mm, -1.44mm), radius=0.15mm, height=1.68mm)
  V42_DCP = cylinder(axis=Z, base_centre=(32.0423mm, -12.65mm, -1.44mm), radius=0.15mm, height=1.68mm)
  V43_DCP = cylinder(axis=Z, base_centre=(22.5654mm, -5.5mm, -1.44mm), radius=0.15mm, height=1.68mm)
  V44_DCP = cylinder(axis=Z, base_centre=(26.1192mm, -12.65mm, -1.44mm), radius=0.15mm, height=1.68mm)
  V45_DCP = cylinder(axis=Z, base_centre=(-19.0115mm, -12.65mm, -1.44mm), radius=0.15mm, height=1.68mm)
  V46_DCP = cylinder(axis=Z, base_centre=(9.5346mm, -12.65mm, -1.44mm), radius=0.15mm, height=1.68mm)
  V47_DCP = cylinder(axis=Z, base_centre=(-35.5962mm, -12.65mm, -1.44mm), radius=0.15mm, height=1.68mm)
  V48_DCP = cylinder(axis=Z, base_centre=(-13.0885mm, -12.65mm, -1.44mm), radius=0.15mm, height=1.68mm)
  V49_DCP = cylinder(axis=Z, base_centre=(-16.6423mm, -12.65mm, -1.44mm), radius=0.15mm, height=1.68mm)
  V50_DCP = cylinder(axis=Z, base_centre=(16.6423mm, -5.5mm, -1.44mm), radius=0.15mm, height=1.68mm)
  V51_DCP = cylinder(axis=Z, base_centre=(21.3808mm, -5.5mm, -1.44mm), radius=0.15mm, height=1.68mm)
  V52_DCP = cylinder(axis=Z, base_centre=(-16.6423mm, -5.5mm, -1.44mm), radius=0.15mm, height=1.68mm)
  V53_DCP = cylinder(axis=Z, base_centre=(30.8577mm, -12.65mm, -1.44mm), radius=0.15mm, height=1.68mm)
  V54_DCP = cylinder(axis=Z, base_centre=(-14.2731mm, -12.65mm, -1.44mm), radius=0.15mm, height=1.68mm)
  V55_DCP = cylinder(axis=Z, base_centre=(-1.15mm, -12.65mm, -1.44mm), radius=0.15mm, height=1.68mm)
  V56_DCP = cylinder(axis=Z, base_centre=(24.9346mm, -5.5mm, -1.44mm), radius=0.15mm, height=1.68mm)
  V57_DCP = cylinder(axis=Z, base_centre=(-16.5mm, 2.5mm, -1.44mm), radius=0.15mm, height=1.68mm)
  V58_DCP = cylinder(axis=Z, base_centre=(19.0115mm, -12.65mm, -1.44mm), radius=0.15mm, height=1.68mm)
  V59_DCP = cylinder(axis=Z, base_centre=(-17.8269mm, -12.65mm, -1.44mm), radius=0.15mm, height=1.68mm)
  V60_DCP = cylinder(axis=Z, base_centre=(4.85mm, -12.65mm, -1.44mm), radius=0.15mm, height=1.68mm)
  V61_DCP = cylinder(axis=Z, base_centre=(8.35mm, -12.65mm, -1.44mm), radius=0.15mm, height=1.68mm)
  V62_DCP = cylinder(axis=Z, base_centre=(3.65mm, -5.5mm, -1.44mm), radius=0.15mm, height=1.68mm)
  V63_DCP = cylinder(axis=Z, base_centre=(-24.9346mm, -5.5mm, -1.44mm), radius=0.15mm, height=1.68mm)
  V64_DCP = cylinder(axis=Z, base_centre=(-30.8577mm, -12.65mm, -1.44mm), radius=0.15mm, height=1.68mm)
  V65_DCP = cylinder(axis=Z, base_centre=(1.25mm, -12.65mm, -1.44mm), radius=0.15mm, height=1.68mm)
  V66_DCP = cylinder(axis=Z, base_centre=(15.4577mm, -12.65mm, -1.44mm), radius=0.15mm, height=1.68mm)
  V67_DCP = cylinder(axis=Z, base_centre=(-20.1962mm, -12.65mm, -1.44mm), radius=0.15mm, height=1.68mm)
  V68_DCP = cylinder(axis=Z, base_centre=(-29.2mm, 2.5mm, -1.44mm), radius=0.15mm, height=1.68mm)
  V69_DCP = cylinder(axis=Z, base_centre=(11.9038mm, -12.65mm, -1.44mm), radius=0.15mm, height=1.68mm)
  V70_DCP = cylinder(axis=Z, base_centre=(-4.75mm, -12.65mm, -1.44mm), radius=0.15mm, height=1.68mm)
  V71_DCP = cylinder(axis=Z, base_centre=(-31mm, 2.5mm, -1.44mm), radius=0.15mm, height=1.68mm)
  V72_DCP = cylinder(axis=Z, base_centre=(-8.35mm, -12.65mm, -1.44mm), radius=0.15mm, height=1.68mm)
  V73_DCP = cylinder(axis=Z, base_centre=(-32.8mm, 2.5mm, -1.44mm), radius=0.15mm, height=1.68mm)
  V74_DCP = cylinder(axis=Z, base_centre=(-28.4885mm, -12.65mm, -1.44mm), radius=0.15mm, height=1.68mm)
  V75_DCP = cylinder(axis=Z, base_centre=(-22.5654mm, -5.5mm, -1.44mm), radius=0.15mm, height=1.68mm)
  V76_DCP = cylinder(axis=Z, base_centre=(-4.75mm, -5.5mm, -1.44mm), radius=0.15mm, height=1.68mm)
  V77_DCP = cylinder(axis=Z, base_centre=(1.25mm, -5.5mm, -1.44mm), radius=0.15mm, height=1.68mm)
  V78_DCP = cylinder(axis=Z, base_centre=(31mm, 2.5mm, -1.44mm), radius=0.15mm, height=1.68mm)
  V79_DCP = cylinder(axis=Z, base_centre=(32.0423mm, -5.5mm, -1.44mm), radius=0.15mm, height=1.68mm)
  V80_DCP = cylinder(axis=Z, base_centre=(34.4115mm, -12.65mm, -1.44mm), radius=0.15mm, height=1.68mm)
  V81_DCP = cylinder(axis=Z, base_centre=(-27.3038mm, -5.5mm, -1.44mm), radius=0.15mm, height=1.68mm)
  V82_DCP = cylinder(axis=Z, base_centre=(11.9038mm, -5.5mm, -1.44mm), radius=0.15mm, height=1.68mm)
  V83_DCP = cylinder(axis=Z, base_centre=(22.5654mm, -12.65mm, -1.44mm), radius=0.15mm, height=1.68mm)
  V84_DCP = cylinder(axis=Z, base_centre=(-27.3038mm, -12.65mm, -1.44mm), radius=0.15mm, height=1.68mm)
  V85_DCP = cylinder(axis=Z, base_centre=(-22.5654mm, -12.65mm, -1.44mm), radius=0.15mm, height=1.68mm)
  V86_DCP = cylinder(axis=Z, base_centre=(-7.15mm, -5.5mm, -1.44mm), radius=0.15mm, height=1.68mm)
  V87_DCP = cylinder(axis=Z, base_centre=(-13.0885mm, -5.5mm, -1.44mm), radius=0.15mm, height=1.68mm)
  V88_DCP = cylinder(axis=Z, base_centre=(-21.3808mm, -5.5mm, -1.44mm), radius=0.15mm, height=1.68mm)
  V89_DCP = cylinder(axis=Z, base_centre=(-39.15mm, -12.65mm, -1.44mm), radius=0.15mm, height=1.68mm)
  V90_DCP = cylinder(axis=Z, base_centre=(-14.2731mm, -5.5mm, -1.44mm), radius=0.15mm, height=1.68mm)
  V91_DCP = cylinder(axis=Z, base_centre=(-11.9038mm, -12.65mm, -1.44mm), radius=0.15mm, height=1.68mm)
  V92_DCP = cylinder(axis=Z, base_centre=(-17.8269mm, -5.5mm, -1.44mm), radius=0.15mm, height=1.68mm)
  V93_DCP = cylinder(axis=Z, base_centre=(26.1192mm, -5.5mm, -1.44mm), radius=0.15mm, height=1.68mm)
  V94_DCP = cylinder(axis=Z, base_centre=(-15.4577mm, -5.5mm, -1.44mm), radius=0.15mm, height=1.68mm)
  V95_DCP = cylinder(axis=Z, base_centre=(-10.7192mm, -12.65mm, -1.44mm), radius=0.15mm, height=1.68mm)
  V96_DCP = cylinder(axis=Z, base_centre=(18.3mm, 2.5mm, -1.44mm), radius=0.15mm, height=1.68mm)
  V97_DCP = cylinder(axis=Z, base_centre=(-35.5962mm, -5.5mm, -1.44mm), radius=0.15mm, height=1.68mm)
  V98_DCP = cylinder(axis=Z, base_centre=(17.8269mm, -5.5mm, -1.44mm), radius=0.15mm, height=1.68mm)
  V99_DCP = cylinder(axis=Z, base_centre=(33.2269mm, -12.65mm, -1.44mm), radius=0.15mm, height=1.68mm)
  V100_DCP = cylinder(axis=Z, base_centre=(14.7mm, 2.5mm, -1.44mm), radius=0.15mm, height=1.68mm)
  V101_DCP = cylinder(axis=Z, base_centre=(34.4115mm, -5.5mm, -1.44mm), radius=0.15mm, height=1.68mm)
  V102_DCP = cylinder(axis=Z, base_centre=(2.45mm, -5.5mm, -1.44mm), radius=0.15mm, height=1.68mm)
  V103_DCP = cylinder(axis=Z, base_centre=(36.7808mm, -12.65mm, -1.44mm), radius=0.15mm, height=1.68mm)
  V104_DCP = cylinder(axis=Z, base_centre=(34.6mm, 2.5mm, -1.44mm), radius=0.15mm, height=1.68mm)
  V105_DCP = cylinder(axis=Z, base_centre=(6.05mm, -5.5mm, -1.44mm), radius=0.15mm, height=1.68mm)
  V106_DCP = cylinder(axis=Z, base_centre=(-10.7192mm, -5.5mm, -1.44mm), radius=0.15mm, height=1.68mm)
  V107_DCP = cylinder(axis=Z, base_centre=(-13.8mm, 2.5mm, -1.44mm), radius=0.15mm, height=1.68mm)
  V108_DCP = cylinder(axis=Z, base_centre=(10.7192mm, -5.5mm, -1.44mm), radius=0.15mm, height=1.68mm)
  V109_DCP = cylinder(axis=Z, base_centre=(30.1mm, 2.5mm, -1.44mm), radius=0.15mm, height=1.68mm)
  V110_DCP = cylinder(axis=Z, base_centre=(6.05mm, -12.65mm, -1.44mm), radius=0.15mm, height=1.68mm)
  V111_DCP = cylinder(axis=Z, base_centre=(-33.2269mm, -5.5mm, -1.44mm), radius=0.15mm, height=1.68mm)
  V112_DCP = cylinder(axis=Z, base_centre=(-1.15mm, -5.5mm, -1.44mm), radius=0.15mm, height=1.68mm)
  V113_DCP = cylinder(axis=Z, base_centre=(-20.1962mm, -5.5mm, -1.44mm), radius=0.15mm, height=1.68mm)
  V114_DCP = cylinder(axis=Z, base_centre=(23.75mm, -5.5mm, -1.44mm), radius=0.15mm, height=1.68mm)
  V115_DCP = cylinder(axis=Z, base_centre=(12.9mm, 2.5mm, -1.44mm), radius=0.15mm, height=1.68mm)
  V116_DCP = cylinder(axis=Z, base_centre=(-2.35mm, -5.5mm, -1.44mm), radius=0.15mm, height=1.68mm)
  V117_DCP = cylinder(axis=Z, base_centre=(39.15mm, -5.5mm, -1.44mm), radius=0.15mm, height=1.68mm)
  V118_DCP = cylinder(axis=Z, base_centre=(35.5962mm, -5.5mm, -1.44mm), radius=0.15mm, height=1.68mm)
  V119_DCP = cylinder(axis=Z, base_centre=(-28.4885mm, -5.5mm, -1.44mm), radius=0.15mm, height=1.68mm)
  V120_DCP = cylinder(axis=Z, base_centre=(-14.7mm, 2.5mm, -1.44mm), radius=0.15mm, height=1.68mm)
  V121_DCP = cylinder(axis=Z, base_centre=(28.4885mm, -12.65mm, -1.44mm), radius=0.15mm, height=1.68mm)
  V122_DCP = cylinder(axis=Z, base_centre=(33.2269mm, -5.5mm, -1.44mm), radius=0.15mm, height=1.68mm)
  V123_DCP = cylinder(axis=Z, base_centre=(-5.95mm, -5.5mm, -1.44mm), radius=0.15mm, height=1.68mm)
  V124_DCP = cylinder(axis=Z, base_centre=(21.3808mm, -12.65mm, -1.44mm), radius=0.15mm, height=1.68mm)
  V125_DCP = cylinder(axis=Z, base_centre=(-35.5mm, 2.5mm, -1.44mm), radius=0.15mm, height=1.68mm)
  V126_DCP = cylinder(axis=Z, base_centre=(17.4mm, 2.5mm, -1.44mm), radius=0.15mm, height=1.68mm)
  V127_DCP = cylinder(axis=Z, base_centre=(-34.6mm, 2.5mm, -1.44mm), radius=0.15mm, height=1.68mm)
  V128_DCP = cylinder(axis=Z, base_centre=(35.5mm, 2.5mm, -1.44mm), radius=0.15mm, height=1.68mm)
  V129_DCP = cylinder(axis=Z, base_centre=(0.05mm, -12.65mm, -1.44mm), radius=0.15mm, height=1.68mm)
  V130_DCP = cylinder(axis=Z, base_centre=(-36.7808mm, -12.65mm, -1.44mm), radius=0.15mm, height=1.68mm)
  V131_DCP = cylinder(axis=Z, base_centre=(16.5mm, 2.5mm, -1.44mm), radius=0.15mm, height=1.68mm)
  V132_DCP = cylinder(axis=Z, base_centre=(-21.3808mm, -12.65mm, -1.44mm), radius=0.15mm, height=1.68mm)
  V133_DCP = cylinder(axis=Z, base_centre=(-33.2269mm, -12.65mm, -1.44mm), radius=0.15mm, height=1.68mm)
  V134_DCP = cylinder(axis=Z, base_centre=(2.45mm, -12.65mm, -1.44mm), radius=0.15mm, height=1.68mm)
  V135_DCP = cylinder(axis=Z, base_centre=(-29.6731mm, -5.5mm, -1.44mm), radius=0.15mm, height=1.68mm)
  V136_DCP = cylinder(axis=Z, base_centre=(0.05mm, -5.5mm, -1.44mm), radius=0.15mm, height=1.68mm)
  V137_DCP = cylinder(axis=Z, base_centre=(39.15mm, -12.65mm, -1.44mm), radius=0.15mm, height=1.68mm)
  V138_DCP = cylinder(axis=Z, base_centre=(-30.1mm, 2.5mm, -1.44mm), radius=0.15mm, height=1.68mm)
  V139_DCP = cylinder(axis=Z, base_centre=(-37.9654mm, -5.5mm, -1.44mm), radius=0.15mm, height=1.68mm)
  V140_DCP = cylinder(axis=Z, base_centre=(-32.0423mm, -12.65mm, -1.44mm), radius=0.15mm, height=1.68mm)
  V141_DCP = cylinder(axis=Z, base_centre=(14.2731mm, -5.5mm, -1.44mm), radius=0.15mm, height=1.68mm)
  V142_DCP = cylinder(axis=Z, base_centre=(3.65mm, -12.65mm, -1.44mm), radius=0.15mm, height=1.68mm)
  V143_DCP = cylinder(axis=Z, base_centre=(9.5346mm, -5.5mm, -1.44mm), radius=0.15mm, height=1.68mm)
  V144_DCP = cylinder(axis=Z, base_centre=(15.4577mm, -5.5mm, -1.44mm), radius=0.15mm, height=1.68mm)
  V145_DCP = cylinder(axis=Z, base_centre=(20.1962mm, -12.65mm, -1.44mm), radius=0.15mm, height=1.68mm)
  V146_DCP = cylinder(axis=Z, base_centre=(-30.8577mm, -5.5mm, -1.44mm), radius=0.15mm, height=1.68mm)
  V147_DCP = cylinder(axis=Z, base_centre=(13.0885mm, -5.5mm, -1.44mm), radius=0.15mm, height=1.68mm)
  V148_DCP = cylinder(axis=Z, base_centre=(-33.7mm, 2.5mm, -1.44mm), radius=0.15mm, height=1.68mm)
  V149_DCP = cylinder(axis=Z, base_centre=(35.5962mm, -12.65mm, -1.44mm), radius=0.15mm, height=1.68mm)
  V150_DCP = cylinder(axis=Z, base_centre=(33.7mm, 2.5mm, -1.44mm), radius=0.15mm, height=1.68mm)
  V151_DCP = cylinder(axis=Z, base_centre=(-17.4mm, 2.5mm, -1.44mm), radius=0.15mm, height=1.68mm)
  V152_DCP = cylinder(axis=Z, base_centre=(23.75mm, -12.65mm, -1.44mm), radius=0.15mm, height=1.68mm)
  V153_DCP = cylinder(axis=Z, base_centre=(-3.55mm, -12.65mm, -1.44mm), radius=0.15mm, height=1.68mm)
  V154_DCP = cylinder(axis=Z, base_centre=(36.7808mm, -5.5mm, -1.44mm), radius=0.15mm, height=1.68mm)
  V155_DCP = cylinder(axis=Z, base_centre=(29.6731mm, -12.65mm, -1.44mm), radius=0.15mm, height=1.68mm)
  V156_DCP = cylinder(axis=Z, base_centre=(37.9654mm, -5.5mm, -1.44mm), radius=0.15mm, height=1.68mm)
  V157_DCP = cylinder(axis=Z, base_centre=(-9.5346mm, -12.65mm, -1.44mm), radius=0.15mm, height=1.68mm)
  V158_DCP = cylinder(axis=Z, base_centre=(-32.0423mm, -5.5mm, -1.44mm), radius=0.15mm, height=1.68mm)
  V159_DCP = cylinder(axis=Z, base_centre=(19.0115mm, -5.5mm, -1.44mm), radius=0.15mm, height=1.68mm)
  V160_DCP = cylinder(axis=Z, base_centre=(-39.15mm, -5.5mm, -1.44mm), radius=0.15mm, height=1.68mm)
  V161_DCP = cylinder(axis=Z, base_centre=(16.6423mm, -12.65mm, -1.44mm), radius=0.15mm, height=1.68mm)
  V162_DCP = cylinder(axis=Z, base_centre=(37.9654mm, -12.65mm, -1.44mm), radius=0.15mm, height=1.68mm)
  V163_DCP = cylinder(axis=Z, base_centre=(-5.95mm, -12.65mm, -1.44mm), radius=0.15mm, height=1.68mm)
  V164_DCN = cylinder(axis=Z, base_centre=(-20.1962mm, -10.75mm, -1.44mm), radius=0.15mm, height=1.68mm)
  V165_DCN = cylinder(axis=Z, base_centre=(29.6731mm, -10.75mm, -1.44mm), radius=0.15mm, height=1.68mm)
  V166_DCN = cylinder(axis=Z, base_centre=(-15.35mm, 14.1mm, -1.44mm), radius=0.15mm, height=1.68mm)
  V167_DCN = cylinder(axis=Z, base_centre=(11.9038mm, -10.75mm, -1.44mm), radius=0.15mm, height=1.68mm)
  V168_DCN = cylinder(axis=Z, base_centre=(22.5654mm, -10.75mm, -1.44mm), radius=0.15mm, height=1.68mm)
  V169_DCN = cylinder(axis=Z, base_centre=(-3.55mm, -10.75mm, -1.44mm), radius=0.15mm, height=1.68mm)
  V170_DCN = cylinder(axis=Z, base_centre=(33.2269mm, -0.5mm, -1.44mm), radius=0.15mm, height=1.68mm)
  V171_DCN = cylinder(axis=Z, base_centre=(35.15mm, 13.4mm, -1.44mm), radius=0.15mm, height=1.68mm)
  V172_DCN = cylinder(axis=Z, base_centre=(15.35mm, 15.5mm, -1.44mm), radius=0.15mm, height=1.68mm)
  V173_DCN = cylinder(axis=Z, base_centre=(-33.15mm, 15.5mm, -1.44mm), radius=0.15mm, height=1.68mm)
  V174_DCN = cylinder(axis=Z, base_centre=(-32.15mm, 13.4mm, -1.44mm), radius=0.15mm, height=1.68mm)
  V175_DCN = cylinder(axis=Z, base_centre=(39.15mm, 13.4mm, -1.44mm), radius=0.15mm, height=1.68mm)
  V176_DCN = cylinder(axis=Z, base_centre=(-22.5654mm, -10.75mm, -1.44mm), radius=0.15mm, height=1.68mm)
  V177_DCN = cylinder(axis=Z, base_centre=(30.8577mm, -10.75mm, -1.44mm), radius=0.15mm, height=1.68mm)
  V178_DCN = cylinder(axis=Z, base_centre=(-33.2269mm, -0.5mm, -1.44mm), radius=0.15mm, height=1.68mm)
  V179_DCN = cylinder(axis=Z, base_centre=(36.7808mm, -10.75mm, -1.44mm), radius=0.15mm, height=1.68mm)
  V180_DCN = cylinder(axis=Z, base_centre=(9.5346mm, -10.75mm, -1.44mm), radius=0.15mm, height=1.68mm)
  V181_DCN = cylinder(axis=Z, base_centre=(-31.15mm, 14.1mm, -1.44mm), radius=0.15mm, height=1.68mm)
  V182_DCN = cylinder(axis=Z, base_centre=(-17.35mm, 13.4mm, -1.44mm), radius=0.15mm, height=1.68mm)
  V183_DCN = cylinder(axis=Z, base_centre=(14.35mm, 15.5mm, -1.44mm), radius=0.15mm, height=1.68mm)
  V184_DCN = cylinder(axis=Z, base_centre=(-26.1192mm, -0.5mm, -1.44mm), radius=0.15mm, height=1.68mm)
  V185_DCN = cylinder(axis=Z, base_centre=(6.05mm, -10.75mm, -1.44mm), radius=0.15mm, height=1.68mm)
  V186_DCN = cylinder(axis=Z, base_centre=(-17.8269mm, -10.75mm, -1.44mm), radius=0.15mm, height=1.68mm)
  V187_DCN = cylinder(axis=Z, base_centre=(-32.15mm, 15.5mm, -1.44mm), radius=0.15mm, height=1.68mm)
  V188_DCN = cylinder(axis=Z, base_centre=(-19.0115mm, -0.5mm, -1.44mm), radius=0.15mm, height=1.68mm)
  V189_DCN = cylinder(axis=Z, base_centre=(-17.8269mm, -0.5mm, -1.44mm), radius=0.15mm, height=1.68mm)
  V190_DCN = cylinder(axis=Z, base_centre=(-34.15mm, 14.8mm, -1.44mm), radius=0.15mm, height=1.68mm)
  V191_DCN = cylinder(axis=Z, base_centre=(-29.6731mm, -0.5mm, -1.44mm), radius=0.15mm, height=1.68mm)
  V192_DCN = cylinder(axis=Z, base_centre=(18.35mm, 15.5mm, -1.44mm), radius=0.15mm, height=1.68mm)
  V193_DCN = cylinder(axis=Z, base_centre=(-37.9654mm, -0.5mm, -1.44mm), radius=0.15mm, height=1.68mm)
  V194_DCN = cylinder(axis=Z, base_centre=(-19.0115mm, -10.75mm, -1.44mm), radius=0.15mm, height=1.68mm)
  V195_DCN = cylinder(axis=Z, base_centre=(-41.15mm, 13.4mm, -1.44mm), radius=0.15mm, height=1.68mm)
  V196_DCN = cylinder(axis=Z, base_centre=(-15.35mm, 14.8mm, -1.44mm), radius=0.15mm, height=1.68mm)
  V197_DCN = cylinder(axis=Z, base_centre=(7.35mm, 13.4mm, -1.44mm), radius=0.15mm, height=1.68mm)
  V198_DCN = cylinder(axis=Z, base_centre=(31.15mm, 13.4mm, -1.44mm), radius=0.15mm, height=1.68mm)
  V199_DCN = cylinder(axis=Z, base_centre=(-34.15mm, 13.4mm, -1.44mm), radius=0.15mm, height=1.68mm)
  V200_DCN = cylinder(axis=Z, base_centre=(33.15mm, 14.1mm, -1.44mm), radius=0.15mm, height=1.68mm)
  V201_DCN = cylinder(axis=Z, base_centre=(10.7192mm, -0.5mm, -1.44mm), radius=0.15mm, height=1.68mm)
  V202_DCN = cylinder(axis=Z, base_centre=(-36.7808mm, -10.75mm, -1.44mm), radius=0.15mm, height=1.68mm)
  V203_DCN = cylinder(axis=Z, base_centre=(0.05mm, -10.75mm, -1.44mm), radius=0.15mm, height=1.68mm)
  V204_DCN = cylinder(axis=Z, base_centre=(-34.4115mm, -10.75mm, -1.44mm), radius=0.15mm, height=1.68mm)
  V205_DCN = cylinder(axis=Z, base_centre=(-8.35mm, 13.4mm, -1.44mm), radius=0.15mm, height=1.68mm)
  V206_DCN = cylinder(axis=Z, base_centre=(16.35mm, 13.4mm, -1.44mm), radius=0.15mm, height=1.68mm)
  V207_DCN = cylinder(axis=Z, base_centre=(-4.75mm, -0.5mm, -1.44mm), radius=0.15mm, height=1.68mm)
  V208_DCN = cylinder(axis=Z, base_centre=(-11.35mm, 13.4mm, -1.44mm), radius=0.15mm, height=1.68mm)
  V209_DCN = cylinder(axis=Z, base_centre=(11.35mm, 13.4mm, -1.44mm), radius=0.15mm, height=1.68mm)
  V210_DCN = cylinder(axis=Z, base_centre=(-34.15mm, 15.5mm, -1.44mm), radius=0.15mm, height=1.68mm)
  V211_DCN = cylinder(axis=Z, base_centre=(34.15mm, 13.4mm, -1.44mm), radius=0.15mm, height=1.68mm)
  V212_DCN = cylinder(axis=Z, base_centre=(-8.35mm, -10.75mm, -1.44mm), radius=0.15mm, height=1.68mm)
  V213_DCN = cylinder(axis=Z, base_centre=(-5.95mm, -10.75mm, -1.44mm), radius=0.15mm, height=1.68mm)
  V214_DCN = cylinder(axis=Z, base_centre=(28.4885mm, -0.5mm, -1.44mm), radius=0.15mm, height=1.68mm)
  V215_DCN = cylinder(axis=Z, base_centre=(14.2731mm, -10.75mm, -1.44mm), radius=0.15mm, height=1.68mm)
  V216_DCN = cylinder(axis=Z, base_centre=(31.15mm, 14.1mm, -1.44mm), radius=0.15mm, height=1.68mm)
  V217_DCN = cylinder(axis=Z, base_centre=(-13.35mm, 13.4mm, -1.44mm), radius=0.15mm, height=1.68mm)
  V218_DCN = cylinder(axis=Z, base_centre=(17.35mm, 15.5mm, -1.44mm), radius=0.15mm, height=1.68mm)
  V219_DCN = cylinder(axis=Z, base_centre=(34.15mm, 14.8mm, -1.44mm), radius=0.15mm, height=1.68mm)
  V220_DCN = cylinder(axis=Z, base_centre=(-29.15mm, 13.4mm, -1.44mm), radius=0.15mm, height=1.68mm)
  V221_DCN = cylinder(axis=Z, base_centre=(1.25mm, -0.5mm, -1.44mm), radius=0.15mm, height=1.68mm)
  V222_DCN = cylinder(axis=Z, base_centre=(-33.15mm, 13.4mm, -1.44mm), radius=0.15mm, height=1.68mm)
  V223_DCN = cylinder(axis=Z, base_centre=(30.15mm, 13.4mm, -1.44mm), radius=0.15mm, height=1.68mm)
  V224_DCN = cylinder(axis=Z, base_centre=(-5.35mm, 13.4mm, -1.44mm), radius=0.15mm, height=1.68mm)
  V225_DCN = cylinder(axis=Z, base_centre=(11.9038mm, -0.5mm, -1.44mm), radius=0.15mm, height=1.68mm)
  V226_DCN = cylinder(axis=Z, base_centre=(8.35mm, -10.75mm, -1.44mm), radius=0.15mm, height=1.68mm)
  V227_DCN = cylinder(axis=Z, base_centre=(-26.1192mm, -10.75mm, -1.44mm), radius=0.15mm, height=1.68mm)
  V228_DCN = cylinder(axis=Z, base_centre=(18.35mm, 14.8mm, -1.44mm), radius=0.15mm, height=1.68mm)
  V229_DCN = cylinder(axis=Z, base_centre=(29.15mm, 14.8mm, -1.44mm), radius=0.15mm, height=1.68mm)
  V230_DCN = cylinder(axis=Z, base_centre=(19.0115mm, -0.5mm, -1.44mm), radius=0.15mm, height=1.68mm)
  V231_DCN = cylinder(axis=Z, base_centre=(-2.35mm, -10.75mm, -1.44mm), radius=0.15mm, height=1.68mm)
  V232_DCN = cylinder(axis=Z, base_centre=(10.7192mm, -10.75mm, -1.44mm), radius=0.15mm, height=1.68mm)
  V233_DCN = cylinder(axis=Z, base_centre=(-8.35mm, -0.5mm, -1.44mm), radius=0.15mm, height=1.68mm)
  V234_DCN = cylinder(axis=Z, base_centre=(-11.35mm, 14.1mm, -1.44mm), radius=0.15mm, height=1.68mm)
  V235_DCN = cylinder(axis=Z, base_centre=(12.35mm, 13.4mm, -1.44mm), radius=0.15mm, height=1.68mm)
  V236_DCN = cylinder(axis=Z, base_centre=(12.35mm, 14.1mm, -1.44mm), radius=0.15mm, height=1.68mm)
  V237_DCN = cylinder(axis=Z, base_centre=(-14.35mm, 14.1mm, -1.44mm), radius=0.15mm, height=1.68mm)
  V238_DCN = cylinder(axis=Z, base_centre=(-23.75mm, -10.75mm, -1.44mm), radius=0.15mm, height=1.68mm)
  V239_DCN = cylinder(axis=Z, base_centre=(-40.15mm, 13.4mm, -1.44mm), radius=0.15mm, height=1.68mm)
  V240_DCN = cylinder(axis=Z, base_centre=(-6.35mm, 13.4mm, -1.44mm), radius=0.15mm, height=1.68mm)
  V241_DCN = cylinder(axis=Z, base_centre=(-33.15mm, 14.8mm, -1.44mm), radius=0.15mm, height=1.68mm)
  V242_DCN = cylinder(axis=Z, base_centre=(36.15mm, 14.8mm, -1.44mm), radius=0.15mm, height=1.68mm)
  V243_DCN = cylinder(axis=Z, base_centre=(22.5654mm, -0.5mm, -1.44mm), radius=0.15mm, height=1.68mm)
  V244_DCN = cylinder(axis=Z, base_centre=(20.1962mm, -0.5mm, -1.44mm), radius=0.15mm, height=1.68mm)
  V245_DCN = cylinder(axis=Z, base_centre=(8.35mm, -0.5mm, -1.44mm), radius=0.15mm, height=1.68mm)
  V246_DCN = cylinder(axis=Z, base_centre=(14.35mm, 14.1mm, -1.44mm), radius=0.15mm, height=1.68mm)
  V247_DCN = cylinder(axis=Z, base_centre=(-30.15mm, 15.5mm, -1.44mm), radius=0.15mm, height=1.68mm)
  V248_DCN = cylinder(axis=Z, base_centre=(39.15mm, -0.5mm, -1.44mm), radius=0.15mm, height=1.68mm)
  V249_DCN = cylinder(axis=Z, base_centre=(6.35mm, 13.4mm, -1.44mm), radius=0.15mm, height=1.68mm)
  V250_DCN = cylinder(axis=Z, base_centre=(-14.2731mm, -0.5mm, -1.44mm), radius=0.15mm, height=1.68mm)
  V251_DCN = cylinder(axis=Z, base_centre=(30.8577mm, -0.5mm, -1.44mm), radius=0.15mm, height=1.68mm)
  V252_DCN = cylinder(axis=Z, base_centre=(29.15mm, 13.4mm, -1.44mm), radius=0.15mm, height=1.68mm)
  V253_DCN = cylinder(axis=Z, base_centre=(-10.7192mm, -0.5mm, -1.44mm), radius=0.15mm, height=1.68mm)
  V254_DCN = cylinder(axis=Z, base_centre=(32.0423mm, -0.5mm, -1.44mm), radius=0.15mm, height=1.68mm)
  V255_DCN = cylinder(axis=Z, base_centre=(16.6423mm, -10.75mm, -1.44mm), radius=0.15mm, height=1.68mm)
  V256_DCN = cylinder(axis=Z, base_centre=(15.4577mm, -10.75mm, -1.44mm), radius=0.15mm, height=1.68mm)
  V257_DCN = cylinder(axis=Z, base_centre=(26.1192mm, -10.75mm, -1.44mm), radius=0.15mm, height=1.68mm)
  V258_DCN = cylinder(axis=Z, base_centre=(30.15mm, 14.1mm, -1.44mm), radius=0.15mm, height=1.68mm)
  V259_DCN = cylinder(axis=Z, base_centre=(-12.35mm, 13.4mm, -1.44mm), radius=0.15mm, height=1.68mm)
  V260_DCN = cylinder(axis=Z, base_centre=(13.0885mm, -0.5mm, -1.44mm), radius=0.15mm, height=1.68mm)
  V261_DCN = cylinder(axis=Z, base_centre=(12.35mm, 19.75mm, -1.44mm), radius=0.15mm, height=1.68mm)
  V262_DCN = cylinder(axis=Z, base_centre=(6.05mm, -0.5mm, -1.44mm), radius=0.15mm, height=1.68mm)
  V263_DCN = cylinder(axis=Z, base_centre=(4.85mm, -10.75mm, -1.44mm), radius=0.15mm, height=1.68mm)
  V264_DCN = cylinder(axis=Z, base_centre=(17.8269mm, -0.5mm, -1.44mm), radius=0.15mm, height=1.68mm)
  V265_DCN = cylinder(axis=Z, base_centre=(35.5962mm, -0.5mm, -1.44mm), radius=0.15mm, height=1.68mm)
  V266_DCN = cylinder(axis=Z, base_centre=(-31.15mm, 15.5mm, -1.44mm), radius=0.15mm, height=1.68mm)
  V267_DCN = cylinder(axis=Z, base_centre=(-13.35mm, 14.8mm, -1.44mm), radius=0.15mm, height=1.68mm)
  V268_DCN = cylinder(axis=Z, base_centre=(29.6731mm, -0.5mm, -1.44mm), radius=0.15mm, height=1.68mm)
  V269_DCN = cylinder(axis=Z, base_centre=(-37.9654mm, -10.75mm, -1.44mm), radius=0.15mm, height=1.68mm)
  V270_DCN = cylinder(axis=Z, base_centre=(13.35mm, 15.5mm, -1.44mm), radius=0.15mm, height=1.68mm)
  V271_DCN = cylinder(axis=Z, base_centre=(-16.35mm, 13.4mm, -1.44mm), radius=0.15mm, height=1.68mm)
  V272_DCN = cylinder(axis=Z, base_centre=(19.0115mm, -10.75mm, -1.44mm), radius=0.15mm, height=1.68mm)
  V273_DCN = cylinder(axis=Z, base_centre=(-16.6423mm, -0.5mm, -1.44mm), radius=0.15mm, height=1.68mm)
  V274_DCN = cylinder(axis=Z, base_centre=(-9.5346mm, -0.5mm, -1.44mm), radius=0.15mm, height=1.68mm)
  V275_DCN = cylinder(axis=Z, base_centre=(-22.5654mm, -0.5mm, -1.44mm), radius=0.15mm, height=1.68mm)
  V276_DCN = cylinder(axis=Z, base_centre=(-35.15mm, 14.8mm, -1.44mm), radius=0.15mm, height=1.68mm)
  V277_DCN = cylinder(axis=Z, base_centre=(33.2269mm, -10.75mm, -1.44mm), radius=0.15mm, height=1.68mm)
  V278_DCN = cylinder(axis=Z, base_centre=(-29.15mm, 15.5mm, -1.44mm), radius=0.15mm, height=1.68mm)
  V279_DCN = cylinder(axis=Z, base_centre=(23.75mm, -0.5mm, -1.44mm), radius=0.15mm, height=1.68mm)
  V280_DCN = cylinder(axis=Z, base_centre=(39.15mm, -10.75mm, -1.44mm), radius=0.15mm, height=1.68mm)
  V281_DCN = cylinder(axis=Z, base_centre=(-23.75mm, -0.5mm, -1.44mm), radius=0.15mm, height=1.68mm)
  V282_DCN = cylinder(axis=Z, base_centre=(2.45mm, -10.75mm, -1.44mm), radius=0.15mm, height=1.68mm)
  V283_DCN = cylinder(axis=Z, base_centre=(31.15mm, 15.5mm, -1.44mm), radius=0.15mm, height=1.68mm)
  V284_DCN = cylinder(axis=Z, base_centre=(35.15mm, 14.8mm, -1.44mm), radius=0.15mm, height=1.68mm)
  V285_DCN = cylinder(axis=Z, base_centre=(5.35mm, 13.4mm, -1.44mm), radius=0.15mm, height=1.68mm)
  V286_DCN = cylinder(axis=Z, base_centre=(-18.35mm, 14.8mm, -1.44mm), radius=0.15mm, height=1.68mm)
  V287_DCN = cylinder(axis=Z, base_centre=(20.1962mm, -10.75mm, -1.44mm), radius=0.15mm, height=1.68mm)
  V288_DCN = cylinder(axis=Z, base_centre=(-7.15mm, -0.5mm, -1.44mm), radius=0.15mm, height=1.68mm)
  V289_DCN = cylinder(axis=Z, base_centre=(-7.15mm, -10.75mm, -1.44mm), radius=0.15mm, height=1.68mm)
  V290_DCN = cylinder(axis=Z, base_centre=(-35.15mm, 14.1mm, -1.44mm), radius=0.15mm, height=1.68mm)
  V291_DCN = cylinder(axis=Z, base_centre=(-17.35mm, 15.5mm, -1.44mm), radius=0.15mm, height=1.68mm)
  V292_DCN = cylinder(axis=Z, base_centre=(13.35mm, 14.8mm, -1.44mm), radius=0.15mm, height=1.68mm)
  V293_DCN = cylinder(axis=Z, base_centre=(-11.35mm, 14.8mm, -1.44mm), radius=0.15mm, height=1.68mm)
  V294_DCN = cylinder(axis=Z, base_centre=(32.15mm, 15.5mm, -1.44mm), radius=0.15mm, height=1.68mm)
  V295_DCN = cylinder(axis=Z, base_centre=(15.35mm, 14.8mm, -1.44mm), radius=0.15mm, height=1.68mm)
  V296_DCN = cylinder(axis=Z, base_centre=(-35.15mm, 13.4mm, -1.44mm), radius=0.15mm, height=1.68mm)
  V297_DCN = cylinder(axis=Z, base_centre=(-39.15mm, 13.4mm, -1.44mm), radius=0.15mm, height=1.68mm)
  V298_DCN = cylinder(axis=Z, base_centre=(0.05mm, -0.5mm, -1.44mm), radius=0.15mm, height=1.68mm)
  V299_DCN = cylinder(axis=Z, base_centre=(-36.15mm, 14.1mm, -1.44mm), radius=0.15mm, height=1.68mm)
  V300_DCN = cylinder(axis=Z, base_centre=(-18.35mm, 13.4mm, -1.44mm), radius=0.15mm, height=1.68mm)
  V301_DCN = cylinder(axis=Z, base_centre=(-18.35mm, 14.1mm, -1.44mm), radius=0.15mm, height=1.68mm)
  V302_DCN = cylinder(axis=Z, base_centre=(16.35mm, 14.1mm, -1.44mm), radius=0.15mm, height=1.68mm)
  V303_DCN = cylinder(axis=Z, base_centre=(24.9346mm, -0.5mm, -1.44mm), radius=0.15mm, height=1.68mm)
  V304_DCN = cylinder(axis=Z, base_centre=(-18.35mm, 15.5mm, -1.44mm), radius=0.15mm, height=1.68mm)
  V305_DCN = cylinder(axis=Z, base_centre=(-12.35mm, 19mm, -1.44mm), radius=0.15mm, height=1.68mm)
  V306_DCN = cylinder(axis=Z, base_centre=(9.35mm, 13.4mm, -1.44mm), radius=0.15mm, height=1.68mm)
  V307_DCN = cylinder(axis=Z, base_centre=(-35.5962mm, -10.75mm, -1.44mm), radius=0.15mm, height=1.68mm)
  V308_DCN = cylinder(axis=Z, base_centre=(12.35mm, 15.5mm, -1.44mm), radius=0.15mm, height=1.68mm)
  V309_DCN = cylinder(axis=Z, base_centre=(17.35mm, 14.1mm, -1.44mm), radius=0.15mm, height=1.68mm)
  V310_DCN = cylinder(axis=Z, base_centre=(-24.9346mm, -0.5mm, -1.44mm), radius=0.15mm, height=1.68mm)
  V311_DCN = cylinder(axis=Z, base_centre=(33.15mm, 14.8mm, -1.44mm), radius=0.15mm, height=1.68mm)
  V312_DCN = cylinder(axis=Z, base_centre=(37.9654mm, -0.5mm, -1.44mm), radius=0.15mm, height=1.68mm)
  V313_DCN = cylinder(axis=Z, base_centre=(9.5346mm, -0.5mm, -1.44mm), radius=0.15mm, height=1.68mm)
  V314_DCN = cylinder(axis=Z, base_centre=(-14.35mm, 13.4mm, -1.44mm), radius=0.15mm, height=1.68mm)
  V315_DCN = cylinder(axis=Z, base_centre=(-36.7808mm, -0.5mm, -1.44mm), radius=0.15mm, height=1.68mm)
  V316_DCN = cylinder(axis=Z, base_centre=(3.65mm, -0.5mm, -1.44mm), radius=0.15mm, height=1.68mm)
  V317_DCN = cylinder(axis=Z, base_centre=(29.15mm, 15.5mm, -1.44mm), radius=0.15mm, height=1.68mm)
  V318_DCN = cylinder(axis=Z, base_centre=(34.15mm, 14.1mm, -1.44mm), radius=0.15mm, height=1.68mm)
  V319_DCN = cylinder(axis=Z, base_centre=(12.35mm, 14.8mm, -1.44mm), radius=0.15mm, height=1.68mm)
  V320_DCN = cylinder(axis=Z, base_centre=(33.15mm, 13.4mm, -1.44mm), radius=0.15mm, height=1.68mm)
  V321_DCN = cylinder(axis=Z, base_centre=(-30.15mm, 14.8mm, -1.44mm), radius=0.15mm, height=1.68mm)
  V322_DCN = cylinder(axis=Z, base_centre=(17.8269mm, -10.75mm, -1.44mm), radius=0.15mm, height=1.68mm)
  V323_DCN = cylinder(axis=Z, base_centre=(-35.15mm, 19mm, -1.44mm), radius=0.15mm, height=1.68mm)
  V324_DCN = cylinder(axis=Z, base_centre=(-1.15mm, -0.5mm, -1.44mm), radius=0.15mm, height=1.68mm)
  V325_DCN = cylinder(axis=Z, base_centre=(-13.35mm, 14.1mm, -1.44mm), radius=0.15mm, height=1.68mm)
  V326_DCN = cylinder(axis=Z, base_centre=(29.15mm, 14.1mm, -1.44mm), radius=0.15mm, height=1.68mm)
  V327_DCN = cylinder(axis=Z, base_centre=(-32.15mm, 14.1mm, -1.44mm), radius=0.15mm, height=1.68mm)
  V328_DCN = cylinder(axis=Z, base_centre=(-11.9038mm, -10.75mm, -1.44mm), radius=0.15mm, height=1.68mm)
  V329_DCN = cylinder(axis=Z, base_centre=(-36.15mm, 14.8mm, -1.44mm), radius=0.15mm, height=1.68mm)
  V330_DCN = cylinder(axis=Z, base_centre=(-35.5962mm, -0.5mm, -1.44mm), radius=0.15mm, height=1.68mm)
  V331_DCN = cylinder(axis=Z, base_centre=(18.35mm, 14.1mm, -1.44mm), radius=0.15mm, height=1.68mm)
  V332_DCN = cylinder(axis=Z, base_centre=(-27.3038mm, -0.5mm, -1.44mm), radius=0.15mm, height=1.68mm)
  V333_DCN = cylinder(axis=Z, base_centre=(-24.9346mm, -10.75mm, -1.44mm), radius=0.15mm, height=1.68mm)
  V334_DCN = cylinder(axis=Z, base_centre=(-21.3808mm, -10.75mm, -1.44mm), radius=0.15mm, height=1.68mm)
  V335_DCN = cylinder(axis=Z, base_centre=(-34.4115mm, -0.5mm, -1.44mm), radius=0.15mm, height=1.68mm)
  V336_DCN = cylinder(axis=Z, base_centre=(-39.15mm, -0.5mm, -1.44mm), radius=0.15mm, height=1.68mm)
  V337_DCN = cylinder(axis=Z, base_centre=(15.35mm, 14.1mm, -1.44mm), radius=0.15mm, height=1.68mm)
  V338_DCN = cylinder(axis=Z, base_centre=(-14.35mm, 14.8mm, -1.44mm), radius=0.15mm, height=1.68mm)
  V339_DCN = cylinder(axis=Z, base_centre=(15.35mm, 13.4mm, -1.44mm), radius=0.15mm, height=1.68mm)
  V340_DCN = cylinder(axis=Z, base_centre=(-16.35mm, 15.5mm, -1.44mm), radius=0.15mm, height=1.68mm)
  V341_DCN = cylinder(axis=Z, base_centre=(-12.35mm, 15.5mm, -1.44mm), radius=0.15mm, height=1.68mm)
  V342_DCN = cylinder(axis=Z, base_centre=(-16.35mm, 14.8mm, -1.44mm), radius=0.15mm, height=1.68mm)
  V343_DCN = cylinder(axis=Z, base_centre=(14.2731mm, -0.5mm, -1.44mm), radius=0.15mm, height=1.68mm)
  V344_DCN = cylinder(axis=Z, base_centre=(-30.8577mm, -10.75mm, -1.44mm), radius=0.15mm, height=1.68mm)
  V345_DCN = cylinder(axis=Z, base_centre=(33.15mm, 15.5mm, -1.44mm), radius=0.15mm, height=1.68mm)
  V346_DCN = cylinder(axis=Z, base_centre=(8.35mm, 13.4mm, -1.44mm), radius=0.15mm, height=1.68mm)
  V347_DCN = cylinder(axis=Z, base_centre=(11.35mm, 14.8mm, -1.44mm), radius=0.15mm, height=1.68mm)
  V348_DCN = cylinder(axis=Z, base_centre=(36.15mm, 14.1mm, -1.44mm), radius=0.15mm, height=1.68mm)
  V349_DCN = cylinder(axis=Z, base_centre=(27.3038mm, -0.5mm, -1.44mm), radius=0.15mm, height=1.68mm)
  V350_DCN = cylinder(axis=Z, base_centre=(18.35mm, 13.4mm, -1.44mm), radius=0.15mm, height=1.68mm)
  V351_DCN = cylinder(axis=Z, base_centre=(41.15mm, 13.4mm, -1.44mm), radius=0.15mm, height=1.68mm)
  V352_DCN = cylinder(axis=Z, base_centre=(-33.2269mm, -10.75mm, -1.44mm), radius=0.15mm, height=1.68mm)
  V353_DCN = cylinder(axis=Z, base_centre=(-39.15mm, -10.75mm, -1.44mm), radius=0.15mm, height=1.68mm)
  V354_DCN = cylinder(axis=Z, base_centre=(-32.0423mm, -10.75mm, -1.44mm), radius=0.15mm, height=1.68mm)
  V355_DCN = cylinder(axis=Z, base_centre=(-10.7192mm, -10.75mm, -1.44mm), radius=0.15mm, height=1.68mm)
  V356_DCN = cylinder(axis=Z, base_centre=(21.3808mm, -0.5mm, -1.44mm), radius=0.15mm, height=1.68mm)
  V357_DCN = cylinder(axis=Z, base_centre=(-36.15mm, 13.4mm, -1.44mm), radius=0.15mm, height=1.68mm)
  V358_DCN = cylinder(axis=Z, base_centre=(-15.4577mm, -10.75mm, -1.44mm), radius=0.15mm, height=1.68mm)
  V359_DCN = cylinder(axis=Z, base_centre=(28.4885mm, -10.75mm, -1.44mm), radius=0.15mm, height=1.68mm)
  V360_DCN = cylinder(axis=Z, base_centre=(-16.35mm, 14.1mm, -1.44mm), radius=0.15mm, height=1.68mm)
  V361_DCN = cylinder(axis=Z, base_centre=(-12.35mm, 14.8mm, -1.44mm), radius=0.15mm, height=1.68mm)
  V362_DCN = cylinder(axis=Z, base_centre=(2.45mm, -0.5mm, -1.44mm), radius=0.15mm, height=1.68mm)
  V363_DCN = cylinder(axis=Z, base_centre=(-32.0423mm, -0.5mm, -1.44mm), radius=0.15mm, height=1.68mm)
  V364_DCN = cylinder(axis=Z, base_centre=(-15.4577mm, -0.5mm, -1.44mm), radius=0.15mm, height=1.68mm)
  V365_DCN = cylinder(axis=Z, base_centre=(-9.5346mm, -10.75mm, -1.44mm), radius=0.15mm, height=1.68mm)
  V366_DCN = cylinder(axis=Z, base_centre=(27.3038mm, -10.75mm, -1.44mm), radius=0.15mm, height=1.68mm)
  V367_DCN = cylinder(axis=Z, base_centre=(35.15mm, 15.5mm, -1.44mm), radius=0.15mm, height=1.68mm)
  V368_DCN = cylinder(axis=Z, base_centre=(14.35mm, 14.8mm, -1.44mm), radius=0.15mm, height=1.68mm)
  V369_DCN = cylinder(axis=Z, base_centre=(17.35mm, 14.8mm, -1.44mm), radius=0.15mm, height=1.68mm)
  V370_DCN = cylinder(axis=Z, base_centre=(-2.35mm, -0.5mm, -1.44mm), radius=0.15mm, height=1.68mm)
  V371_DCN = cylinder(axis=Z, base_centre=(37.9654mm, -10.75mm, -1.44mm), radius=0.15mm, height=1.68mm)
  V372_DCN = cylinder(axis=Z, base_centre=(-29.15mm, 14.1mm, -1.44mm), radius=0.15mm, height=1.68mm)
  V373_DCN = cylinder(axis=Z, base_centre=(-35.15mm, 19.75mm, -1.44mm), radius=0.15mm, height=1.68mm)
  V374_DCN = cylinder(axis=Z, base_centre=(-20.1962mm, -0.5mm, -1.44mm), radius=0.15mm, height=1.68mm)
  V375_DCN = cylinder(axis=Z, base_centre=(-17.35mm, 14.8mm, -1.44mm), radius=0.15mm, height=1.68mm)
  V376_DCN = cylinder(axis=Z, base_centre=(-13.0885mm, -10.75mm, -1.44mm), radius=0.15mm, height=1.68mm)
  V377_DCN = cylinder(axis=Z, base_centre=(-13.35mm, 15.5mm, -1.44mm), radius=0.15mm, height=1.68mm)
  V378_DCN = cylinder(axis=Z, base_centre=(-13.0885mm, -0.5mm, -1.44mm), radius=0.15mm, height=1.68mm)
  V379_DCN = cylinder(axis=Z, base_centre=(-42.15mm, 13.4mm, -1.44mm), radius=0.15mm, height=1.68mm)
  V380_DCN = cylinder(axis=Z, base_centre=(16.35mm, 14.8mm, -1.44mm), radius=0.15mm, height=1.68mm)
  V381_DCN = cylinder(axis=Z, base_centre=(42.15mm, 13.4mm, -1.44mm), radius=0.15mm, height=1.68mm)
  V382_DCN = cylinder(axis=Z, base_centre=(16.35mm, 15.5mm, -1.44mm), radius=0.15mm, height=1.68mm)
  V383_DCN = cylinder(axis=Z, base_centre=(11.35mm, 14.1mm, -1.44mm), radius=0.15mm, height=1.68mm)
  V384_DCN = cylinder(axis=Z, base_centre=(36.7808mm, -0.5mm, -1.44mm), radius=0.15mm, height=1.68mm)
  V385_DCN = cylinder(axis=Z, base_centre=(-38.15mm, 13.4mm, -1.44mm), radius=0.15mm, height=1.68mm)
  V386_DCN = cylinder(axis=Z, base_centre=(-30.15mm, 13.4mm, -1.44mm), radius=0.15mm, height=1.68mm)
  V387_DCN = cylinder(axis=Z, base_centre=(-14.35mm, 15.5mm, -1.44mm), radius=0.15mm, height=1.68mm)
  V388_DCN = cylinder(axis=Z, base_centre=(31.15mm, 14.8mm, -1.44mm), radius=0.15mm, height=1.68mm)
  V389_DCN = cylinder(axis=Z, base_centre=(-17.35mm, 14.1mm, -1.44mm), radius=0.15mm, height=1.68mm)
  V390_DCN = cylinder(axis=Z, base_centre=(-15.35mm, 13.4mm, -1.44mm), radius=0.15mm, height=1.68mm)
  V391_DCN = cylinder(axis=Z, base_centre=(-28.4885mm, -0.5mm, -1.44mm), radius=0.15mm, height=1.68mm)
  V392_DCN = cylinder(axis=Z, base_centre=(38.15mm, 13.4mm, -1.44mm), radius=0.15mm, height=1.68mm)
  V393_DCN = cylinder(axis=Z, base_centre=(-16.6423mm, -10.75mm, -1.44mm), radius=0.15mm, height=1.68mm)
  V394_DCN = cylinder(axis=Z, base_centre=(-7.35mm, 13.4mm, -1.44mm), radius=0.15mm, height=1.68mm)
  V395_DCN = cylinder(axis=Z, base_centre=(-21.3808mm, -0.5mm, -1.44mm), radius=0.15mm, height=1.68mm)
  V396_DCN = cylinder(axis=Z, base_centre=(36.15mm, 15.5mm, -1.44mm), radius=0.15mm, height=1.68mm)
  V397_DCN = cylinder(axis=Z, base_centre=(15.4577mm, -0.5mm, -1.44mm), radius=0.15mm, height=1.68mm)
  V398_DCN = cylinder(axis=Z, base_centre=(-29.15mm, 14.8mm, -1.44mm), radius=0.15mm, height=1.68mm)
  V399_DCN = cylinder(axis=Z, base_centre=(34.15mm, 15.5mm, -1.44mm), radius=0.15mm, height=1.68mm)
  V400_DCN = cylinder(axis=Z, base_centre=(-35.15mm, 15.5mm, -1.44mm), radius=0.15mm, height=1.68mm)
  V401_DCN = cylinder(axis=Z, base_centre=(32.15mm, 14.8mm, -1.44mm), radius=0.15mm, height=1.68mm)
  V402_DCN = cylinder(axis=Z, base_centre=(-31.15mm, 14.8mm, -1.44mm), radius=0.15mm, height=1.68mm)
  V403_DCN = cylinder(axis=Z, base_centre=(3.65mm, -10.75mm, -1.44mm), radius=0.15mm, height=1.68mm)
  V404_DCN = cylinder(axis=Z, base_centre=(-15.35mm, 15.5mm, -1.44mm), radius=0.15mm, height=1.68mm)
  V405_DCN = cylinder(axis=Z, base_centre=(26.1192mm, -0.5mm, -1.44mm), radius=0.15mm, height=1.68mm)
  V406_DCN = cylinder(axis=Z, base_centre=(-11.9038mm, -0.5mm, -1.44mm), radius=0.15mm, height=1.68mm)
  V407_DCN = cylinder(axis=Z, base_centre=(13.35mm, 13.4mm, -1.44mm), radius=0.15mm, height=1.68mm)
  V408_DCN = cylinder(axis=Z, base_centre=(-14.2731mm, -10.75mm, -1.44mm), radius=0.15mm, height=1.68mm)
  V409_DCN = cylinder(axis=Z, base_centre=(32.15mm, 14.1mm, -1.44mm), radius=0.15mm, height=1.68mm)
  V410_DCN = cylinder(axis=Z, base_centre=(13.35mm, 14.1mm, -1.44mm), radius=0.15mm, height=1.68mm)
  V411_DCN = cylinder(axis=Z, base_centre=(-34.15mm, 14.1mm, -1.44mm), radius=0.15mm, height=1.68mm)
  V412_DCN = cylinder(axis=Z, base_centre=(21.3808mm, -10.75mm, -1.44mm), radius=0.15mm, height=1.68mm)
  V413_DCN = cylinder(axis=Z, base_centre=(12.35mm, 19mm, -1.44mm), radius=0.15mm, height=1.68mm)
  V414_DCN = cylinder(axis=Z, base_centre=(30.15mm, 14.8mm, -1.44mm), radius=0.15mm, height=1.68mm)
  V415_DCN = cylinder(axis=Z, base_centre=(34.4115mm, -10.75mm, -1.44mm), radius=0.15mm, height=1.68mm)
  V416_DCN = cylinder(axis=Z, base_centre=(-9.35mm, 13.4mm, -1.44mm), radius=0.15mm, height=1.68mm)
  V417_DCN = cylinder(axis=Z, base_centre=(34.4115mm, -0.5mm, -1.44mm), radius=0.15mm, height=1.68mm)
  V418_DCN = cylinder(axis=Z, base_centre=(-5.95mm, -0.5mm, -1.44mm), radius=0.15mm, height=1.68mm)
  V419_DCN = cylinder(axis=Z, base_centre=(-1.15mm, -10.75mm, -1.44mm), radius=0.15mm, height=1.68mm)
  V420_DCN = cylinder(axis=Z, base_centre=(36.15mm, 13.4mm, -1.44mm), radius=0.15mm, height=1.68mm)
  V421_DCN = cylinder(axis=Z, base_centre=(-33.15mm, 14.1mm, -1.44mm), radius=0.15mm, height=1.68mm)
  V422_DCN = cylinder(axis=Z, base_centre=(-30.8577mm, -0.5mm, -1.44mm), radius=0.15mm, height=1.68mm)
  V423_DCN = cylinder(axis=Z, base_centre=(-3.55mm, -0.5mm, -1.44mm), radius=0.15mm, height=1.68mm)
  V424_DCN = cylinder(axis=Z, base_centre=(-30.15mm, 14.1mm, -1.44mm), radius=0.15mm, height=1.68mm)
  V425_DCN = cylinder(axis=Z, base_centre=(32.15mm, 13.4mm, -1.44mm), radius=0.15mm, height=1.68mm)
  V426_DCN = cylinder(axis=Z, base_centre=(40.15mm, 13.4mm, -1.44mm), radius=0.15mm, height=1.68mm)
  V427_DCN = cylinder(axis=Z, base_centre=(1.25mm, -10.75mm, -1.44mm), radius=0.15mm, height=1.68mm)
  V428_DCN = cylinder(axis=Z, base_centre=(35.15mm, 19mm, -1.44mm), radius=0.15mm, height=1.68mm)
  V429_DCN = cylinder(axis=Z, base_centre=(16.6423mm, -0.5mm, -1.44mm), radius=0.15mm, height=1.68mm)
  V430_DCN = cylinder(axis=Z, base_centre=(32.0423mm, -10.75mm, -1.44mm), radius=0.15mm, height=1.68mm)
  V431_DCN = cylinder(axis=Z, base_centre=(17.35mm, 13.4mm, -1.44mm), radius=0.15mm, height=1.68mm)
  V432_DCN = cylinder(axis=Z, base_centre=(-28.4885mm, -10.75mm, -1.44mm), radius=0.15mm, height=1.68mm)
  V433_DCN = cylinder(axis=Z, base_centre=(35.15mm, 19.75mm, -1.44mm), radius=0.15mm, height=1.68mm)
  V434_DCN = cylinder(axis=Z, base_centre=(13.0885mm, -10.75mm, -1.44mm), radius=0.15mm, height=1.68mm)
  V435_DCN = cylinder(axis=Z, base_centre=(-27.3038mm, -10.75mm, -1.44mm), radius=0.15mm, height=1.68mm)
  V436_DCN = cylinder(axis=Z, base_centre=(-11.35mm, 15.5mm, -1.44mm), radius=0.15mm, height=1.68mm)
  V437_DCN = cylinder(axis=Z, base_centre=(24.9346mm, -10.75mm, -1.44mm), radius=0.15mm, height=1.68mm)
  V438_DCN = cylinder(axis=Z, base_centre=(-12.35mm, 14.1mm, -1.44mm), radius=0.15mm, height=1.68mm)
  V439_DCN = cylinder(axis=Z, base_centre=(4.85mm, -0.5mm, -1.44mm), radius=0.15mm, height=1.68mm)
  V440_DCN = cylinder(axis=Z, base_centre=(14.35mm, 13.4mm, -1.44mm), radius=0.15mm, height=1.68mm)
  V441_DCN = cylinder(axis=Z, base_centre=(30.15mm, 15.5mm, -1.44mm), radius=0.15mm, height=1.68mm)
  V442_DCN = cylinder(axis=Z, base_centre=(-36.15mm, 15.5mm, -1.44mm), radius=0.15mm, height=1.68mm)
  V443_DCN = cylinder(axis=Z, base_centre=(35.5962mm, -10.75mm, -1.44mm), radius=0.15mm, height=1.68mm)
  V444_DCN = cylinder(axis=Z, base_centre=(-12.35mm, 19.75mm, -1.44mm), radius=0.15mm, height=1.68mm)
  V445_DCN = cylinder(axis=Z, base_centre=(11.35mm, 15.5mm, -1.44mm), radius=0.15mm, height=1.68mm)
  V446_DCN = cylinder(axis=Z, base_centre=(-29.6731mm, -10.75mm, -1.44mm), radius=0.15mm, height=1.68mm)
  V447_DCN = cylinder(axis=Z, base_centre=(-4.75mm, -10.75mm, -1.44mm), radius=0.15mm, height=1.68mm)
  V448_DCN = cylinder(axis=Z, base_centre=(35.15mm, 14.1mm, -1.44mm), radius=0.15mm, height=1.68mm)
  V449_DCN = cylinder(axis=Z, base_centre=(-32.15mm, 14.8mm, -1.44mm), radius=0.15mm, height=1.68mm)
  V450_DCN = cylinder(axis=Z, base_centre=(-31.15mm, 13.4mm, -1.44mm), radius=0.15mm, height=1.68mm)
  V451_DCN = cylinder(axis=Z, base_centre=(23.75mm, -10.75mm, -1.44mm), radius=0.15mm, height=1.68mm)
  V452_AC = cylinder(axis=Z, base_centre=(42.15mm, 10.3mm, -1.44mm), radius=0.15mm, height=1.68mm)
  V453_AC = cylinder(axis=Z, base_centre=(43.15mm, 8.05mm, -1.44mm), radius=0.15mm, height=1.68mm)
  V454_AC = cylinder(axis=Z, base_centre=(-42.15mm, 7.3mm, -1.44mm), radius=0.15mm, height=1.68mm)
  V455_AC = cylinder(axis=Z, base_centre=(-42.15mm, 9.55mm, -1.44mm), radius=0.15mm, height=1.68mm)
  V456_AC = cylinder(axis=Z, base_centre=(42.15mm, 22.8mm, -1.44mm), radius=0.15mm, height=1.68mm)
  V457_AC = cylinder(axis=Z, base_centre=(4.35mm, 10.3mm, -1.44mm), radius=0.15mm, height=1.68mm)
  V458_AC = cylinder(axis=Z, base_centre=(42.15mm, 5.8mm, -1.44mm), radius=0.15mm, height=1.68mm)
  V459_AC = cylinder(axis=Z, base_centre=(42.15mm, 24mm, -1.44mm), radius=0.15mm, height=1.68mm)
  V460_AC = cylinder(axis=Z, base_centre=(4.45mm, 25.2mm, -1.44mm), radius=0.15mm, height=1.68mm)
  V461_AC = cylinder(axis=Z, base_centre=(-5.35mm, 21.6mm, -1.44mm), radius=0.15mm, height=1.68mm)
  V462_AC = cylinder(axis=Z, base_centre=(-29.2mm, 7.05mm, -1.44mm), radius=0.15mm, height=1.68mm)
  V463_AC = cylinder(axis=Z, base_centre=(43.15mm, 7.3mm, -1.44mm), radius=0.15mm, height=1.68mm)
  V464_AC = cylinder(axis=Z, base_centre=(-5.35mm, 8.8mm, -1.44mm), radius=0.15mm, height=1.68mm)
  V465_AC = cylinder(axis=Z, base_centre=(42.15mm, 27.6mm, -1.44mm), radius=0.15mm, height=1.68mm)
  V466_AC = cylinder(axis=Z, base_centre=(4.45mm, 28.8mm, -1.44mm), radius=0.15mm, height=1.68mm)
  V467_AC = cylinder(axis=Z, base_centre=(-5.35mm, 26.4mm, -1.44mm), radius=0.15mm, height=1.68mm)
  V468_AC = cylinder(axis=Z, base_centre=(-6.55mm, 22.8mm, -1.44mm), radius=0.15mm, height=1.68mm)
  V469_AC = cylinder(axis=Z, base_centre=(-42.15mm, 8.05mm, -1.44mm), radius=0.15mm, height=1.68mm)
  V470_AC = cylinder(axis=Z, base_centre=(-4.35mm, 5.8mm, -1.44mm), radius=0.15mm, height=1.68mm)
  V471_AC = cylinder(axis=Z, base_centre=(-6.55mm, 30mm, -1.44mm), radius=0.15mm, height=1.68mm)
  V472_AC = cylinder(axis=Z, base_centre=(4.45mm, 27.6mm, -1.44mm), radius=0.15mm, height=1.68mm)
  V473_AC = cylinder(axis=Z, base_centre=(-41.85mm, 21.6mm, -1.44mm), radius=0.15mm, height=1.68mm)
  V474_AC = cylinder(axis=Z, base_centre=(40.95mm, 25.2mm, -1.44mm), radius=0.15mm, height=1.68mm)
  V475_AC = cylinder(axis=Z, base_centre=(-41.85mm, 25.2mm, -1.44mm), radius=0.15mm, height=1.68mm)
  V476_AC = cylinder(axis=Z, base_centre=(-6.55mm, 27.6mm, -1.44mm), radius=0.15mm, height=1.68mm)
  V477_AC = cylinder(axis=Z, base_centre=(4.45mm, 22.8mm, -1.44mm), radius=0.15mm, height=1.68mm)
  V478_AC = cylinder(axis=Z, base_centre=(-6.55mm, 28.8mm, -1.44mm), radius=0.15mm, height=1.68mm)
  V479_AC = cylinder(axis=Z, base_centre=(-4.35mm, 8.05mm, -1.44mm), radius=0.15mm, height=1.68mm)
  V480_AC = cylinder(axis=Z, base_centre=(42.15mm, 8.8mm, -1.44mm), radius=0.15mm, height=1.68mm)
  V481_AC = cylinder(axis=Z, base_centre=(-5.35mm, 5.8mm, -1.44mm), radius=0.15mm, height=1.68mm)
  V482_AC = cylinder(axis=Z, base_centre=(-6.55mm, 26.4mm, -1.44mm), radius=0.15mm, height=1.68mm)
  V483_AC = cylinder(axis=Z, base_centre=(5.35mm, 5.8mm, -1.44mm), radius=0.15mm, height=1.68mm)
  V484_AC = cylinder(axis=Z, base_centre=(-42.15mm, 5.8mm, -1.44mm), radius=0.15mm, height=1.68mm)
  V485_AC = cylinder(axis=Z, base_centre=(43.15mm, 9.55mm, -1.44mm), radius=0.15mm, height=1.68mm)
  V486_AC = cylinder(axis=Z, base_centre=(-5.35mm, 9.55mm, -1.44mm), radius=0.15mm, height=1.68mm)
  V487_AC = cylinder(axis=Z, base_centre=(-43.05mm, 25.2mm, -1.44mm), radius=0.15mm, height=1.68mm)
  V488_AC = cylinder(axis=Z, base_centre=(5.65mm, 24mm, -1.44mm), radius=0.15mm, height=1.68mm)
  V489_AC = cylinder(axis=Z, base_centre=(43.15mm, 8.8mm, -1.44mm), radius=0.15mm, height=1.68mm)
  V490_AC = cylinder(axis=Z, base_centre=(-43.15mm, 8.05mm, -1.44mm), radius=0.15mm, height=1.68mm)
  V491_AC = cylinder(axis=Z, base_centre=(4.45mm, 30mm, -1.44mm), radius=0.15mm, height=1.68mm)
  V492_AC = cylinder(axis=Z, base_centre=(4.35mm, 5.8mm, -1.44mm), radius=0.15mm, height=1.68mm)
  V493_AC = cylinder(axis=Z, base_centre=(-42.15mm, 8.8mm, -1.44mm), radius=0.15mm, height=1.68mm)
  V494_AC = cylinder(axis=Z, base_centre=(42.15mm, 25.2mm, -1.44mm), radius=0.15mm, height=1.68mm)
  V495_AC = cylinder(axis=Z, base_centre=(4.45mm, 26.4mm, -1.44mm), radius=0.15mm, height=1.68mm)
  V496_AC = cylinder(axis=Z, base_centre=(-4.35mm, 8.8mm, -1.44mm), radius=0.15mm, height=1.68mm)
  V497_AC = cylinder(axis=Z, base_centre=(40.95mm, 27.6mm, -1.44mm), radius=0.15mm, height=1.68mm)
  V498_AC = cylinder(axis=Z, base_centre=(40.95mm, 30mm, -1.44mm), radius=0.15mm, height=1.68mm)
  V499_AC = cylinder(axis=Z, base_centre=(-41.85mm, 24mm, -1.44mm), radius=0.15mm, height=1.68mm)
  V500_AC = cylinder(axis=Z, base_centre=(4.35mm, 9.55mm, -1.44mm), radius=0.15mm, height=1.68mm)
  V501_AC = cylinder(axis=Z, base_centre=(-41.85mm, 26.4mm, -1.44mm), radius=0.15mm, height=1.68mm)
  V502_AC = cylinder(axis=Z, base_centre=(5.35mm, 6.55mm, -1.44mm), radius=0.15mm, height=1.68mm)
  V503_AC = cylinder(axis=Z, base_centre=(42.15mm, 9.55mm, -1.44mm), radius=0.15mm, height=1.68mm)
  V504_AC = cylinder(axis=Z, base_centre=(5.35mm, 8.8mm, -1.44mm), radius=0.15mm, height=1.68mm)
  V505_AC = cylinder(axis=Z, base_centre=(-18.3mm, 7.05mm, -1.44mm), radius=0.15mm, height=1.68mm)
  V506_AC = cylinder(axis=Z, base_centre=(-6.55mm, 24mm, -1.44mm), radius=0.15mm, height=1.68mm)
  V507_AC = cylinder(axis=Z, base_centre=(-4.35mm, 10.3mm, -1.44mm), radius=0.15mm, height=1.68mm)
  V508_AC = cylinder(axis=Z, base_centre=(42.15mm, 30mm, -1.44mm), radius=0.15mm, height=1.68mm)
  V509_AC = cylinder(axis=Z, base_centre=(-4.35mm, 6.55mm, -1.44mm), radius=0.15mm, height=1.68mm)
  V510_AC = cylinder(axis=Z, base_centre=(-5.35mm, 25.2mm, -1.44mm), radius=0.15mm, height=1.68mm)
  V511_AC = cylinder(axis=Z, base_centre=(4.35mm, 6.55mm, -1.44mm), radius=0.15mm, height=1.68mm)
  V512_AC = cylinder(axis=Z, base_centre=(-41.85mm, 28.8mm, -1.44mm), radius=0.15mm, height=1.68mm)
  V513_AC = cylinder(axis=Z, base_centre=(29.2mm, 7.05mm, -1.44mm), radius=0.15mm, height=1.68mm)
  V514_AC = cylinder(axis=Z, base_centre=(-5.35mm, 6.55mm, -1.44mm), radius=0.15mm, height=1.68mm)
  V515_AC = cylinder(axis=Z, base_centre=(-5.35mm, 28.8mm, -1.44mm), radius=0.15mm, height=1.68mm)
  V516_AC = cylinder(axis=Z, base_centre=(-42.15mm, 6.55mm, -1.44mm), radius=0.15mm, height=1.68mm)
  V517_AC = cylinder(axis=Z, base_centre=(-5.35mm, 30mm, -1.44mm), radius=0.15mm, height=1.68mm)
  V518_AC = cylinder(axis=Z, base_centre=(-5.35mm, 22.8mm, -1.44mm), radius=0.15mm, height=1.68mm)
  V519_AC = cylinder(axis=Z, base_centre=(40.95mm, 24mm, -1.44mm), radius=0.15mm, height=1.68mm)
  V520_AC = cylinder(axis=Z, base_centre=(4.35mm, 7.3mm, -1.44mm), radius=0.15mm, height=1.68mm)
  V521_AC = cylinder(axis=Z, base_centre=(5.35mm, 10.3mm, -1.44mm), radius=0.15mm, height=1.68mm)
  V522_AC = cylinder(axis=Z, base_centre=(42.15mm, 6.55mm, -1.44mm), radius=0.15mm, height=1.68mm)
  V523_AC = cylinder(axis=Z, base_centre=(-43.05mm, 30mm, -1.44mm), radius=0.15mm, height=1.68mm)
  V524_AC = cylinder(axis=Z, base_centre=(-4.35mm, 7.3mm, -1.44mm), radius=0.15mm, height=1.68mm)
  V525_AC = cylinder(axis=Z, base_centre=(-5.35mm, 10.3mm, -1.44mm), radius=0.15mm, height=1.68mm)
  V526_AC = cylinder(axis=Z, base_centre=(-42.15mm, 10.3mm, -1.44mm), radius=0.15mm, height=1.68mm)
  V527_AC = cylinder(axis=Z, base_centre=(-43.05mm, 26.4mm, -1.44mm), radius=0.15mm, height=1.68mm)
  V528_AC = cylinder(axis=Z, base_centre=(-6.55mm, 21.6mm, -1.44mm), radius=0.15mm, height=1.68mm)
  V529_AC = cylinder(axis=Z, base_centre=(40.95mm, 28.8mm, -1.44mm), radius=0.15mm, height=1.68mm)
  V530_AC = cylinder(axis=Z, base_centre=(-43.05mm, 24mm, -1.44mm), radius=0.15mm, height=1.68mm)
  V531_AC = cylinder(axis=Z, base_centre=(42.15mm, 7.3mm, -1.44mm), radius=0.15mm, height=1.68mm)
  V532_AC = cylinder(axis=Z, base_centre=(4.35mm, 8.8mm, -1.44mm), radius=0.15mm, height=1.68mm)
  V533_AC = cylinder(axis=Z, base_centre=(43.15mm, 6.55mm, -1.44mm), radius=0.15mm, height=1.68mm)
  V534_AC = cylinder(axis=Z, base_centre=(-43.05mm, 22.8mm, -1.44mm), radius=0.15mm, height=1.68mm)
  V535_AC = cylinder(axis=Z, base_centre=(5.35mm, 7.3mm, -1.44mm), radius=0.15mm, height=1.68mm)
  V536_AC = cylinder(axis=Z, base_centre=(43.15mm, 10.3mm, -1.44mm), radius=0.15mm, height=1.68mm)
  V537_AC = cylinder(axis=Z, base_centre=(-43.05mm, 28.8mm, -1.44mm), radius=0.15mm, height=1.68mm)
  V538_AC = cylinder(axis=Z, base_centre=(5.35mm, 8.05mm, -1.44mm), radius=0.15mm, height=1.68mm)
  V539_AC = cylinder(axis=Z, base_centre=(-41.85mm, 22.8mm, -1.44mm), radius=0.15mm, height=1.68mm)
  V540_AC = cylinder(axis=Z, base_centre=(-41.85mm, 30mm, -1.44mm), radius=0.15mm, height=1.68mm)
  V541_AC = cylinder(axis=Z, base_centre=(42.15mm, 28.8mm, -1.44mm), radius=0.15mm, height=1.68mm)
  V542_AC = cylinder(axis=Z, base_centre=(-5.35mm, 24mm, -1.44mm), radius=0.15mm, height=1.68mm)
  V543_AC = cylinder(axis=Z, base_centre=(-43.05mm, 27.6mm, -1.44mm), radius=0.15mm, height=1.68mm)
  V544_AC = cylinder(axis=Z, base_centre=(4.45mm, 21.6mm, -1.44mm), radius=0.15mm, height=1.68mm)
  V545_AC = cylinder(axis=Z, base_centre=(5.65mm, 30mm, -1.44mm), radius=0.15mm, height=1.68mm)
  V546_AC = cylinder(axis=Z, base_centre=(-43.15mm, 5.8mm, -1.44mm), radius=0.15mm, height=1.68mm)
  V547_AC = cylinder(axis=Z, base_centre=(-6.55mm, 25.2mm, -1.44mm), radius=0.15mm, height=1.68mm)
  V548_AC = cylinder(axis=Z, base_centre=(4.45mm, 24mm, -1.44mm), radius=0.15mm, height=1.68mm)
  V549_AC = cylinder(axis=Z, base_centre=(-5.35mm, 7.3mm, -1.44mm), radius=0.15mm, height=1.68mm)
  V550_AC = cylinder(axis=Z, base_centre=(42.15mm, 21.6mm, -1.44mm), radius=0.15mm, height=1.68mm)
  V551_AC = cylinder(axis=Z, base_centre=(5.65mm, 21.6mm, -1.44mm), radius=0.15mm, height=1.68mm)
  V552_AC = cylinder(axis=Z, base_centre=(5.65mm, 26.4mm, -1.44mm), radius=0.15mm, height=1.68mm)
  V553_AC = cylinder(axis=Z, base_centre=(40.95mm, 21.6mm, -1.44mm), radius=0.15mm, height=1.68mm)
  V554_AC = cylinder(axis=Z, base_centre=(-43.15mm, 7.3mm, -1.44mm), radius=0.15mm, height=1.68mm)
  V555_AC = cylinder(axis=Z, base_centre=(-5.35mm, 8.05mm, -1.44mm), radius=0.15mm, height=1.68mm)
  V556_AC = cylinder(axis=Z, base_centre=(-43.15mm, 6.55mm, -1.44mm), radius=0.15mm, height=1.68mm)
  V557_AC = cylinder(axis=Z, base_centre=(43.15mm, 5.8mm, -1.44mm), radius=0.15mm, height=1.68mm)
  V558_AC = cylinder(axis=Z, base_centre=(5.65mm, 27.6mm, -1.44mm), radius=0.15mm, height=1.68mm)
  V559_AC = cylinder(axis=Z, base_centre=(-43.15mm, 8.8mm, -1.44mm), radius=0.15mm, height=1.68mm)
  V560_AC = cylinder(axis=Z, base_centre=(40.95mm, 26.4mm, -1.44mm), radius=0.15mm, height=1.68mm)
  V561_AC = cylinder(axis=Z, base_centre=(-43.15mm, 10.3mm, -1.44mm), radius=0.15mm, height=1.68mm)
  V562_AC = cylinder(axis=Z, base_centre=(-41.85mm, 27.6mm, -1.44mm), radius=0.15mm, height=1.68mm)
  V563_AC = cylinder(axis=Z, base_centre=(5.65mm, 22.8mm, -1.44mm), radius=0.15mm, height=1.68mm)
  V564_AC = cylinder(axis=Z, base_centre=(5.65mm, 25.2mm, -1.44mm), radius=0.15mm, height=1.68mm)
  V565_AC = cylinder(axis=Z, base_centre=(42.15mm, 8.05mm, -1.44mm), radius=0.15mm, height=1.68mm)
  V566_AC = cylinder(axis=Z, base_centre=(18.3mm, 7.05mm, -1.44mm), radius=0.15mm, height=1.68mm)
  V567_AC = cylinder(axis=Z, base_centre=(-4.35mm, 9.55mm, -1.44mm), radius=0.15mm, height=1.68mm)
  V568_AC = cylinder(axis=Z, base_centre=(-43.15mm, 9.55mm, -1.44mm), radius=0.15mm, height=1.68mm)
  V569_AC = cylinder(axis=Z, base_centre=(-43.05mm, 21.6mm, -1.44mm), radius=0.15mm, height=1.68mm)
  V570_AC = cylinder(axis=Z, base_centre=(5.65mm, 28.8mm, -1.44mm), radius=0.15mm, height=1.68mm)
  V571_AC = cylinder(axis=Z, base_centre=(40.95mm, 22.8mm, -1.44mm), radius=0.15mm, height=1.68mm)
  V572_AC = cylinder(axis=Z, base_centre=(4.35mm, 8.05mm, -1.44mm), radius=0.15mm, height=1.68mm)
  V573_AC = cylinder(axis=Z, base_centre=(-5.35mm, 27.6mm, -1.44mm), radius=0.15mm, height=1.68mm)
  V574_AC = cylinder(axis=Z, base_centre=(42.15mm, 26.4mm, -1.44mm), radius=0.15mm, height=1.68mm)
  V575_AC = cylinder(axis=Z, base_centre=(5.35mm, 9.55mm, -1.44mm), radius=0.15mm, height=1.68mm)
  V576_LSRC1 = cylinder(axis=Z, base_centre=(-37.225mm, 11.8mm, -1.44mm), radius=0.15mm, height=1.68mm)
  V577_LSRC2 = cylinder(axis=Z, base_centre=(-10.275mm, 11.8mm, -1.44mm), radius=0.15mm, height=1.68mm)
  V578_LSRC3 = cylinder(axis=Z, base_centre=(10.275mm, 11.8mm, -1.44mm), radius=0.15mm, height=1.68mm)
  V579_LSRC4 = cylinder(axis=Z, base_centre=(37.225mm, 11.8mm, -1.44mm), radius=0.15mm, height=1.68mm)
  V580_DCP = cylinder(axis=Z, base_centre=(-8.935mm, -21.735mm, -1.44mm), radius=0.925mm, height=1.68mm)
  V581_DCP = cylinder(axis=Z, base_centre=(-8.935mm, -15.865mm, -1.44mm), radius=0.925mm, height=1.68mm)
  V582_DCP = cylinder(axis=Z, base_centre=(-3.065mm, -21.735mm, -1.44mm), radius=0.925mm, height=1.68mm)
  V583_DCP = cylinder(axis=Z, base_centre=(-3.065mm, -15.865mm, -1.44mm), radius=0.925mm, height=1.68mm)
  V584_DCN = cylinder(axis=Z, base_centre=(3.065mm, -21.735mm, -1.44mm), radius=0.925mm, height=1.68mm)
  V585_DCN = cylinder(axis=Z, base_centre=(3.065mm, -15.865mm, -1.44mm), radius=0.925mm, height=1.68mm)
  V586_DCN = cylinder(axis=Z, base_centre=(8.935mm, -21.735mm, -1.44mm), radius=0.925mm, height=1.68mm)
  V587_DCN = cylinder(axis=Z, base_centre=(8.935mm, -15.865mm, -1.44mm), radius=0.925mm, height=1.68mm)
  V588_AC = cylinder(axis=Z, base_centre=(-3.15mm, 45.2mm, -1.44mm), radius=0.15mm, height=1.68mm)
  V589_AC = cylinder(axis=Z, base_centre=(-38.35mm, 58mm, -1.44mm), radius=0.15mm, height=1.68mm)
  V590_AC = cylinder(axis=Z, base_centre=(22.45mm, 54.8mm, -1.44mm), radius=0.15mm, height=1.68mm)
  V591_AC = cylinder(axis=Z, base_centre=(-22.35mm, 48.4mm, -1.44mm), radius=0.15mm, height=1.68mm)
  V592_AC = cylinder(axis=Z, base_centre=(36.85mm, 46.8mm, -1.44mm), radius=0.15mm, height=1.68mm)
  V593_AC = cylinder(axis=Z, base_centre=(8.05mm, 54.8mm, -1.44mm), radius=0.15mm, height=1.68mm)
  V594_AC = cylinder(axis=Z, base_centre=(-4.75mm, 45.2mm, -1.44mm), radius=0.15mm, height=1.68mm)
  V595_AC = cylinder(axis=Z, base_centre=(24.05mm, 46.8mm, -1.44mm), radius=0.15mm, height=1.68mm)
  V596_AC = cylinder(axis=Z, base_centre=(6.45mm, 58mm, -1.44mm), radius=0.15mm, height=1.68mm)
  V597_AC = cylinder(axis=Z, base_centre=(-6.55mm, 31.2mm, -1.44mm), radius=0.15mm, height=1.68mm)
  V598_AC = cylinder(axis=Z, base_centre=(4.45mm, 39.6mm, -1.44mm), radius=0.15mm, height=1.68mm)
  V599_AC = cylinder(axis=Z, base_centre=(-41.55mm, 48.4mm, -1.44mm), radius=0.15mm, height=1.68mm)
  V600_AC = cylinder(axis=Z, base_centre=(32.05mm, 45.2mm, -1.44mm), radius=0.15mm, height=1.68mm)
  V601_AC = cylinder(axis=Z, base_centre=(-20.75mm, 53.2mm, -1.44mm), radius=0.15mm, height=1.68mm)
  V602_AC = cylinder(axis=Z, base_centre=(-38.35mm, 53.2mm, -1.44mm), radius=0.15mm, height=1.68mm)
  V603_AC = cylinder(axis=Z, base_centre=(-15.95mm, 58mm, -1.44mm), radius=0.15mm, height=1.68mm)
  V604_AC = cylinder(axis=Z, base_centre=(-11.15mm, 56.4mm, -1.44mm), radius=0.15mm, height=1.68mm)
  V605_AC = cylinder(axis=Z, base_centre=(-25.55mm, 50mm, -1.44mm), radius=0.15mm, height=1.68mm)
  V606_AC = cylinder(axis=Z, base_centre=(-35.15mm, 46.8mm, -1.44mm), radius=0.15mm, height=1.68mm)
  V607_AC = cylinder(axis=Z, base_centre=(-43.15mm, 51.6mm, -1.44mm), radius=0.15mm, height=1.68mm)
  V608_AC = cylinder(axis=Z, base_centre=(17.65mm, 46.8mm, -1.44mm), radius=0.15mm, height=1.68mm)
  V609_AC = cylinder(axis=Z, base_centre=(36.85mm, 54.8mm, -1.44mm), radius=0.15mm, height=1.68mm)
  V610_AC = cylinder(axis=Z, base_centre=(16.05mm, 51.6mm, -1.44mm), radius=0.15mm, height=1.68mm)
  V611_AC = cylinder(axis=Z, base_centre=(4.85mm, 45.2mm, -1.44mm), radius=0.15mm, height=1.68mm)
  V612_AC = cylinder(axis=Z, base_centre=(-25.55mm, 53.2mm, -1.44mm), radius=0.15mm, height=1.68mm)
  V613_AC = cylinder(axis=Z, base_centre=(-12.75mm, 46.8mm, -1.44mm), radius=0.15mm, height=1.68mm)
  V614_AC = cylinder(axis=Z, base_centre=(30.45mm, 46.8mm, -1.44mm), radius=0.15mm, height=1.68mm)
  V615_AC = cylinder(axis=Z, base_centre=(-41.55mm, 54.8mm, -1.44mm), radius=0.15mm, height=1.68mm)
  V616_AC = cylinder(axis=Z, base_centre=(-33.55mm, 46.8mm, -1.44mm), radius=0.15mm, height=1.68mm)
  V617_AC = cylinder(axis=Z, base_centre=(5.65mm, 31.2mm, -1.44mm), radius=0.15mm, height=1.68mm)
  V618_AC = cylinder(axis=Z, base_centre=(-43.05mm, 38.4mm, -1.44mm), radius=0.15mm, height=1.68mm)
  V619_AC = cylinder(axis=Z, base_centre=(-12.75mm, 56.4mm, -1.44mm), radius=0.15mm, height=1.68mm)
  V620_AC = cylinder(axis=Z, base_centre=(14.45mm, 53.2mm, -1.44mm), radius=0.15mm, height=1.68mm)
  V621_AC = cylinder(axis=Z, base_centre=(16.05mm, 54.8mm, -1.44mm), radius=0.15mm, height=1.68mm)
  V622_AC = cylinder(axis=Z, base_centre=(-39.95mm, 50mm, -1.44mm), radius=0.15mm, height=1.68mm)
  V623_AC = cylinder(axis=Z, base_centre=(-43.15mm, 50mm, -1.44mm), radius=0.15mm, height=1.68mm)
  V624_AC = cylinder(axis=Z, base_centre=(35.25mm, 58mm, -1.44mm), radius=0.15mm, height=1.68mm)
  V625_AC = cylinder(axis=Z, base_centre=(-33.55mm, 53.2mm, -1.44mm), radius=0.15mm, height=1.68mm)
  V626_AC = cylinder(axis=Z, base_centre=(27.25mm, 54.8mm, -1.44mm), radius=0.15mm, height=1.68mm)
  V627_AC = cylinder(axis=Z, base_centre=(40.95mm, 36mm, -1.44mm), radius=0.15mm, height=1.68mm)
  V628_AC = cylinder(axis=Z, base_centre=(6.45mm, 45.2mm, -1.44mm), radius=0.15mm, height=1.68mm)
  V629_AC = cylinder(axis=Z, base_centre=(42.15mm, 34.8mm, -1.44mm), radius=0.15mm, height=1.68mm)
  V630_AC = cylinder(axis=Z, base_centre=(5.65mm, 36mm, -1.44mm), radius=0.15mm, height=1.68mm)
  V631_AC = cylinder(axis=Z, base_centre=(19.25mm, 50mm, -1.44mm), radius=0.15mm, height=1.68mm)
  V632_AC = cylinder(axis=Z, base_centre=(9.65mm, 56.4mm, -1.44mm), radius=0.15mm, height=1.68mm)
  V633_AC = cylinder(axis=Z, base_centre=(-6.55mm, 33.6mm, -1.44mm), radius=0.15mm, height=1.68mm)
  V634_AC = cylinder(axis=Z, base_centre=(36.85mm, 53.2mm, -1.44mm), radius=0.15mm, height=1.68mm)
  V635_AC = cylinder(axis=Z, base_centre=(-36.75mm, 48.4mm, -1.44mm), radius=0.15mm, height=1.68mm)
  V636_AC = cylinder(axis=Z, base_centre=(-43.15mm, 53.2mm, -1.44mm), radius=0.15mm, height=1.68mm)
  V637_AC = cylinder(axis=Z, base_centre=(4.45mm, 36mm, -1.44mm), radius=0.15mm, height=1.68mm)
  V638_AC = cylinder(axis=Z, base_centre=(-22.35mm, 45.2mm, -1.44mm), radius=0.15mm, height=1.68mm)
  V639_AC = cylinder(axis=Z, base_centre=(22.45mm, 50mm, -1.44mm), radius=0.15mm, height=1.68mm)
  V640_AC = cylinder(axis=Z, base_centre=(22.45mm, 56.4mm, -1.44mm), radius=0.15mm, height=1.68mm)
  V641_AC = cylinder(axis=Z, base_centre=(-6.55mm, 40.8mm, -1.44mm), radius=0.15mm, height=1.68mm)
  V642_AC = cylinder(axis=Z, base_centre=(-14.35mm, 53.2mm, -1.44mm), radius=0.15mm, height=1.68mm)
  V643_AC = cylinder(axis=Z, base_centre=(4.45mm, 33.6mm, -1.44mm), radius=0.15mm, height=1.68mm)
  V644_AC = cylinder(axis=Z, base_centre=(-43.15mm, 46.8mm, -1.44mm), radius=0.15mm, height=1.68mm)
  V645_AC = cylinder(axis=Z, base_centre=(19.25mm, 51.6mm, -1.44mm), radius=0.15mm, height=1.68mm)
  V646_AC = cylinder(axis=Z, base_centre=(32.05mm, 46.8mm, -1.44mm), radius=0.15mm, height=1.68mm)
  V647_AC = cylinder(axis=Z, base_centre=(16.05mm, 56.4mm, -1.44mm), radius=0.15mm, height=1.68mm)
  V648_AC = cylinder(axis=Z, base_centre=(-11.15mm, 58mm, -1.44mm), radius=0.15mm, height=1.68mm)
  V649_AC = cylinder(axis=Z, base_centre=(36.85mm, 48.4mm, -1.44mm), radius=0.15mm, height=1.68mm)
  V650_AC = cylinder(axis=Z, base_centre=(20.85mm, 58mm, -1.44mm), radius=0.15mm, height=1.68mm)
  V651_AC = cylinder(axis=Z, base_centre=(-25.55mm, 48.4mm, -1.44mm), radius=0.15mm, height=1.68mm)
  V652_AC = cylinder(axis=Z, base_centre=(-9.55mm, 54.8mm, -1.44mm), radius=0.15mm, height=1.68mm)
  V653_AC = cylinder(axis=Z, base_centre=(-28.75mm, 51.6mm, -1.44mm), radius=0.15mm, height=1.68mm)
  V654_AC = cylinder(axis=Z, base_centre=(-6.55mm, 39.6mm, -1.44mm), radius=0.15mm, height=1.68mm)
  V655_AC = cylinder(axis=Z, base_centre=(-17.55mm, 48.4mm, -1.44mm), radius=0.15mm, height=1.68mm)
  V656_AC = cylinder(axis=Z, base_centre=(-30.35mm, 56.4mm, -1.44mm), radius=0.15mm, height=1.68mm)
  V657_AC = cylinder(axis=Z, base_centre=(-19.15mm, 51.6mm, -1.44mm), radius=0.15mm, height=1.68mm)
  V658_AC = cylinder(axis=Z, base_centre=(-19.15mm, 48.4mm, -1.44mm), radius=0.15mm, height=1.68mm)
  V659_AC = cylinder(axis=Z, base_centre=(19.25mm, 54.8mm, -1.44mm), radius=0.15mm, height=1.68mm)
  V660_AC = cylinder(axis=Z, base_centre=(-12.75mm, 51.6mm, -1.44mm), radius=0.15mm, height=1.68mm)
  V661_AC = cylinder(axis=Z, base_centre=(28.85mm, 46.8mm, -1.44mm), radius=0.15mm, height=1.68mm)
  V662_AC = cylinder(axis=Z, base_centre=(22.45mm, 48.4mm, -1.44mm), radius=0.15mm, height=1.68mm)
  V663_AC = cylinder(axis=Z, base_centre=(-5.35mm, 39.6mm, -1.44mm), radius=0.15mm, height=1.68mm)
  V664_AC = cylinder(axis=Z, base_centre=(-7.95mm, 58mm, -1.44mm), radius=0.15mm, height=1.68mm)
  V665_AC = cylinder(axis=Z, base_centre=(-25.55mm, 58mm, -1.44mm), radius=0.15mm, height=1.68mm)
  V666_AC = cylinder(axis=Z, base_centre=(-39.95mm, 45.2mm, -1.44mm), radius=0.15mm, height=1.68mm)
  V667_AC = cylinder(axis=Z, base_centre=(-28.75mm, 53.2mm, -1.44mm), radius=0.15mm, height=1.68mm)
  V668_AC = cylinder(axis=Z, base_centre=(11.25mm, 50mm, -1.44mm), radius=0.15mm, height=1.68mm)
  V669_AC = cylinder(axis=Z, base_centre=(42.15mm, 31.2mm, -1.44mm), radius=0.15mm, height=1.68mm)
  V670_AC = cylinder(axis=Z, base_centre=(9.65mm, 53.2mm, -1.44mm), radius=0.15mm, height=1.68mm)
  V671_AC = cylinder(axis=Z, base_centre=(14.45mm, 48.4mm, -1.44mm), radius=0.15mm, height=1.68mm)
  V672_AC = cylinder(axis=Z, base_centre=(-19.15mm, 54.8mm, -1.44mm), radius=0.15mm, height=1.68mm)
  V673_AC = cylinder(axis=Z, base_centre=(27.25mm, 46.8mm, -1.44mm), radius=0.15mm, height=1.68mm)
  V674_AC = cylinder(axis=Z, base_centre=(14.45mm, 58mm, -1.44mm), radius=0.15mm, height=1.68mm)
  V675_AC = cylinder(axis=Z, base_centre=(-14.35mm, 54.8mm, -1.44mm), radius=0.15mm, height=1.68mm)
  V676_AC = cylinder(axis=Z, base_centre=(40.05mm, 54.8mm, -1.44mm), radius=0.15mm, height=1.68mm)
  V677_AC = cylinder(axis=Z, base_centre=(32.05mm, 50mm, -1.44mm), radius=0.15mm, height=1.68mm)
  V678_AC = cylinder(axis=Z, base_centre=(36.85mm, 45.2mm, -1.44mm), radius=0.15mm, height=1.68mm)
  V679_AC = cylinder(axis=Z, base_centre=(-41.85mm, 38.4mm, -1.44mm), radius=0.15mm, height=1.68mm)
  V680_AC = cylinder(axis=Z, base_centre=(41.65mm, 56.4mm, -1.44mm), radius=0.15mm, height=1.68mm)
  V681_AC = cylinder(axis=Z, base_centre=(-30.35mm, 48.4mm, -1.44mm), radius=0.15mm, height=1.68mm)
  V682_AC = cylinder(axis=Z, base_centre=(32.05mm, 56.4mm, -1.44mm), radius=0.15mm, height=1.68mm)
  V683_AC = cylinder(axis=Z, base_centre=(24.05mm, 50mm, -1.44mm), radius=0.15mm, height=1.68mm)
  V684_AC = cylinder(axis=Z, base_centre=(20.85mm, 46.8mm, -1.44mm), radius=0.15mm, height=1.68mm)
  V685_AC = cylinder(axis=Z, base_centre=(-6.55mm, 32.4mm, -1.44mm), radius=0.15mm, height=1.68mm)
  V686_AC = cylinder(axis=Z, base_centre=(-22.35mm, 53.2mm, -1.44mm), radius=0.15mm, height=1.68mm)
  V687_AC = cylinder(axis=Z, base_centre=(40.05mm, 48.4mm, -1.44mm), radius=0.15mm, height=1.68mm)
  V688_AC = cylinder(axis=Z, base_centre=(4.45mm, 34.8mm, -1.44mm), radius=0.15mm, height=1.68mm)
  V689_AC = cylinder(axis=Z, base_centre=(41.65mm, 54.8mm, -1.44mm), radius=0.15mm, height=1.68mm)
  V690_AC = cylinder(axis=Z, base_centre=(-19.15mm, 46.8mm, -1.44mm), radius=0.15mm, height=1.68mm)
  V691_AC = cylinder(axis=Z, base_centre=(-15.95mm, 46.8mm, -1.44mm), radius=0.15mm, height=1.68mm)
  V692_AC = cylinder(axis=Z, base_centre=(40.95mm, 37.2mm, -1.44mm), radius=0.15mm, height=1.68mm)
  V693_AC = cylinder(axis=Z, base_centre=(25.65mm, 56.4mm, -1.44mm), radius=0.15mm, height=1.68mm)
  V694_AC = cylinder(axis=Z, base_centre=(12.85mm, 56.4mm, -1.44mm), radius=0.15mm, height=1.68mm)
  V695_AC = cylinder(axis=Z, base_centre=(9.65mm, 50mm, -1.44mm), radius=0.15mm, height=1.68mm)
  V696_AC = cylinder(axis=Z, base_centre=(11.25mm, 48.4mm, -1.44mm), radius=0.15mm, height=1.68mm)
  V697_AC = cylinder(axis=Z, base_centre=(-43.05mm, 31.2mm, -1.44mm), radius=0.15mm, height=1.68mm)
  V698_AC = cylinder(axis=Z, base_centre=(27.25mm, 45.2mm, -1.44mm), radius=0.15mm, height=1.68mm)
  V699_AC = cylinder(axis=Z, base_centre=(19.25mm, 56.4mm, -1.44mm), radius=0.15mm, height=1.68mm)
  V700_AC = cylinder(axis=Z, base_centre=(33.65mm, 48.4mm, -1.44mm), radius=0.15mm, height=1.68mm)
  V701_AC = cylinder(axis=Z, base_centre=(42.15mm, 40.8mm, -1.44mm), radius=0.15mm, height=1.68mm)
  V702_AC = cylinder(axis=Z, base_centre=(-19.15mm, 58mm, -1.44mm), radius=0.15mm, height=1.68mm)
  V703_AC = cylinder(axis=Z, base_centre=(30.45mm, 50mm, -1.44mm), radius=0.15mm, height=1.68mm)
  V704_AC = cylinder(axis=Z, base_centre=(-11.15mm, 53.2mm, -1.44mm), radius=0.15mm, height=1.68mm)
  V705_AC = cylinder(axis=Z, base_centre=(-33.55mm, 54.8mm, -1.44mm), radius=0.15mm, height=1.68mm)
  V706_AC = cylinder(axis=Z, base_centre=(-20.75mm, 46.8mm, -1.44mm), radius=0.15mm, height=1.68mm)
  V707_AC = cylinder(axis=Z, base_centre=(-30.35mm, 58mm, -1.44mm), radius=0.15mm, height=1.68mm)
  V708_AC = cylinder(axis=Z, base_centre=(33.65mm, 50mm, -1.44mm), radius=0.15mm, height=1.68mm)
  V709_AC = cylinder(axis=Z, base_centre=(8.05mm, 45.2mm, -1.44mm), radius=0.15mm, height=1.68mm)
  V710_AC = cylinder(axis=Z, base_centre=(-20.75mm, 51.6mm, -1.44mm), radius=0.15mm, height=1.68mm)
  V711_AC = cylinder(axis=Z, base_centre=(-23.95mm, 58mm, -1.44mm), radius=0.15mm, height=1.68mm)
  V712_AC = cylinder(axis=Z, base_centre=(-35.15mm, 48.4mm, -1.44mm), radius=0.15mm, height=1.68mm)
  V713_AC = cylinder(axis=Z, base_centre=(-19.15mm, 50mm, -1.44mm), radius=0.15mm, height=1.68mm)
  V714_AC = cylinder(axis=Z, base_centre=(42.15mm, 39.6mm, -1.44mm), radius=0.15mm, height=1.68mm)
  V715_AC = cylinder(axis=Z, base_centre=(-41.55mm, 56.4mm, -1.44mm), radius=0.15mm, height=1.68mm)
  V716_AC = cylinder(axis=Z, base_centre=(11.25mm, 45.2mm, -1.44mm), radius=0.15mm, height=1.68mm)
  V717_AC = cylinder(axis=Z, base_centre=(16.05mm, 53.2mm, -1.44mm), radius=0.15mm, height=1.68mm)
  V718_AC = cylinder(axis=Z, base_centre=(-41.85mm, 39.6mm, -1.44mm), radius=0.15mm, height=1.68mm)
  V719_AC = cylinder(axis=Z, base_centre=(-23.95mm, 45.2mm, -1.44mm), radius=0.15mm, height=1.68mm)
  V720_AC = cylinder(axis=Z, base_centre=(27.25mm, 56.4mm, -1.44mm), radius=0.15mm, height=1.68mm)
  V721_AC = cylinder(axis=Z, base_centre=(-25.55mm, 45.2mm, -1.44mm), radius=0.15mm, height=1.68mm)
  V722_AC = cylinder(axis=Z, base_centre=(-43.05mm, 40.8mm, -1.44mm), radius=0.15mm, height=1.68mm)
  V723_AC = cylinder(axis=Z, base_centre=(-6.55mm, 43.2mm, -1.44mm), radius=0.15mm, height=1.68mm)
  V724_AC = cylinder(axis=Z, base_centre=(-9.55mm, 53.2mm, -1.44mm), radius=0.15mm, height=1.68mm)
  V725_AC = cylinder(axis=Z, base_centre=(32.05mm, 51.6mm, -1.44mm), radius=0.15mm, height=1.68mm)
  V726_AC = cylinder(axis=Z, base_centre=(-6.55mm, 38.4mm, -1.44mm), radius=0.15mm, height=1.68mm)
  V727_AC = cylinder(axis=Z, base_centre=(-33.55mm, 51.6mm, -1.44mm), radius=0.15mm, height=1.68mm)
  V728_AC = cylinder(axis=Z, base_centre=(8.05mm, 58mm, -1.44mm), radius=0.15mm, height=1.68mm)
  V729_AC = cylinder(axis=Z, base_centre=(12.85mm, 45.2mm, -1.44mm), radius=0.15mm, height=1.68mm)
  V730_AC = cylinder(axis=Z, base_centre=(-17.55mm, 51.6mm, -1.44mm), radius=0.15mm, height=1.68mm)
  V731_AC = cylinder(axis=Z, base_centre=(12.85mm, 58mm, -1.44mm), radius=0.15mm, height=1.68mm)
  V732_AC = cylinder(axis=Z, base_centre=(4.45mm, 43.2mm, -1.44mm), radius=0.15mm, height=1.68mm)
  V733_AC = cylinder(axis=Z, base_centre=(11.25mm, 56.4mm, -1.44mm), radius=0.15mm, height=1.68mm)
  V734_AC = cylinder(axis=Z, base_centre=(28.85mm, 58mm, -1.44mm), radius=0.15mm, height=1.68mm)
  V735_AC = cylinder(axis=Z, base_centre=(32.05mm, 54.8mm, -1.44mm), radius=0.15mm, height=1.68mm)
  V736_AC = cylinder(axis=Z, base_centre=(-23.95mm, 56.4mm, -1.44mm), radius=0.15mm, height=1.68mm)
  V737_AC = cylinder(axis=Z, base_centre=(40.95mm, 39.6mm, -1.44mm), radius=0.15mm, height=1.68mm)
  V738_AC = cylinder(axis=Z, base_centre=(14.45mm, 50mm, -1.44mm), radius=0.15mm, height=1.68mm)
  V739_AC = cylinder(axis=Z, base_centre=(-12.75mm, 45.2mm, -1.44mm), radius=0.15mm, height=1.68mm)
  V740_AC = cylinder(axis=Z, base_centre=(-14.35mm, 50mm, -1.44mm), radius=0.15mm, height=1.68mm)
  V741_AC = cylinder(axis=Z, base_centre=(42.15mm, 42mm, -1.44mm), radius=0.15mm, height=1.68mm)
  V742_AC = cylinder(axis=Z, base_centre=(-30.35mm, 51.6mm, -1.44mm), radius=0.15mm, height=1.68mm)
  V743_AC = cylinder(axis=Z, base_centre=(25.65mm, 53.2mm, -1.44mm), radius=0.15mm, height=1.68mm)
  V744_AC = cylinder(axis=Z, base_centre=(8.05mm, 48.4mm, -1.44mm), radius=0.15mm, height=1.68mm)
  V745_AC = cylinder(axis=Z, base_centre=(11.25mm, 46.8mm, -1.44mm), radius=0.15mm, height=1.68mm)
  V746_AC = cylinder(axis=Z, base_centre=(4.45mm, 38.4mm, -1.44mm), radius=0.15mm, height=1.68mm)
  V747_AC = cylinder(axis=Z, base_centre=(-28.75mm, 48.4mm, -1.44mm), radius=0.15mm, height=1.68mm)
  V748_AC = cylinder(axis=Z, base_centre=(-41.85mm, 34.8mm, -1.44mm), radius=0.15mm, height=1.68mm)
  V749_AC = cylinder(axis=Z, base_centre=(-20.75mm, 54.8mm, -1.44mm), radius=0.15mm, height=1.68mm)
  V750_AC = cylinder(axis=Z, base_centre=(4.45mm, 37.2mm, -1.44mm), radius=0.15mm, height=1.68mm)
  V751_AC = cylinder(axis=Z, base_centre=(-5.35mm, 37.2mm, -1.44mm), radius=0.15mm, height=1.68mm)
  V752_AC = cylinder(axis=Z, base_centre=(-7.95mm, 53.2mm, -1.44mm), radius=0.15mm, height=1.68mm)
  V753_AC = cylinder(axis=Z, base_centre=(11.25mm, 58mm, -1.44mm), radius=0.15mm, height=1.68mm)
  V754_AC = cylinder(axis=Z, base_centre=(-20.75mm, 56.4mm, -1.44mm), radius=0.15mm, height=1.68mm)
  V755_AC = cylinder(axis=Z, base_centre=(-5.3259mm, 54.1305mm, -1.44mm), radius=0.2mm, height=1.68mm)
  V756_AC = cylinder(axis=Z, base_centre=(-3.2916mm, 56.9305mm, -1.44mm), radius=0.2mm, height=1.68mm)
  V757_AC = cylinder(axis=Z, base_centre=(0mm, 46.8mm, -1.44mm), radius=0.2mm, height=1.68mm)
  V758_AC = cylinder(axis=Z, base_centre=(2.2mm, 48.5895mm, -1.44mm), radius=0.2mm, height=1.68mm)
  V759_AC = cylinder(axis=Z, base_centre=(3.2916mm, 56.9305mm, -1.44mm), radius=0.2mm, height=1.68mm)
  V760_AC = cylinder(axis=Z, base_centre=(5.3259mm, 54.1305mm, -1.44mm), radius=0.2mm, height=1.68mm)
  Q4_3 = box(corner=(-15.85mm, 7.4mm, 0.17mm), size=(0.65mm, 3.6mm, 0.105mm))
  Q4_4 = box(corner=(-15mm, 7.4mm, 0.17mm), size=(0.65mm, 3.6mm, 0.105mm))
  Q4_5 = box(corner=(-14.15mm, 7.4mm, 0.17mm), size=(0.65mm, 3.6mm, 0.105mm))
  Q4_6 = box(corner=(-13.3mm, 7.4mm, 0.17mm), size=(0.65mm, 3.6mm, 0.105mm))
  Q4_7 = box(corner=(-12.449mm, 7.4mm, 0.17mm), size=(1.102mm, 3.6mm, 0.105mm))
  Q5_3 = box(corner=(15.2mm, 3.1mm, 0.17mm), size=(0.65mm, 3.6mm, 0.105mm))
  Q5_4 = box(corner=(14.35mm, 3.1mm, 0.17mm), size=(0.65mm, 3.6mm, 0.105mm))
  Q5_5 = box(corner=(13.5mm, 3.1mm, 0.17mm), size=(0.65mm, 3.6mm, 0.105mm))
  Q5_6 = box(corner=(12.65mm, 3.1mm, 0.17mm), size=(0.65mm, 3.6mm, 0.105mm))
  Q5_7 = box(corner=(11.347mm, 3.1mm, 0.17mm), size=(1.102mm, 3.6mm, 0.105mm))
  Q2_3 = box(corner=(-15.85mm, 3.1mm, 0.17mm), size=(0.65mm, 3.6mm, 0.105mm))
  Q2_4 = box(corner=(-15mm, 3.1mm, 0.17mm), size=(0.65mm, 3.6mm, 0.105mm))
  Q2_5 = box(corner=(-14.15mm, 3.1mm, 0.17mm), size=(0.65mm, 3.6mm, 0.105mm))
  Q2_6 = box(corner=(-13.3mm, 3.1mm, 0.17mm), size=(0.65mm, 3.6mm, 0.105mm))
  Q2_7 = box(corner=(-12.449mm, 3.1mm, 0.17mm), size=(1.102mm, 3.6mm, 0.105mm))
  Q3_3 = box(corner=(-32.3mm, 7.4mm, 0.17mm), size=(0.65mm, 3.6mm, 0.105mm))
  Q3_4 = box(corner=(-33.15mm, 7.4mm, 0.17mm), size=(0.65mm, 3.6mm, 0.105mm))
  Q3_5 = box(corner=(-34mm, 7.4mm, 0.17mm), size=(0.65mm, 3.6mm, 0.105mm))
  Q3_6 = box(corner=(-34.85mm, 7.4mm, 0.17mm), size=(0.65mm, 3.6mm, 0.105mm))
  Q3_7 = box(corner=(-36.153mm, 7.4mm, 0.17mm), size=(1.102mm, 3.6mm, 0.105mm))
  Q1_3 = box(corner=(-32.3mm, 3.1mm, 0.17mm), size=(0.65mm, 3.6mm, 0.105mm))
  Q1_4 = box(corner=(-33.15mm, 3.1mm, 0.17mm), size=(0.65mm, 3.6mm, 0.105mm))
  Q1_5 = box(corner=(-34mm, 3.1mm, 0.17mm), size=(0.65mm, 3.6mm, 0.105mm))
  Q1_6 = box(corner=(-34.85mm, 3.1mm, 0.17mm), size=(0.65mm, 3.6mm, 0.105mm))
  Q1_7 = box(corner=(-36.153mm, 3.1mm, 0.17mm), size=(1.102mm, 3.6mm, 0.105mm))
  Q7_3 = box(corner=(15.2mm, 7.4mm, 0.17mm), size=(0.65mm, 3.6mm, 0.105mm))
  Q7_4 = box(corner=(14.35mm, 7.4mm, 0.17mm), size=(0.65mm, 3.6mm, 0.105mm))
  Q7_5 = box(corner=(13.5mm, 7.4mm, 0.17mm), size=(0.65mm, 3.6mm, 0.105mm))
  Q7_6 = box(corner=(12.65mm, 7.4mm, 0.17mm), size=(0.65mm, 3.6mm, 0.105mm))
  Q7_7 = box(corner=(11.347mm, 7.4mm, 0.17mm), size=(1.102mm, 3.6mm, 0.105mm))
  Q6_3 = box(corner=(31.65mm, 3.1mm, 0.17mm), size=(0.65mm, 3.6mm, 0.105mm))
  Q6_4 = box(corner=(32.5mm, 3.1mm, 0.17mm), size=(0.65mm, 3.6mm, 0.105mm))
  Q6_5 = box(corner=(33.35mm, 3.1mm, 0.17mm), size=(0.65mm, 3.6mm, 0.105mm))
  Q6_6 = box(corner=(34.2mm, 3.1mm, 0.17mm), size=(0.65mm, 3.6mm, 0.105mm))
  Q6_7 = box(corner=(35.051mm, 3.1mm, 0.17mm), size=(1.102mm, 3.6mm, 0.105mm))
  Q8_3 = box(corner=(31.65mm, 7.4mm, 0.17mm), size=(0.65mm, 3.6mm, 0.105mm))
  Q8_4 = box(corner=(32.5mm, 7.4mm, 0.17mm), size=(0.65mm, 3.6mm, 0.105mm))
  Q8_5 = box(corner=(33.35mm, 7.4mm, 0.17mm), size=(0.65mm, 3.6mm, 0.105mm))
  Q8_6 = box(corner=(34.2mm, 7.4mm, 0.17mm), size=(0.65mm, 3.6mm, 0.105mm))
  Q8_7 = box(corner=(35.051mm, 7.4mm, 0.17mm), size=(1.102mm, 3.6mm, 0.105mm))
  C35_1 = box(corner=(11.125mm, 1.55mm, 0.17mm), size=(1.45mm, 1mm, 0.105mm))
  C35_2 = box(corner=(11.125mm, -0.35mm, 0.17mm), size=(1.45mm, 1mm, 0.105mm))
  C80_1 = box(corner=(12.3mm, -2.85mm, 0.17mm), size=(5.4mm, 1.8mm, 0.105mm))
  C80_2 = box(corner=(12.3mm, -7.95mm, 0.17mm), size=(5.4mm, 1.8mm, 0.105mm))
  C68_1 = box(corner=(12.3mm, -10.3mm, 0.17mm), size=(5.4mm, 1.8mm, 0.105mm))
  C68_2 = box(corner=(12.3mm, -15.4mm, 0.17mm), size=(5.4mm, 1.8mm, 0.105mm))
  C43_1 = box(corner=(33.325mm, 1.55mm, 0.17mm), size=(1.45mm, 1mm, 0.105mm))
  C43_2 = box(corner=(33.325mm, -0.35mm, 0.17mm), size=(1.45mm, 1mm, 0.105mm))
  C76_1 = box(corner=(0.3mm, -2.85mm, 0.17mm), size=(5.4mm, 1.8mm, 0.105mm))
  C76_2 = box(corner=(0.3mm, -7.95mm, 0.17mm), size=(5.4mm, 1.8mm, 0.105mm))
  C42_1 = box(corner=(31.725mm, 1.55mm, 0.17mm), size=(1.45mm, 1mm, 0.105mm))
  C42_2 = box(corner=(31.725mm, -0.35mm, 0.17mm), size=(1.45mm, 1mm, 0.105mm))
  C41_1 = box(corner=(30.125mm, 1.55mm, 0.17mm), size=(1.45mm, 1mm, 0.105mm))
  C41_2 = box(corner=(30.125mm, -0.35mm, 0.17mm), size=(1.45mm, 1mm, 0.105mm))
  C86_1 = box(corner=(30.3mm, -2.85mm, 0.17mm), size=(5.4mm, 1.8mm, 0.105mm))
  C86_2 = box(corner=(30.3mm, -7.95mm, 0.17mm), size=(5.4mm, 1.8mm, 0.105mm))
  RS4_1 = box(corner=(28.65mm, 11.2mm, 0.17mm), size=(15mm, 1.2mm, 0.105mm))
  RS4_2 = box(corner=(28.65mm, 12.9mm, 0.17mm), size=(15mm, 3mm, 0.105mm))
  C71_1 = box(corner=(-29.7mm, -10.3mm, 0.17mm), size=(5.4mm, 1.8mm, 0.105mm))
  C71_2 = box(corner=(-29.7mm, -15.4mm, 0.17mm), size=(5.4mm, 1.8mm, 0.105mm))
  J_AC = box(corner=(-6mm, 46.4mm, -1.475mm), size=(12mm, 12mm, 0.105mm))
  C3_1 = box(corner=(-34.775mm, 1.55mm, 0.17mm), size=(1.45mm, 1mm, 0.105mm))
  C3_2 = box(corner=(-34.775mm, -0.35mm, 0.17mm), size=(1.45mm, 1mm, 0.105mm))
  C77_1 = box(corner=(-11.7mm, -2.85mm, 0.17mm), size=(5.4mm, 1.8mm, 0.105mm))
  C77_2 = box(corner=(-11.7mm, -7.95mm, 0.17mm), size=(5.4mm, 1.8mm, 0.105mm))
  C1_1 = box(corner=(-37.975mm, 1.55mm, 0.17mm), size=(1.45mm, 1mm, 0.105mm))
  C1_2 = box(corner=(-37.975mm, -0.35mm, 0.17mm), size=(1.45mm, 1mm, 0.105mm))
  C85_1 = box(corner=(-35.7mm, -2.85mm, 0.17mm), size=(5.4mm, 1.8mm, 0.105mm))
  C85_2 = box(corner=(-35.7mm, -7.95mm, 0.17mm), size=(5.4mm, 1.8mm, 0.105mm))
  C34_1 = box(corner=(9.525mm, 1.55mm, 0.17mm), size=(1.45mm, 1mm, 0.105mm))
  C34_2 = box(corner=(9.525mm, -0.35mm, 0.17mm), size=(1.45mm, 1mm, 0.105mm))
  C12_1 = box(corner=(-10.975mm, 1.55mm, 0.17mm), size=(1.45mm, 1mm, 0.105mm))
  C12_2 = box(corner=(-10.975mm, -0.35mm, 0.17mm), size=(1.45mm, 1mm, 0.105mm))
  C6_1 = box(corner=(-29.975mm, 1.55mm, 0.17mm), size=(1.45mm, 1mm, 0.105mm))
  C6_2 = box(corner=(-29.975mm, -0.35mm, 0.17mm), size=(1.45mm, 1mm, 0.105mm))
  C11_1 = box(corner=(-12.575mm, 1.55mm, 0.17mm), size=(1.45mm, 1mm, 0.105mm))
  C11_2 = box(corner=(-12.575mm, -0.35mm, 0.17mm), size=(1.45mm, 1mm, 0.105mm))
  C44_1 = box(corner=(34.925mm, 1.55mm, 0.17mm), size=(1.45mm, 1mm, 0.105mm))
  C44_2 = box(corner=(34.925mm, -0.35mm, 0.17mm), size=(1.45mm, 1mm, 0.105mm))
  C74_1 = box(corner=(30.3mm, -10.3mm, 0.17mm), size=(5.4mm, 1.8mm, 0.105mm))
  C74_2 = box(corner=(30.3mm, -15.4mm, 0.17mm), size=(5.4mm, 1.8mm, 0.105mm))
  C81_1 = box(corner=(-23.7mm, -2.85mm, 0.17mm), size=(5.4mm, 1.8mm, 0.105mm))
  C81_2 = box(corner=(-23.7mm, -7.95mm, 0.17mm), size=(5.4mm, 1.8mm, 0.105mm))
  C40_1 = box(corner=(28.525mm, 1.55mm, 0.17mm), size=(1.45mm, 1mm, 0.105mm))
  C40_2 = box(corner=(28.525mm, -0.35mm, 0.17mm), size=(1.45mm, 1mm, 0.105mm))
  C72_1 = box(corner=(24.3mm, -10.3mm, 0.17mm), size=(5.4mm, 1.8mm, 0.105mm))
  C72_2 = box(corner=(24.3mm, -15.4mm, 0.17mm), size=(5.4mm, 1.8mm, 0.105mm))
  C4_1 = box(corner=(-33.175mm, 1.55mm, 0.17mm), size=(1.45mm, 1mm, 0.105mm))
  C4_2 = box(corner=(-33.175mm, -0.35mm, 0.17mm), size=(1.45mm, 1mm, 0.105mm))
  C69_1 = box(corner=(-23.7mm, -10.3mm, 0.17mm), size=(5.4mm, 1.8mm, 0.105mm))
  C69_2 = box(corner=(-23.7mm, -15.4mm, 0.17mm), size=(5.4mm, 1.8mm, 0.105mm))
  C10_1 = box(corner=(-14.175mm, 1.55mm, 0.17mm), size=(1.45mm, 1mm, 0.105mm))
  C10_2 = box(corner=(-14.175mm, -0.35mm, 0.17mm), size=(1.45mm, 1mm, 0.105mm))
  C37_1 = box(corner=(14.325mm, 1.55mm, 0.17mm), size=(1.45mm, 1mm, 0.105mm))
  C37_2 = box(corner=(14.325mm, -0.35mm, 0.17mm), size=(1.45mm, 1mm, 0.105mm))
  C39_1 = box(corner=(17.525mm, 1.55mm, 0.17mm), size=(1.45mm, 1mm, 0.105mm))
  C39_2 = box(corner=(17.525mm, -0.35mm, 0.17mm), size=(1.45mm, 1mm, 0.105mm))
  C83_1 = box(corner=(-29.7mm, -2.85mm, 0.17mm), size=(5.4mm, 1.8mm, 0.105mm))
  C83_2 = box(corner=(-29.7mm, -7.95mm, 0.17mm), size=(5.4mm, 1.8mm, 0.105mm))
  C5_1 = box(corner=(-31.575mm, 1.55mm, 0.17mm), size=(1.45mm, 1mm, 0.105mm))
  C5_2 = box(corner=(-31.575mm, -0.35mm, 0.17mm), size=(1.45mm, 1mm, 0.105mm))
  C36_1 = box(corner=(12.725mm, 1.55mm, 0.17mm), size=(1.45mm, 1mm, 0.105mm))
  C36_2 = box(corner=(12.725mm, -0.35mm, 0.17mm), size=(1.45mm, 1mm, 0.105mm))
  RS3_1 = box(corner=(3.85mm, 11.2mm, 0.17mm), size=(15mm, 1.2mm, 0.105mm))
  RS3_2 = box(corner=(3.85mm, 12.9mm, 0.17mm), size=(15mm, 3mm, 0.105mm))
  C38_1 = box(corner=(15.925mm, 1.55mm, 0.17mm), size=(1.45mm, 1mm, 0.105mm))
  C38_2 = box(corner=(15.925mm, -0.35mm, 0.17mm), size=(1.45mm, 1mm, 0.105mm))
  C45_1 = box(corner=(36.525mm, 1.55mm, 0.17mm), size=(1.45mm, 1mm, 0.105mm))
  C45_2 = box(corner=(36.525mm, -0.35mm, 0.17mm), size=(1.45mm, 1mm, 0.105mm))
  C84_1 = box(corner=(24.3mm, -2.85mm, 0.17mm), size=(5.4mm, 1.8mm, 0.105mm))
  C84_2 = box(corner=(24.3mm, -7.95mm, 0.17mm), size=(5.4mm, 1.8mm, 0.105mm))
  C73_1 = box(corner=(-35.7mm, -10.3mm, 0.17mm), size=(5.4mm, 1.8mm, 0.105mm))
  C73_2 = box(corner=(-35.7mm, -15.4mm, 0.17mm), size=(5.4mm, 1.8mm, 0.105mm))
  C8_1 = box(corner=(-17.375mm, 1.55mm, 0.17mm), size=(1.45mm, 1mm, 0.105mm))
  C8_2 = box(corner=(-17.375mm, -0.35mm, 0.17mm), size=(1.45mm, 1mm, 0.105mm))
  C9_1 = box(corner=(-15.775mm, 1.55mm, 0.17mm), size=(1.45mm, 1mm, 0.105mm))
  C9_2 = box(corner=(-15.775mm, -0.35mm, 0.17mm), size=(1.45mm, 1mm, 0.105mm))
  C82_1 = box(corner=(18.3mm, -2.85mm, 0.17mm), size=(5.4mm, 1.8mm, 0.105mm))
  C82_2 = box(corner=(18.3mm, -7.95mm, 0.17mm), size=(5.4mm, 1.8mm, 0.105mm))
  C7_1 = box(corner=(-18.975mm, 1.55mm, 0.17mm), size=(1.45mm, 1mm, 0.105mm))
  C7_2 = box(corner=(-18.975mm, -0.35mm, 0.17mm), size=(1.45mm, 1mm, 0.105mm))
  RS2_1 = box(corner=(-18.85mm, 11.2mm, 0.17mm), size=(15mm, 1.2mm, 0.105mm))
  RS2_2 = box(corner=(-18.85mm, 12.9mm, 0.17mm), size=(15mm, 3mm, 0.105mm))
  C79_1 = box(corner=(-17.7mm, -2.85mm, 0.17mm), size=(5.4mm, 1.8mm, 0.105mm))
  C79_2 = box(corner=(-17.7mm, -7.95mm, 0.17mm), size=(5.4mm, 1.8mm, 0.105mm))
  C75_1 = box(corner=(-5.7mm, -2.85mm, 0.17mm), size=(5.4mm, 1.8mm, 0.105mm))
  C75_2 = box(corner=(-5.7mm, -7.95mm, 0.17mm), size=(5.4mm, 1.8mm, 0.105mm))
  RS1_1 = box(corner=(-43.65mm, 11.2mm, 0.17mm), size=(15mm, 1.2mm, 0.105mm))
  RS1_2 = box(corner=(-43.65mm, 12.9mm, 0.17mm), size=(15mm, 3mm, 0.105mm))
  C78_1 = box(corner=(6.3mm, -2.85mm, 0.17mm), size=(5.4mm, 1.8mm, 0.105mm))
  C78_2 = box(corner=(6.3mm, -7.95mm, 0.17mm), size=(5.4mm, 1.8mm, 0.105mm))
  C70_1 = box(corner=(18.3mm, -10.3mm, 0.17mm), size=(5.4mm, 1.8mm, 0.105mm))
  C70_2 = box(corner=(18.3mm, -15.4mm, 0.17mm), size=(5.4mm, 1.8mm, 0.105mm))
  C67_1 = box(corner=(-17.7mm, -10.3mm, 0.17mm), size=(5.4mm, 1.8mm, 0.105mm))
  C67_2 = box(corner=(-17.7mm, -15.4mm, 0.17mm), size=(5.4mm, 1.8mm, 0.105mm))
  C2_1 = box(corner=(-36.375mm, 1.55mm, 0.17mm), size=(1.45mm, 1mm, 0.105mm))
  C2_2 = box(corner=(-36.375mm, -0.35mm, 0.17mm), size=(1.45mm, 1mm, 0.105mm))
  C27_1 = box(corner=(-33.175mm, -0.25mm, -1.475mm), size=(1.45mm, 1mm, 0.105mm))
  C27_2 = box(corner=(-33.175mm, 1.65mm, -1.475mm), size=(1.45mm, 1mm, 0.105mm))
  J_DCP = box(corner=(-9.5mm, -22.3mm, -1.475mm), size=(7mm, 7mm, 0.105mm))
  C61_1 = box(corner=(15.925mm, -0.25mm, -1.475mm), size=(1.45mm, 1mm, 0.105mm))
  C61_2 = box(corner=(15.925mm, 1.65mm, -1.475mm), size=(1.45mm, 1mm, 0.105mm))
  C31_1 = box(corner=(-15.775mm, -0.25mm, -1.475mm), size=(1.45mm, 1mm, 0.105mm))
  C31_2 = box(corner=(-15.775mm, 1.65mm, -1.475mm), size=(1.45mm, 1mm, 0.105mm))
  C62_1 = box(corner=(17.525mm, -0.25mm, -1.475mm), size=(1.45mm, 1mm, 0.105mm))
  C62_2 = box(corner=(17.525mm, 1.65mm, -1.475mm), size=(1.45mm, 1mm, 0.105mm))
  C64_1 = box(corner=(31.725mm, -0.25mm, -1.475mm), size=(1.45mm, 1mm, 0.105mm))
  C64_2 = box(corner=(31.725mm, 1.65mm, -1.475mm), size=(1.45mm, 1mm, 0.105mm))
  C26_1 = box(corner=(-34.775mm, -0.25mm, -1.475mm), size=(1.45mm, 1mm, 0.105mm))
  C26_2 = box(corner=(-34.775mm, 1.65mm, -1.475mm), size=(1.45mm, 1mm, 0.105mm))
  C65_1 = box(corner=(30.125mm, -0.25mm, -1.475mm), size=(1.45mm, 1mm, 0.105mm))
  C65_2 = box(corner=(30.125mm, 1.65mm, -1.475mm), size=(1.45mm, 1mm, 0.105mm))
  C30_1 = box(corner=(-14.175mm, -0.25mm, -1.475mm), size=(1.45mm, 1mm, 0.105mm))
  C30_2 = box(corner=(-14.175mm, 1.65mm, -1.475mm), size=(1.45mm, 1mm, 0.105mm))
  C33_1 = box(corner=(-18.975mm, -0.25mm, -1.475mm), size=(1.45mm, 1mm, 0.105mm))
  C33_2 = box(corner=(-18.975mm, 1.65mm, -1.475mm), size=(1.45mm, 1mm, 0.105mm))
  C66_1 = box(corner=(28.525mm, -0.25mm, -1.475mm), size=(1.45mm, 1mm, 0.105mm))
  C66_2 = box(corner=(28.525mm, 1.65mm, -1.475mm), size=(1.45mm, 1mm, 0.105mm))
  C59_1 = box(corner=(12.725mm, -0.25mm, -1.475mm), size=(1.45mm, 1mm, 0.105mm))
  C59_2 = box(corner=(12.725mm, 1.65mm, -1.475mm), size=(1.45mm, 1mm, 0.105mm))
  C29_1 = box(corner=(-29.975mm, -0.25mm, -1.475mm), size=(1.45mm, 1mm, 0.105mm))
  C29_2 = box(corner=(-29.975mm, 1.65mm, -1.475mm), size=(1.45mm, 1mm, 0.105mm))
  C28_1 = box(corner=(-31.575mm, -0.25mm, -1.475mm), size=(1.45mm, 1mm, 0.105mm))
  C28_2 = box(corner=(-31.575mm, 1.65mm, -1.475mm), size=(1.45mm, 1mm, 0.105mm))
  C32_1 = box(corner=(-17.375mm, -0.25mm, -1.475mm), size=(1.45mm, 1mm, 0.105mm))
  C32_2 = box(corner=(-17.375mm, 1.65mm, -1.475mm), size=(1.45mm, 1mm, 0.105mm))
  J_DCN = box(corner=(2.5mm, -22.3mm, -1.475mm), size=(7mm, 7mm, 0.105mm))
  C63_1 = box(corner=(33.325mm, -0.25mm, -1.475mm), size=(1.45mm, 1mm, 0.105mm))
  C63_2 = box(corner=(33.325mm, 1.65mm, -1.475mm), size=(1.45mm, 1mm, 0.105mm))
  C60_1 = box(corner=(14.325mm, -0.25mm, -1.475mm), size=(1.45mm, 1mm, 0.105mm))
  C60_2 = box(corner=(14.325mm, 1.65mm, -1.475mm), size=(1.45mm, 1mm, 0.105mm))
  P32_AC_L1.unite(P33_AC_L1, P34_AC_L1, P35_AC_L1, P36_AC_L1, P37_AC_L2, P38_AC_L3, P39_AC_L4, V452_AC, V453_AC, V454_AC, V455_AC, V456_AC, V457_AC, V458_AC, V459_AC, V460_AC, V461_AC, V462_AC, V463_AC, V464_AC, V465_AC, V466_AC, V467_AC, V468_AC, V469_AC, V470_AC, V471_AC, V472_AC, V473_AC, V474_AC, V475_AC, V476_AC, V477_AC, V478_AC, V479_AC, V480_AC, V481_AC, V482_AC, V483_AC, V484_AC, V485_AC, V486_AC, V487_AC, V488_AC, V489_AC, V490_AC, V491_AC, V492_AC, V493_AC, V494_AC, V495_AC, V496_AC, V497_AC, V498_AC, V499_AC, V500_AC, V501_AC, V502_AC, V503_AC, V504_AC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)
  P32_AC_L1.separate_bodies()
  P28_LSRC3_L1.unite(P29_LSRC3_L4, V578_LSRC3, Q7_4, Q7_6, RS3_1)
  P28_LSRC3_L1.separate_bodies()
  P26_LSRC2_L1.unite(P27_LSRC2_L4, V577_LSRC2, Q4_4, Q4_6, RS2_1)
  P26_LSRC2_L1.separate_bodies()
  P24_LSRC1_L1.unite(P25_LSRC1_L4, V576_LSRC1, Q3_4, Q3_6, RS1_1)
  P24_LSRC1_L1.separate_bodies()
  P30_LSRC4_L1.unite(P31_LSRC4_L4, V579_LSRC4, Q8_4, Q8_6, RS4_1)
  P30_LSRC4_L1.separate_bodies()
  P0_DCN_L1.unite(P1_DCN_L1, P2_DCN_L1, P3_DCN_L1, P4_DCN_L1, P5_DCN_L1, P6_DCN_L2, P7_DCN_L4, P8_DCN_L4, P9_DCN_L4, P10_DCN_L4, P11_DCN_L4, V164_DCN, V165_DCN, V166_DCN, V167_DCN, V168_DCN, V169_DCN, V170_DCN, V171_DCN, V172_DCN, V173_DCN, V174_DCN, V175_DCN, V176_DCN, V177_DCN, V178_DCN, V179_DCN, V180_DCN, V181_DCN, V182_DCN, V183_DCN, V184_DCN, V185_DCN, V186_DCN, V187_DCN, V188_DCN, V189_DCN, V190_DCN, V191_DCN, V192_DCN, V193_DCN, V194_DCN, V195_DCN, V196_DCN, V197_DCN, V198_DCN, V199_DCN, V200_DCN, V201_DCN, V202_DCN, V203_DCN, V204_DCN, V205_DCN, V206_DCN, V207_DCN, V208_DCN, V209_DCN, V210_DCN, V211_DCN, V212_DCN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)
  P0_DCN_L1.separate_bodies()
  P12_DCP_L1.unite(P13_DCP_L1, P14_DCP_L1, P15_DCP_L1, P16_DCP_L1, P17_DCP_L1, P18_DCP_L3, P19_DCP_L4, P20_DCP_L4, P21_DCP_L4, P22_DCP_L4, P23_DCP_L4, V0_DCP, V1_DCP, V2_DCP, V3_DCP, V4_DCP, V5_DCP, V6_DCP, V7_DCP, V8_DCP, V9_DCP, V10_DCP, V11_DCP, V12_DCP, V13_DCP, V14_DCP, V15_DCP, V16_DCP, V17_DCP, V18_DCP, V19_DCP, V20_DCP, V21_DCP, V22_DCP, V23_DCP, V24_DCP, V25_DCP, V26_DCP, V27_DCP, V28_DCP, V29_DCP, V30_DCP, V31_DCP, V32_DCP, V33_DCP, V34_DCP, V35_DCP, V36_DCP, V37_DCP, V38_DCP, V39_DCP, V40_DCP, V41_DCP, V42_DCP, V43_DCP, V44_DCP, V45_DCP, V46_DCP, V47_DCP, V48_DCP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)
  P12_DCP_L1.separate_bodies()
boundaries and excitations:
  AC: SignalNet Objects=P32_AC_L1
  LSRC3: SignalNet Objects=P28_LSRC3_L1
  LSRC2: SignalNet Objects=P26_LSRC2_L1
  LSRC1: SignalNet Objects=P24_LSRC1_L1
  LSRC4: SignalNet Objects=P30_LSRC4_L1
  DCN: SignalNet Objects=P0_DCN_L1
  DCP: SignalNet Objects=P12_DCP_L1
  BankN_1: Source Faces=P0_DCN_L1.face(at (-27, -9.4, 0.275), at (-33, -1.95, 0.275), at (-27, -1.95, 0.275), at (-33, -9.4, 0.275)) TerminalType=ConstantVoltage Net=DCN
  BankN_2: Source Faces=P0_DCN_L1.face(at (-9, -1.95, 0.275), at (-21, -1.95, 0.275), at (-21, -9.4, 0.275), at (-15, -1.95, 0.275), at (-15, -9.4, 0.275)) TerminalType=ConstantVoltage Net=DCN
  BankN_3: Source Faces=P0_DCN_L1.face(at (15, -1.95, 0.275), at (15, -9.4, 0.275), at (21, -1.95, 0.275), at (9, -1.95, 0.275), at (21, -9.4, 0.275)) TerminalType=ConstantVoltage Net=DCN
  BankN_4: Source Faces=P0_DCN_L1.face(at (33, -1.95, 0.275), at (33, -9.4, 0.275), at (27, -9.4, 0.275), at (27, -1.95, 0.275)) TerminalType=ConstantVoltage Net=DCN
  BankN_C: Source Faces=P0_DCN_L1.face(at (3, -1.95, 0.275), at (-3, -1.95, 0.275)) TerminalType=ConstantVoltage Net=DCN
  BankP_1: Source Faces=P12_DCP_L1.face(at (-27, -14.5, 0.275), at (-33, -7.05, 0.275), at (-27, -7.05, 0.275), at (-33, -14.5, 0.275)) TerminalType=ConstantVoltage Net=DCP
  BankP_2: Source Faces=P12_DCP_L1.face(at (-9, -7.05, 0.275), at (-21, -7.05, 0.275), at (-21, -14.5, 0.275), at (-15, -7.05, 0.275), at (-15, -14.5, 0.275)) TerminalType=ConstantVoltage Net=DCP
  BankP_3: Source Faces=P12_DCP_L1.face(at (15, -7.05, 0.275), at (15, -14.5, 0.275), at (21, -7.05, 0.275), at (9, -7.05, 0.275), at (21, -14.5, 0.275)) TerminalType=ConstantVoltage Net=DCP
  BankP_4: Source Faces=P12_DCP_L1.face(at (33, -7.05, 0.275), at (33, -14.5, 0.275), at (27, -14.5, 0.275), at (27, -7.05, 0.275)) TerminalType=ConstantVoltage Net=DCP
  BankP_C: Source Faces=P12_DCP_L1.face(at (3, -7.05, 0.275), at (-3, -7.05, 0.275)) TerminalType=ConstantVoltage Net=DCP
  CapN_2: Source Faces=P0_DCN_L1.face(at (-10.25, 0.15, 0.275), at (-11.85, 0.15, 0.275), at (-13.45, 0.15, 0.275), at (-16.65, 0.15, 0.275), at (-15.05, 0.15, 0.275), at (-18.25, 0.15, 0.275)) TerminalType=ConstantVoltage Net=DCN
  CapN_3: Source Faces=P0_DCN_L1.face(at (11.85, 0.15, 0.275), at (10.25, 0.15, 0.275), at (15.05, 0.15, 0.275), at (18.25, 0.15, 0.275), at (13.45, 0.15, 0.275), at (16.65, 0.15, 0.275)) TerminalType=ConstantVoltage Net=DCN
  CapN_4: Source Faces=P0_DCN_L1.face(at (34.05, 0.15, 0.275), at (32.45, 0.15, 0.275), at (30.85, 0.15, 0.275), at (35.65, 0.15, 0.275), at (29.25, 0.15, 0.275), at (37.25, 0.15, 0.275)) TerminalType=ConstantVoltage Net=DCN
  CapNb_1: Source Faces=P0_DCN_L1.face(at (-32.45, 0.25, -1.475), at (-34.05, 0.25, -1.475), at (-29.25, 0.25, -1.475), at (-30.85, 0.25, -1.475)) TerminalType=ConstantVoltage Net=DCN
  CapNb_2: Source Faces=P0_DCN_L1.face(at (-15.05, 0.25, -1.475), at (-13.45, 0.25, -1.475), at (-18.25, 0.25, -1.475), at (-16.65, 0.25, -1.475)) TerminalType=ConstantVoltage Net=DCN
  CapNb_3: Source Faces=P0_DCN_L1.face(at (16.65, 0.25, -1.475), at (18.25, 0.25, -1.475), at (13.45, 0.25, -1.475), at (15.05, 0.25, -1.475)) TerminalType=ConstantVoltage Net=DCN
  CapNb_4: Source Faces=P0_DCN_L1.face(at (32.45, 0.25, -1.475), at (30.85, 0.25, -1.475), at (29.25, 0.25, -1.475), at (34.05, 0.25, -1.475)) TerminalType=ConstantVoltage Net=DCN
  CapP_2: Source Faces=P12_DCP_L1.face(at (-10.25, 2.05, 0.275), at (-11.85, 2.05, 0.275), at (-13.45, 2.05, 0.275), at (-16.65, 2.05, 0.275), at (-15.05, 2.05, 0.275), at (-18.25, 2.05, 0.275)) TerminalType=ConstantVoltage Net=DCP
  CapP_3: Source Faces=P12_DCP_L1.face(at (11.85, 2.05, 0.275), at (10.25, 2.05, 0.275), at (15.05, 2.05, 0.275), at (18.25, 2.05, 0.275), at (13.45, 2.05, 0.275), at (16.65, 2.05, 0.275)) TerminalType=ConstantVoltage Net=DCP
  CapP_4: Source Faces=P12_DCP_L1.face(at (34.05, 2.05, 0.275), at (32.45, 2.05, 0.275), at (30.85, 2.05, 0.275), at (35.65, 2.05, 0.275), at (29.25, 2.05, 0.275), at (37.25, 2.05, 0.275)) TerminalType=ConstantVoltage Net=DCP
  CapPb_1: Source Faces=P12_DCP_L1.face(at (-32.45, 2.15, -1.475), at (-34.05, 2.15, -1.475), at (-29.25, 2.15, -1.475), at (-30.85, 2.15, -1.475)) TerminalType=ConstantVoltage Net=DCP
  CapPb_2: Source Faces=P12_DCP_L1.face(at (-15.05, 2.15, -1.475), at (-13.45, 2.15, -1.475), at (-18.25, 2.15, -1.475), at (-16.65, 2.15, -1.475)) TerminalType=ConstantVoltage Net=DCP
  CapPb_3: Source Faces=P12_DCP_L1.face(at (16.65, 2.15, -1.475), at (18.25, 2.15, -1.475), at (13.45, 2.15, -1.475), at (15.05, 2.15, -1.475)) TerminalType=ConstantVoltage Net=DCP
  CapPb_4: Source Faces=P12_DCP_L1.face(at (32.45, 2.15, -1.475), at (30.85, 2.15, -1.475), at (29.25, 2.15, -1.475), at (34.05, 2.15, -1.475)) TerminalType=ConstantVoltage Net=DCP
  J_AC: Source Faces=P32_AC_L1.face(at (0, 52.4, -1.475)) TerminalType=ConstantVoltage Net=AC
  J_DCN: Source Faces=P0_DCN_L1.face(at (6, -18.8, -1.475)) TerminalType=ConstantVoltage Net=DCN
  J_DCP: Source Faces=P12_DCP_L1.face(at (-6, -18.8, -1.475)) TerminalType=ConstantVoltage Net=DCP
  QH_D_1: Source Faces=P12_DCP_L1.face(at (-31.975, 4.9, 0.275), at (-33.675, 4.9, 0.275), at (-35.602, 4.9, 0.275)) TerminalType=ConstantVoltage Net=DCP
  QH_D_2: Source Faces=P12_DCP_L1.face(at (-15.525, 4.9, 0.275), at (-13.825, 4.9, 0.275), at (-11.898, 4.9, 0.275)) TerminalType=ConstantVoltage Net=DCP
  QH_D_3: Source Faces=P12_DCP_L1.face(at (15.525, 4.9, 0.275), at (13.825, 4.9, 0.275), at (11.898, 4.9, 0.275)) TerminalType=ConstantVoltage Net=DCP
  QH_D_4: Source Faces=P12_DCP_L1.face(at (31.975, 4.9, 0.275), at (33.675, 4.9, 0.275), at (35.602, 4.9, 0.275)) TerminalType=ConstantVoltage Net=DCP
  QH_S_2: Source Faces=P32_AC_L1.face(at (-14.675, 4.9, 0.275), at (-12.975, 4.9, 0.275)) TerminalType=ConstantVoltage Net=AC
  QH_S_3: Source Faces=P32_AC_L1.face(at (14.675, 4.9, 0.275), at (12.975, 4.9, 0.275)) TerminalType=ConstantVoltage Net=AC
  QH_S_4: Source Faces=P32_AC_L1.face(at (32.825, 4.9, 0.275), at (34.525, 4.9, 0.275)) TerminalType=ConstantVoltage Net=AC
  QL_D_1: Source Faces=P32_AC_L1.face(at (-31.975, 9.2, 0.275), at (-33.675, 9.2, 0.275), at (-35.602, 9.2, 0.275)) TerminalType=ConstantVoltage Net=AC
  QL_D_2: Source Faces=P32_AC_L1.face(at (-15.525, 9.2, 0.275), at (-13.825, 9.2, 0.275), at (-11.898, 9.2, 0.275)) TerminalType=ConstantVoltage Net=AC
  QL_D_3: Source Faces=P32_AC_L1.face(at (15.525, 9.2, 0.275), at (13.825, 9.2, 0.275), at (11.898, 9.2, 0.275)) TerminalType=ConstantVoltage Net=AC
  QL_D_4: Source Faces=P32_AC_L1.face(at (31.975, 9.2, 0.275), at (33.675, 9.2, 0.275), at (35.602, 9.2, 0.275)) TerminalType=ConstantVoltage Net=AC
  QL_S_1: Source Faces=P24_LSRC1_L1.face(at (-32.825, 9.2, 0.275), at (-34.525, 9.2, 0.275)) TerminalType=ConstantVoltage Net=LSRC1
  QL_S_2: Source Faces=P26_LSRC2_L1.face(at (-14.675, 9.2, 0.275), at (-12.975, 9.2, 0.275)) TerminalType=ConstantVoltage Net=LSRC2
  QL_S_3: Source Faces=P28_LSRC3_L1.face(at (14.675, 9.2, 0.275), at (12.975, 9.2, 0.275)) TerminalType=ConstantVoltage Net=LSRC3
  QL_S_4: Source Faces=P30_LSRC4_L1.face(at (32.825, 9.2, 0.275), at (34.525, 9.2, 0.275)) TerminalType=ConstantVoltage Net=LSRC4
  RSN_1: Source Faces=P0_DCN_L1.face(at (-36.15, 14.4, 0.275)) TerminalType=ConstantVoltage Net=DCN
  RSN_2: Source Faces=P0_DCN_L1.face(at (-11.35, 14.4, 0.275)) TerminalType=ConstantVoltage Net=DCN
  RSN_3: Source Faces=P0_DCN_L1.face(at (11.35, 14.4, 0.275)) TerminalType=ConstantVoltage Net=DCN
  RSN_4: Source Faces=P0_DCN_L1.face(at (36.15, 14.4, 0.275)) TerminalType=ConstantVoltage Net=DCN
  CapN_1: Sink Faces=P0_DCN_L1.face(at (-34.05, 0.15, 0.275), at (-37.25, 0.15, 0.275), at (-29.25, 0.15, 0.275), at (-32.45, 0.15, 0.275), at (-30.85, 0.15, 0.275), at (-35.65, 0.15, 0.275)) TerminalType=ConstantVoltage Net=DCN
  CapP_1: Sink Faces=P12_DCP_L1.face(at (-34.05, 2.05, 0.275), at (-37.25, 2.05, 0.275), at (-29.25, 2.05, 0.275), at (-32.45, 2.05, 0.275), at (-30.85, 2.05, 0.275), at (-35.65, 2.05, 0.275)) TerminalType=ConstantVoltage Net=DCP
  QH_S_1: Sink Faces=P32_AC_L1.face(at (-32.825, 4.9, 0.275), at (-34.525, 4.9, 0.275)) TerminalType=ConstantVoltage Net=AC
  RSI_1: Sink Faces=P24_LSRC1_L1.face(at (-36.15, 11.8, 0.275)) TerminalType=ConstantVoltage Net=LSRC1
  RSI_2: Sink Faces=P26_LSRC2_L1.face(at (-11.35, 11.8, 0.275)) TerminalType=ConstantVoltage Net=LSRC2
  RSI_3: Sink Faces=P28_LSRC3_L1.face(at (11.35, 11.8, 0.275)) TerminalType=ConstantVoltage Net=LSRC3
  RSI_4: Sink Faces=P30_LSRC4_L1.face(at (36.15, 11.8, 0.275)) TerminalType=ConstantVoltage Net=LSRC4
setups:
  Setup1: Matrix AdaptiveFreq=100MHz Cap{MaxPass=1 MinPass=1 MinConvPass=1 PerError=30 PerRefine=30 AutoIncreaseAccuracy AccuracyLevel=High Solver_Type=Iterative} DC{SolveResOnly Cond{MaxPass=3 MinPass=1 MinConvPass=1 PerError=5 PerRefine=30} Mult{MaxPass=1 MinPass=1 MinConvPass=1 PerError=1 PerRefine=30} AccuracyLevel=Normal} AC{MaxPass=8 MinPass=2 MinConvPass=1 PerError=2 PerRefine=30 ACRLSolverType=ACA} ErrorValue=0.1
source amplitudes:
  AC:J_AC, AC:QH_S_2, AC:QH_S_3, AC:QH_S_4, AC:QL_D_1..AC:QL_D_4, DCN:BankN_2, DCN:BankN_3, DCN:BankN_4, DCN:BankN_C, DCN:CapN_2, DCN:CapN_3, DCN:CapN_4, DCN:CapNb_1..DCN:CapNb_4, DCN:J_DCN, DCN:RSN_1..DCN:RSN_4, DCP:BankP_1..DCP:BankP_4, DCP:BankP_C, DCP:CapP_2, DCP:CapP_3, DCP:CapP_4, DCP:CapPb_1..DCP:CapPb_4, DCP:J_DCP, DCP:QH_D_1..DCP:QH_D_4, LSRC1:QL_S_1, LSRC2:QL_S_2, LSRC3:QL_S_3, LSRC4:QL_S_4: AC R/L Fields 0A
  DCN:BankN_1: AC R/L Fields 1A
  AC: CG Fields 1V 0deg
  DCN, DCP, LSRC1..LSRC4: CG Fields 0V 0deg
  AC:J_AC, AC:QH_S_2, AC:QH_S_3, AC:QH_S_4, AC:QL_D_1..AC:QL_D_4, DCN:BankN_2, DCN:BankN_3, DCN:BankN_4, DCN:BankN_C, DCN:CapN_2, DCN:CapN_3, DCN:CapN_4, DCN:CapNb_1..DCN:CapNb_4, DCN:J_DCN, DCN:RSN_1..DCN:RSN_4, DCP:BankP_1..DCP:BankP_4, DCP:BankP_C, DCP:CapP_2, DCP:CapP_3, DCP:CapP_4, DCP:CapPb_1..DCP:CapPb_4, DCP:J_DCP, DCP:QH_D_1..DCP:QH_D_4, LSRC1:QL_S_1, LSRC2:QL_S_2, LSRC3:QL_S_3, LSRC4:QL_S_4: DC R/L Fields 0A
  DCN:BankN_1: DC R/L Fields 1A
