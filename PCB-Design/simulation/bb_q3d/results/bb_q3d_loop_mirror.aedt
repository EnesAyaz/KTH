# Ansys Electronics Desktop project, version 2024.2
materials:
  vacuum: permittivity=1
  copper: permeability=0.999991 conductivity=58000000

design BB_PL_LOOP_mirror (Q3D Extractor, model units mm)
options: SParamCalcMethod=EqTransLine Calculate_Lossy_Dielectrics
geometry:
  P0_DCN_L1 [copper] = polyline(z=0.17mm, xy in mm: (28.749, 15.5) (43.5816, 15.5048) (43.65, 15.599) (43.6452, 20.1316) (43.551, 20.2) (28.7184, 20.1952) (28.65, 20.101) (28.6908, 15.5189) (28.749, 15.5), closed, covered)
  P0_DCN_L1.sweep_along_vector((0mm, 0mm, 0.07mm))
  P1_DCN_L1 = polyline(z=0.17mm, xy in mm: (3.949, 15.5) (18.7816, 15.5048) (18.85, 15.599) (18.8452, 20.1316) (18.751, 20.2) (3.9184, 20.1952) (3.85, 20.101) (3.8908, 15.5189) (3.949, 15.5), closed, covered)
  P1_DCN_L1.sweep_along_vector((0mm, 0mm, 0.07mm))
  P2_DCN_L1 = polyline(z=0.17mm, xy in mm: (-18.751, 15.5) (-3.9184, 15.5048) (-3.85, 15.599) (-3.8548, 20.1316) (-3.949, 20.2) (-18.7816, 20.1952) (-18.85, 20.101) (-18.8092, 15.5189) (-18.751, 15.5), closed, covered)
  P2_DCN_L1.sweep_along_vector((0mm, 0mm, 0.07mm))
  P3_DCN_L1 = polyline(z=0.17mm, xy in mm: (-43.551, 15.5) (-28.7184, 15.5048) (-28.65, 15.599) (-28.6548, 20.1316) (-28.749, 20.2) (-43.5816, 20.1952) (-43.65, 20.101) (-43.6092, 15.5189) (-43.551, 15.5), closed, covered)
  P3_DCN_L1.sweep_along_vector((0mm, 0mm, 0.07mm))
  P4_DCN_L1 = polyline(z=0.17mm, xy in mm: (36.4525, 9.5) (37.7311, 9.5408) (37.75, 11.2) (43.6311, 11.2408) (43.6092, 14.9811) (28.6689, 14.9592) (28.65, 11.299) (28.75, 11.2) (28.7908, 10.7994) (29.15, 10.8608) (29.4231, 10.7805) (30.0781, 10.7853) (30.1964, 11.0685) (30.4106, 11.2005) (32.3386, 11.1851) (32.5005, 10.9612) (32.5053, 9.5684) (32.5995, 9.5) (33.0505, 9.5) (33.1495, 9.599) (33.1649, 11.0386) (33.3889, 11.2005) (34.0386, 11.1851) (34.2005, 10.9612) (34.2053, 9.5684) (34.2995, 9.5) (34.7515, 9.5) (34.8505, 9.599) (34.9004, 11.0685) (35.1146, 11.2005) (36.1153, 11.1975) (36.3505, 10.9623) (36.3943, 9.5189) (36.4525, 9.5), closed, covered)
  P4_DCN_L1.sweep_along_vector((0mm, 0mm, 0.07mm))
  P5_DCN_L1 = polyline(z=0.17mm, xy in mm: (17.4525, 9.5) (18.651, 9.5) (18.75, 9.599) (18.75, 11.2) (18.85, 11.299) (18.8092, 14.9811) (3.8689, 14.9592) (3.8908, 11.2189) (9.75, 11.2) (9.75, 9.599) (9.849, 9.5) (11.1276, 9.5408) (11.1495, 10.9623) (11.3847, 11.1975) (12.3854, 11.2005) (12.5996, 11.0685) (12.6495, 9.599) (12.7485, 9.5) (13.2806, 9.5408) (13.2995, 10.9611) (13.3736, 11.1264) (13.5389, 11.2005) (14.1886, 11.1851) (14.3505, 10.9612) (14.3553, 9.5684) (14.4495, 9.5) (14.9005, 9.5) (14.9995, 9.599) (14.9995, 10.9611) (15.0736, 11.1264) (15.2389, 11.2005) (17.1153, 11.1975) (17.3505, 10.9623) (17.3943, 9.5189) (17.4525, 9.5), closed, covered)
  P5_DCN_L1.sweep_along_vector((0mm, 0mm, 0.07mm))
  P6_DCN_L1 = polyline(z=0.17mm, xy in mm: (-11.0475, 9.5) (-9.7689, 9.5408) (-9.75, 11.2) (-3.8689, 11.2408) (-3.8908, 14.9811) (-18.8311, 14.9592) (-18.85, 11.299) (-18.75, 11.2) (-18.7092, 10.7994) (-18.35, 10.8608) (-18.0769, 10.7805) (-17.4219, 10.7853) (-17.3036, 11.0685) (-17.0894, 11.2005) (-15.1614, 11.1851) (-14.9995, 10.9612) (-14.9947, 9.5684) (-14.9005, 9.5) (-14.4495, 9.5) (-14.3505, 9.599) (-14.3351, 11.0386) (-14.1111, 11.2005) (-13.4614, 11.1851) (-13.2995, 10.9612) (-13.2947, 9.5684) (-13.2005, 9.5) (-12.7485, 9.5) (-12.6495, 9.599) (-12.5996, 11.0685) (-12.3854, 11.2005) (-11.3847, 11.1975) (-11.1495, 10.9623) (-11.1057, 9.5189) (-11.0475, 9.5), closed, covered)
  P6_DCN_L1.sweep_along_vector((0mm, 0mm, 0.07mm))
  P7_DCN_L1 = polyline(z=0.17mm, xy in mm: (-30.0475, 9.5) (-28.849, 9.5) (-28.75, 9.599) (-28.75, 11.2) (-28.65, 11.299) (-28.6908, 14.9811) (-43.6311, 14.9592) (-43.6092, 11.2189) (-37.75, 11.2) (-37.75, 9.599) (-37.651, 9.5) (-36.3724, 9.5408) (-36.3505, 10.9623) (-36.1153, 11.1975) (-35.1146, 11.2005) (-34.9004, 11.0685) (-34.8505, 9.599) (-34.7515, 9.5) (-34.2194, 9.5408) (-34.2005, 10.9611) (-34.1264, 11.1264) (-33.9611, 11.2005) (-33.3114, 11.1851) (-33.1495, 10.9612) (-33.1447, 9.5684) (-33.0505, 9.5) (-32.5995, 9.5) (-32.5005, 9.599) (-32.5005, 10.9611) (-32.4264, 11.1264) (-32.2611, 11.2005) (-30.3847, 11.1975) (-30.1495, 10.9623) (-30.1057, 9.5189) (-30.0475, 9.5), closed, covered)
  P7_DCN_L1.sweep_along_vector((0mm, 0mm, 0.07mm))
  P8_DCN_L1 = polyline(z=0.17mm, xy in mm: (-39.651, -4.2) (39.651, -4.2) (39.75, -4.101) (39.75, 0.801) (39.651, 0.9) (-39.651, 0.9) (-39.75, 0.801) (-39.7092, -4.1811) (-39.651, -4.2), closed, covered)
  P8_DCN_L1.sweep_along_vector((0mm, 0mm, 0.07mm))
  P9_DCN_L2 = polyline(z=0mm, xy in mm: (-39.75, -4.6) (39.75, -4.6) (39.75, 11.9) (44.0311, 11.9408) (44.05, 20.501) (43.951, 20.6) (28.6689, 20.5537) (28.65, 11.9) (28.4184, 11.8952) (28.35, 11.801) (28.35, 10) (27.149, 10) (27.05, 9.901) (27.05, 3.3) (20.45, 3.3) (20.4452, 9.9316) (20.351, 10) (19.15, 10) (19.1452, 11.8316) (18.85, 11.9) (18.85, 20.4955) (18.751, 20.5945) (-5.6556, 20.5592) (-5.6745, 2.7456) (-5.4944, 2.32) (-5.5746, 2.0466) (-5.928, 1.8195) (-6.3311, 1.9379) (-6.5056, 2.32) (-6.3255, 2.7456) (-6.3255, 20.501) (-6.4245, 20.6) (-18.8311, 20.5537) (-18.85, 11.9) (-19.0816, 11.8952) (-19.15, 11.801) (-19.15, 10) (-20.351, 10) (-20.45, 9.901) (-20.45, 3.3) (-27.05, 3.3) (-27.0548, 9.9316) (-27.149, 10) (-28.35, 10) (-28.3548, 11.8316) (-28.65, 11.9) (-28.6908, 20.5756) (-44.0311, 20.5592) (-44.0452, 11.9684) (-43.951, 11.9) (-39.75, 11.9) (-39.75, -4.6), closed, covered)
  P9_DCN_L2_h0 = polyline(z=0mm, xy in mm: (29.15, 9.9992) (28.8015, 10.1768) (28.7192, 10.43) (28.8015, 10.6832) (29.0169, 10.8397) (29.4032, 10.7785) (29.5597, 10.5631) (29.4985, 10.1768) (29.2831, 10.0203) (29.15, 9.9992), closed, covered)
  P9_DCN_L2_h1 = polyline(z=0mm, xy in mm: (-18.35, 9.9992) (-18.6985, 10.1768) (-18.7808, 10.43) (-18.6985, 10.6832) (-18.4831, 10.8397) (-18.0968, 10.7785) (-17.9403, 10.5631) (-18.0015, 10.1768) (-18.2169, 10.0203) (-18.35, 9.9992), closed, covered)
  P9_DCN_L2_h2 = polyline(z=0mm, xy in mm: (29.848, 8.9492) (29.4995, 9.1268) (29.4172, 9.38) (29.4995, 9.6332) (29.7149, 9.7897) (30.1012, 9.7285) (30.2577, 9.5131) (30.1965, 9.1268) (29.9811, 8.9703) (29.848, 8.9492), closed, covered)
  P9_DCN_L2_h3 = polyline(z=0mm, xy in mm: (-17.652, 8.9492) (-18.0005, 9.1268) (-18.0828, 9.38) (-18.0005, 9.6332) (-17.7851, 9.7897) (-17.3988, 9.7285) (-17.2423, 9.5131) (-17.3035, 9.1268) (-17.5189, 8.9703) (-17.652, 8.9492), closed, covered)
  P9_DCN_L2_h4 = polyline(z=0mm, xy in mm: (17.652, 8.5892) (17.3035, 8.7668) (17.2212, 9.02) (17.3035, 9.2732) (17.5189, 9.4297) (17.9052, 9.3685) (18.0617, 9.1531) (18.0005, 8.7668) (17.7851, 8.6103) (17.652, 8.5892), closed, covered)
  P9_DCN_L2_h5 = polyline(z=0mm, xy in mm: (-29.848, 8.5892) (-30.1965, 8.7668) (-30.2788, 9.02) (-30.1965, 9.2732) (-29.9811, 9.4297) (-29.5948, 9.3685) (-29.4383, 9.1531) (-29.4995, 8.7668) (-29.7149, 8.6103) (-29.848, 8.5892), closed, covered)
  P9_DCN_L2_h6 = polyline(z=0mm, xy in mm: (18.372, 6.5495) (17.9689, 6.6679) (17.7944, 7.05) (17.8746, 7.3234) (18.1029, 7.5886) (17.9403, 7.8369) (17.9403, 8.1031) (18.0968, 8.3185) (18.35, 8.4008) (18.6985, 8.2232) (18.7808, 7.97) (18.5573, 7.5609) (18.7852, 7.1925) (18.7852, 6.9075) (18.5101, 6.59) (18.372, 6.5495), closed, covered)
  P9_DCN_L2_h7 = polyline(z=0mm, xy in mm: (-29.128, 6.5495) (-29.5311, 6.6679) (-29.7056, 7.05) (-29.6254, 7.3234) (-29.3971, 7.5886) (-29.5597, 7.8369) (-29.5597, 8.1031) (-29.4032, 8.3185) (-29.15, 8.4008) (-28.8015, 8.2232) (-28.7192, 7.97) (-28.9427, 7.5609) (-28.7148, 7.1925) (-28.7148, 6.9075) (-28.9899, 6.59) (-29.128, 6.5495), closed, covered)
  P9_DCN_L2_h8 = polyline(z=0mm, xy in mm: (0.0629, 4.3995) (-0.4961, 4.4731) (-0.9437, 4.7012) (-1.4305, 5.2711) (-1.5857, 5.7489) (-1.5269, 6.4961) (-1.2988, 6.9437) (-0.7289, 7.4305) (-0.2511, 7.5857) (0.4961, 7.5269) (0.9437, 7.2988) (1.4305, 6.7289) (1.5857, 6.2511) (1.5269, 5.5039) (1.2988, 5.0563) (0.7289, 4.5695) (0.1333, 4.405) (0.0629, 4.3995), closed, covered)
  P9_DCN_L2_h9 = polyline(z=0mm, xy in mm: (29.15, 5.6992) (28.8968, 5.7815) (28.7403, 5.9969) (28.7403, 6.2631) (28.9427, 6.5391) (28.6944, 7.05) (28.7746, 7.3234) (29.128, 7.5505) (29.5311, 7.4321) (29.7056, 7.05) (29.6254, 6.7766) (29.3971, 6.5114) (29.5597, 6.2631) (29.5597, 5.9969) (29.2831, 5.7203) (29.15, 5.6992), closed, covered)
  P9_DCN_L2_h10 = polyline(z=0mm, xy in mm: (10.272, 6.5495) (9.9899, 6.59) (9.7148, 6.9075) (9.7148, 7.1925) (9.9899, 7.51) (10.4101, 7.51) (10.6852, 7.1925) (10.6852, 6.9075) (10.4101, 6.59) (10.272, 6.5495), closed, covered)
  P9_DCN_L2_h11 = polyline(z=0mm, xy in mm: (-18.35, 5.6992) (-18.6032, 5.7815) (-18.7597, 5.9969) (-18.7597, 6.2631) (-18.5573, 6.5391) (-18.8056, 7.05) (-18.7254, 7.3234) (-18.372, 7.5505) (-17.9689, 7.4321) (-17.7944, 7.05) (-17.8746, 6.7766) (-18.1029, 6.5114) (-17.9403, 6.2631) (-17.9403, 5.9969) (-18.2169, 5.7203) (-18.35, 5.6992), closed, covered)
  P9_DCN_L2_h12 = polyline(z=0mm, xy in mm: (-37.228, 6.5495) (-37.5101, 6.59) (-37.7852, 6.9075) (-37.7852, 7.1925) (-37.5101, 7.51) (-37.0899, 7.51) (-36.8148, 7.1925) (-36.8148, 6.9075) (-37.0899, 6.59) (-37.228, 6.5495), closed, covered)
  P9_DCN_L2_h13 = polyline(z=0mm, xy in mm: (29.848, 4.6492) (29.4995, 4.8268) (29.4172, 5.08) (29.4995, 5.3332) (29.7149, 5.4897) (30.1012, 5.4285) (30.2577, 5.2131) (30.1965, 4.8268) (29.9811, 4.6703) (29.848, 4.6492), closed, covered)
  P9_DCN_L2_h14 = polyline(z=0mm, xy in mm: (-17.652, 4.6492) (-18.0005, 4.8268) (-18.0828, 5.08) (-18.0005, 5.3332) (-17.7851, 5.4897) (-17.3988, 5.4285) (-17.2423, 5.2131) (-17.3035, 4.8268) (-17.5189, 4.6703) (-17.652, 4.6492), closed, covered)
  P9_DCN_L2_h15 = polyline(z=0mm, xy in mm: (17.652, 4.2892) (17.3035, 4.4668) (17.2212, 4.72) (17.3035, 4.9732) (17.5189, 5.1297) (17.9052, 5.0685) (18.0617, 4.8531) (18.0005, 4.4668) (17.7851, 4.3103) (17.652, 4.2892), closed, covered)
  P9_DCN_L2_h16 = polyline(z=0mm, xy in mm: (-29.848, 4.2892) (-30.1965, 4.4668) (-30.2788, 4.72) (-30.1965, 4.9732) (-29.9811, 5.1297) (-29.5948, 5.0685) (-29.4383, 4.8531) (-29.4995, 4.4668) (-29.7149, 4.3103) (-29.848, 4.2892), closed, covered)
  P9_DCN_L2_h17 = polyline(z=0mm, xy in mm: (18.35, 3.2392) (18.0015, 3.4168) (17.9192, 3.67) (18.0015, 3.9232) (18.2169, 4.0797) (18.6032, 4.0185) (18.7597, 3.8031) (18.6985, 3.4168) (18.4831, 3.2603) (18.35, 3.2392), closed, covered)
  P9_DCN_L2_h18 = polyline(z=0mm, xy in mm: (-29.15, 3.2392) (-29.4985, 3.4168) (-29.5808, 3.67) (-29.4985, 3.9232) (-29.2831, 4.0797) (-28.8968, 4.0185) (-28.7403, 3.8031) (-28.8015, 3.4168) (-29.0169, 3.2603) (-29.15, 3.2392), closed, covered)
  P9_DCN_L2_h19 = polyline(z=0mm, xy in mm: (37.372, 1.9995) (37.0899, 2.04) (36.8276, 2.2003) (36.6101, 2.04) (36.328, 1.9995) (35.9276, 2.2003) (35.7101, 2.04) (35.428, 1.9995) (35.0276, 2.2003) (34.8101, 2.04) (34.528, 1.9995) (34.1276, 2.2003) (33.9101, 2.04) (33.628, 1.9995) (33.2276, 2.2003) (33.0101, 2.04) (32.728, 1.9995) (32.3276, 2.2003) (32.1101, 2.04) (31.828, 1.9995) (31.4276, 2.2003) (31.2101, 2.04) (30.928, 1.9995) (30.5276, 2.2003) (30.3101, 2.04) (30.028, 1.9995) (29.6276, 2.2003) (29.4101, 2.04) (29.128, 1.9995) (28.7746, 2.2266) (28.6944, 2.5) (28.7746, 2.7734) (29.128, 3.0005) (29.4101, 2.96) (29.6724, 2.7997) (29.8899, 2.96) (30.172, 3.0005) (30.5724, 2.7997) (30.7899, 2.96) (31.072, 3.0005) (31.4724, 2.7997) (31.6899, 2.96) (31.972, 3.0005) (32.3724, 2.7997) (32.5899, 2.96) (32.872, 3.0005) (33.2724, 2.7997) (33.4899, 2.96) (33.772, 3.0005) (34.1724, 2.7997) (34.3899, 2.96) (34.672, 3.0005) (35.0724, 2.7997) (35.2899, 2.96) (35.572, 3.0005) (35.9724, 2.7997) (36.1899, 2.96) (36.472, 3.0005) (36.8724, 2.7997) (37.0899, 2.96) (37.372, 3.0005) (37.6311, 2.8821) (37.7852, 2.6425) (37.7852, 2.3575) (37.5101, 2.04) (37.372, 1.9995), closed, covered)
  P9_DCN_L2_h20 = polyline(z=0mm, xy in mm: (18.372, 1.9995) (18.0899, 2.04) (17.8276, 2.2003) (17.6101, 2.04) (17.328, 1.9995) (16.9276, 2.2003) (16.7101, 2.04) (16.428, 1.9995) (16.0276, 2.2003) (15.8101, 2.04) (15.528, 1.9995) (15.1276, 2.2003) (14.9101, 2.04) (14.628, 1.9995) (14.2276, 2.2003) (14.0101, 2.04) (13.728, 1.9995) (13.3276, 2.2003) (13.1101, 2.04) (12.828, 1.9995) (12.4276, 2.2003) (12.2101, 2.04) (11.928, 1.9995) (11.5746, 2.2266) (11.4944, 2.5) (11.5746, 2.7734) (11.928, 3.0005) (12.2101, 2.96) (12.4724, 2.7997) (12.6899, 2.96) (12.972, 3.0005) (13.3724, 2.7997) (13.5899, 2.96) (13.872, 3.0005) (14.2724, 2.7997) (14.4899, 2.96) (14.772, 3.0005) (15.1724, 2.7997) (15.3899, 2.96) (15.672, 3.0005) (16.0724, 2.7997) (16.2899, 2.96) (16.572, 3.0005) (16.9724, 2.7997) (17.1899, 2.96) (17.472, 3.0005) (17.8724, 2.7997) (18.0899, 2.96) (18.372, 3.0005) (18.6311, 2.8821) (18.7852, 2.6425) (18.7852, 2.3575) (18.5101, 2.04) (18.372, 1.9995), closed, covered)
  P9_DCN_L2_h21 = polyline(z=0mm, xy in mm: (-10.128, 1.9995) (-10.4101, 2.04) (-10.6724, 2.2003) (-10.8899, 2.04) (-11.172, 1.9995) (-11.5724, 2.2003) (-11.7899, 2.04) (-12.072, 1.9995) (-12.4724, 2.2003) (-12.6899, 2.04) (-12.972, 1.9995) (-13.3724, 2.2003) (-13.5899, 2.04) (-13.872, 1.9995) (-14.2724, 2.2003) (-14.4899, 2.04) (-14.772, 1.9995) (-15.1724, 2.2003) (-15.3899, 2.04) (-15.672, 1.9995) (-16.0724, 2.2003) (-16.2899, 2.04) (-16.572, 1.9995) (-16.9724, 2.2003) (-17.1899, 2.04) (-17.472, 1.9995) (-17.8724, 2.2003) (-18.0899, 2.04) (-18.372, 1.9995) (-18.7254, 2.2266) (-18.8056, 2.5) (-18.7254, 2.7734) (-18.372, 3.0005) (-18.0899, 2.96) (-17.8276, 2.7997) (-17.6101, 2.96) (-17.328, 3.0005) (-16.9276, 2.7997) (-16.7101, 2.96) (-16.428, 3.0005) (-16.0276, 2.7997) (-15.8101, 2.96) (-15.528, 3.0005) (-15.1276, 2.7997) (-14.9101, 2.96) (-14.628, 3.0005) (-14.2276, 2.7997) (-14.0101, 2.96) (-13.728, 3.0005) (-13.3276, 2.7997) (-13.1101, 2.96) (-12.828, 3.0005) (-12.4276, 2.7997) (-12.2101, 2.96) (-11.928, 3.0005) (-11.5276, 2.7997) (-11.3101, 2.96) (-11.028, 3.0005) (-10.6276, 2.7997) (-10.4101, 2.96) (-10.128, 3.0005) (-9.8689, 2.8821) (-9.7148, 2.6425) (-9.7148, 2.3575) (-9.9899, 2.04) (-10.128, 1.9995), closed, covered)
  P9_DCN_L2_h22 = polyline(z=0mm, xy in mm: (-29.128, 1.9995) (-29.4101, 2.04) (-29.6724, 2.2003) (-29.8899, 2.04) (-30.172, 1.9995) (-30.5724, 2.2003) (-30.7899, 2.04) (-31.072, 1.9995) (-31.4724, 2.2003) (-31.6899, 2.04) (-31.972, 1.9995) (-32.3724, 2.2003) (-32.5899, 2.04) (-32.872, 1.9995) (-33.2724, 2.2003) (-33.4899, 2.04) (-33.772, 1.9995) (-34.1724, 2.2003) (-34.3899, 2.04) (-34.672, 1.9995) (-35.0724, 2.2003) (-35.2899, 2.04) (-35.572, 1.9995) (-35.9254, 2.2266) (-36.0056, 2.5) (-35.9254, 2.7734) (-35.572, 3.0005) (-35.2899, 2.96) (-35.0276, 2.7997) (-34.8101, 2.96) (-34.528, 3.0005) (-34.1276, 2.7997) (-33.9101, 2.96) (-33.628, 3.0005) (-33.2276, 2.7997) (-33.0101, 2.96) (-32.728, 3.0005) (-32.3276, 2.7997) (-32.1101, 2.96) (-31.828, 3.0005) (-31.4276, 2.7997) (-31.2101, 2.96) (-30.928, 3.0005) (-30.5276, 2.7997) (-30.3101, 2.96) (-30.028, 3.0005) (-29.6276, 2.7997) (-29.4101, 2.96) (-29.128, 3.0005) (-28.8689, 2.8821) (-28.7148, 2.6425) (-28.7148, 2.3575) (-28.9899, 2.04) (-29.128, 1.9995), closed, covered)
  P9_DCN_L2.subtract(P9_DCN_L2_h0..P9_DCN_L2_h22)
  P9_DCN_L2.sweep_along_vector((0mm, 0mm, 0.07mm))
  P10_DCN_L4 = polyline(z=-1.44mm, xy in mm: (37.025, 12.025) (37.425, 12.025) (37.425, 16.575) (37.025, 16.575) (37.025, 13.225) (37.025, 12.025), closed, covered)
  P10_DCN_L4.sweep_along_vector((0mm, 0mm, 0.07mm))
  P11_DCN_L4 = polyline(z=-1.44mm, xy in mm: (10.075, 12.025) (10.475, 12.025) (10.475, 16.575) (10.075, 16.575) (10.075, 13.225) (10.075, 12.025), closed, covered)
  P11_DCN_L4.sweep_along_vector((0mm, 0mm, 0.07mm))
  P12_DCN_L4 = polyline(z=-1.44mm, xy in mm: (-10.475, 12.025) (-10.075, 12.025) (-10.075, 16.575) (-10.475, 16.575) (-10.475, 13.225) (-10.475, 12.025), closed, covered)
  P12_DCN_L4.sweep_along_vector((0mm, 0mm, 0.07mm))
  P13_DCN_L4 = polyline(z=-1.44mm, xy in mm: (-37.425, 12.025) (-37.025, 12.025) (-37.025, 16.575) (-37.425, 16.575) (-37.425, 13.225) (-37.425, 12.025), closed, covered)
  P13_DCN_L4.sweep_along_vector((0mm, 0mm, 0.07mm))
  P14_DCN_L4 = polyline(z=-1.44mm, xy in mm: (28.549, -1.2) (37.9816, -1.1952) (38.05, -1.101) (38.0452, 0.8816) (37.951, 0.95) (28.5184, 0.9452) (28.45, 0.851) (28.4908, -1.1811) (28.549, -1.2), closed, covered)
  P14_DCN_L4.sweep_along_vector((0mm, 0mm, 0.07mm))
  P15_DCN_L4 = polyline(z=-1.44mm, xy in mm: (9.549, -1.2) (18.9816, -1.1952) (19.05, -1.101) (19.0452, 0.8816) (18.951, 0.95) (9.5184, 0.9452) (9.45, 0.851) (9.4908, -1.1811) (9.549, -1.2), closed, covered)
  P15_DCN_L4.sweep_along_vector((0mm, 0mm, 0.07mm))
  P16_DCN_L4 = polyline(z=-1.44mm, xy in mm: (-18.951, -1.2) (-9.5184, -1.1952) (-9.45, -1.101) (-9.4548, 0.8816) (-9.549, 0.95) (-18.9816, 0.9452) (-19.05, 0.851) (-19.0092, -1.1811) (-18.951, -1.2), closed, covered)
  P16_DCN_L4.sweep_along_vector((0mm, 0mm, 0.07mm))
  P17_DCN_L4 = polyline(z=-1.44mm, xy in mm: (-37.951, -1.2) (-28.5184, -1.1952) (-28.45, -1.101) (-28.4548, 0.8816) (-28.549, 0.95) (-37.9816, 0.9452) (-38.05, 0.851) (-38.0092, -1.1811) (-37.951, -1.2), closed, covered)
  P17_DCN_L4.sweep_along_vector((0mm, 0mm, 0.07mm))
  P18_DCP_L1 [copper] = polyline(z=0.17mm, xy in mm: (28.849, 1.5) (37.6816, 1.5048) (37.75, 1.599) (37.7452, 4.5316) (37.651, 4.6) (35.1189, 4.5952) (35.0505, 4.501) (35.0351, 3.0614) (34.8886, 2.9149) (34.2389, 2.8995) (34.0736, 2.9736) (33.9995, 3.1388) (33.9947, 4.5316) (33.9005, 4.6) (33.4189, 4.5952) (33.3505, 4.501) (33.3351, 3.0614) (33.1886, 2.9149) (32.5389, 2.8995) (32.3736, 2.9736) (32.2995, 3.1388) (32.2947, 4.5316) (32.2005, 4.6) (31.7179, 4.5952) (31.6495, 4.501) (31.5996, 3.0315) (31.3854, 2.8995) (30.4106, 2.8995) (30.2785, 2.9494) (30.1495, 3.1377) (30.1057, 4.5811) (28.8184, 4.5952) (28.75, 4.501) (28.7908, 1.5189) (28.849, 1.5), closed, covered)
  P18_DCP_L1.sweep_along_vector((0mm, 0mm, 0.07mm))
  P19_DCP_L1 = polyline(z=0.17mm, xy in mm: (9.849, 1.5) (18.6816, 1.5048) (18.75, 1.599) (18.7452, 3.2511) (18.651, 3.3195) (18.35, 3.2392) (18.0769, 3.3195) (17.4525, 3.3195) (17.3724, 3.2787) (17.3036, 3.0315) (17.1153, 2.9025) (16.0887, 2.9025) (15.8535, 3.1377) (15.9029, 4.3191) (15.8457, 4.5316) (15.7515, 4.6) (15.2995, 4.6) (15.2005, 4.501) (15.1851, 3.0614) (14.9612, 2.8995) (14.3114, 2.9149) (14.1495, 3.1388) (14.1447, 4.5316) (14.0505, 4.6) (13.5995, 4.6) (13.5005, 4.501) (13.4851, 3.0614) (13.3386, 2.9149) (12.6889, 2.8995) (12.5236, 2.9736) (12.4495, 3.1388) (12.4087, 4.5811) (9.8184, 4.5952) (9.75, 4.501) (9.7908, 1.5189) (9.849, 1.5), closed, covered)
  P19_DCP_L1.sweep_along_vector((0mm, 0mm, 0.07mm))
  P20_DCP_L1 = polyline(z=0.17mm, xy in mm: (-18.651, 1.5) (-9.8184, 1.5048) (-9.75, 1.599) (-9.7548, 4.5316) (-9.849, 4.6) (-12.3811, 4.5952) (-12.4495, 4.501) (-12.4649, 3.0614) (-12.6114, 2.9149) (-13.2611, 2.8995) (-13.4264, 2.9736) (-13.5005, 3.1388) (-13.5053, 4.5316) (-13.5995, 4.6) (-14.0811, 4.5952) (-14.1495, 4.501) (-14.1649, 3.0614) (-14.3114, 2.9149) (-14.9611, 2.8995) (-15.1264, 2.9736) (-15.2005, 3.1388) (-15.2053, 4.5316) (-15.2995, 4.6) (-15.7821, 4.5952) (-15.8505, 4.501) (-15.9004, 3.0315) (-16.1146, 2.8995) (-17.0894, 2.8995) (-17.2215, 2.9494) (-17.3505, 3.1377) (-17.3943, 4.5811) (-18.6816, 4.5952) (-18.75, 4.501) (-18.7092, 1.5189) (-18.651, 1.5), closed, covered)
  P20_DCP_L1.sweep_along_vector((0mm, 0mm, 0.07mm))
  P21_DCP_L1 = polyline(z=0.17mm, xy in mm: (-37.651, 1.5) (-28.8184, 1.5048) (-28.75, 1.599) (-28.7548, 3.2511) (-28.849, 3.3195) (-29.15, 3.2392) (-29.4231, 3.3195) (-30.0475, 3.3195) (-30.1276, 3.2787) (-30.1964, 3.0315) (-30.3847, 2.9025) (-31.4113, 2.9025) (-31.6465, 3.1377) (-31.5971, 4.3191) (-31.6543, 4.5316) (-31.7485, 4.6) (-32.2005, 4.6) (-32.2995, 4.501) (-32.3149, 3.0614) (-32.5388, 2.8995) (-33.1886, 2.9149) (-33.3505, 3.1388) (-33.3553, 4.5316) (-33.4495, 4.6) (-33.9005, 4.6) (-33.9995, 4.501) (-34.0149, 3.0614) (-34.1614, 2.9149) (-34.8111, 2.8995) (-34.9764, 2.9736) (-35.0505, 3.1388) (-35.0913, 4.5811) (-37.6816, 4.5952) (-37.75, 4.501) (-37.7092, 1.5189) (-37.651, 1.5), closed, covered)
  P21_DCP_L1.sweep_along_vector((0mm, 0mm, 0.07mm))
  P22_DCP_L3 = polyline(z=-1.27mm, xy in mm: (-39.75, -4.6) (39.75, -4.6) (39.7358, -0.7862) (39.6286, -0.7408) (39.3601, -0.96) (39.078, -1.0005) (38.8189, -0.8821) (38.5812, -0.5012) (38.8189, -0.1179) (39.078, 0.0005) (39.3601, -0.04) (39.6204, -0.2569) (39.75, -0.1627) (39.75, 4.501) (39.651, 4.6) (24.1975, 4.6) (23.9601, 4.44) (23.678, 4.3995) (23.3025, 4.6) (18.1291, 4.6) (17.9052, 4.3715) (17.652, 4.2892) (17.3988, 4.3715) (17.1749, 4.6) (0.8065, 4.6) (0.2511, 4.4143) (-0.0629, 4.3995) (-0.8065, 4.6) (-6.6707, 4.6) (-6.763, 4.4651) (-6.5148, 4.1425) (-6.5148, 3.8575) (-6.7899, 3.54) (-7.072, 3.4995) (-7.3311, 3.6179) (-7.4852, 3.8575) (-7.4852, 4.1425) (-7.2351, 4.4704) (-7.3293, 4.6) (-23.3025, 4.6) (-23.5399, 4.44) (-23.822, 4.3995) (-24.1975, 4.6) (-29.3709, 4.6) (-29.5948, 4.3715) (-29.848, 4.2892) (-30.1012, 4.3715) (-30.3251, 4.6) (-39.651, 4.6) (-39.75, 4.501) (-39.75, -0.1627) (-39.6286, -0.2592) (-39.3601, -0.04) (-39.078, 0.0005) (-38.8189, -0.1179) (-38.5812, -0.4988) (-38.8189, -0.8821) (-39.078, -1.0005) (-39.3601, -0.96) (-39.6204, -0.7431) (-39.75, -0.8373) (-39.75, -4.6), closed, covered)
  P22_DCP_L3_h0 = polyline(z=-1.27mm, xy in mm: (18.35, 3.2392) (18.0015, 3.4168) (17.9192, 3.67) (18.0015, 3.9232) (18.2169, 4.0797) (18.6032, 4.0185) (18.7597, 3.8031) (18.6985, 3.4168) (18.4831, 3.2603) (18.35, 3.2392), closed, covered)
  P22_DCP_L3_h1 = polyline(z=-1.27mm, xy in mm: (-29.15, 3.2392) (-29.4985, 3.4168) (-29.5808, 3.67) (-29.4985, 3.9232) (-29.2831, 4.0797) (-28.8968, 4.0185) (-28.7403, 3.8031) (-28.8015, 3.4168) (-29.0169, 3.2603) (-29.15, 3.2392), closed, covered)
  P22_DCP_L3_h2 = polyline(z=-1.27mm, xy in mm: (-5.928, 1.8195) (-6.2101, 1.86) (-6.4852, 2.1775) (-6.4852, 2.4625) (-6.2101, 2.78) (-5.7899, 2.78) (-5.5148, 2.4625) (-5.5148, 2.1775) (-5.7899, 1.86) (-5.928, 1.8195), closed, covered)
  P22_DCP_L3_h3 = polyline(z=-1.27mm, xy in mm: (38.0373, -1.0005) (37.6343, -0.8821) (37.3966, -0.5012) (37.54, -0.2266) (37.7553, -0.04) (38.1754, -0.04) (38.3908, -0.2266) (38.5342, -0.4988) (38.3908, -0.7734) (38.1754, -0.96) (38.0373, -1.0005), closed, covered)
  P22_DCP_L3_h4 = polyline(z=-1.27mm, xy in mm: (36.8527, -1.0005) (36.4496, -0.8821) (36.212, -0.5012) (36.3554, -0.2266) (36.5707, -0.04) (36.9908, -0.04) (37.2061, -0.2266) (37.3496, -0.4988) (37.2061, -0.7734) (36.9908, -0.96) (36.8527, -1.0005), closed, covered)
  P22_DCP_L3_h5 = polyline(z=-1.27mm, xy in mm: (35.6681, -1.0005) (35.265, -0.8821) (35.0273, -0.5012) (35.1708, -0.2266) (35.3861, -0.04) (35.8062, -0.04) (36.0215, -0.2266) (36.165, -0.4988) (36.0215, -0.7734) (35.8062, -0.96) (35.6681, -1.0005), closed, covered)
  P22_DCP_L3_h6 = polyline(z=-1.27mm, xy in mm: (34.4835, -1.0005) (34.0804, -0.8821) (33.8427, -0.5012) (33.9862, -0.2266) (34.2015, -0.04) (34.6216, -0.04) (34.8369, -0.2266) (34.9804, -0.4988) (34.8369, -0.7734) (34.6216, -0.96) (34.4835, -1.0005), closed, covered)
  P22_DCP_L3_h7 = polyline(z=-1.27mm, xy in mm: (33.2989, -1.0005) (32.8958, -0.8821) (32.6581, -0.5012) (32.8015, -0.2266) (33.0169, -0.04) (33.437, -0.04) (33.6523, -0.2266) (33.7957, -0.4988) (33.6523, -0.7734) (33.437, -0.96) (33.2989, -1.0005), closed, covered)
  P22_DCP_L3_h8 = polyline(z=-1.27mm, xy in mm: (32.1143, -1.0005) (31.7112, -0.8821) (31.4735, -0.5012) (31.6169, -0.2266) (31.8323, -0.04) (32.2524, -0.04) (32.4677, -0.2266) (32.6111, -0.4988) (32.4677, -0.7734) (32.2524, -0.96) (32.1143, -1.0005), closed, covered)
  P22_DCP_L3_h9 = polyline(z=-1.27mm, xy in mm: (30.9297, -1.0005) (30.5266, -0.8821) (30.2889, -0.5012) (30.4323, -0.2266) (30.6476, -0.04) (31.0678, -0.04) (31.2831, -0.2266) (31.4265, -0.4988) (31.2831, -0.7734) (31.0677, -0.96) (30.9297, -1.0005), closed, covered)
  P22_DCP_L3_h10 = polyline(z=-1.27mm, xy in mm: (29.745, -1.0005) (29.3419, -0.8821) (29.1043, -0.5012) (29.2477, -0.2266) (29.463, -0.04) (29.8831, -0.04) (30.0985, -0.2266) (30.2419, -0.4988) (30.0985, -0.7734) (29.8831, -0.96) (29.745, -1.0005), closed, covered)
  P22_DCP_L3_h11 = polyline(z=-1.27mm, xy in mm: (28.5604, -1.0005) (28.1573, -0.8821) (27.9196, -0.5012) (28.0631, -0.2266) (28.2784, -0.04) (28.6985, -0.04) (28.9138, -0.2266) (29.0573, -0.4988) (28.9138, -0.7734) (28.6985, -0.96) (28.5604, -1.0005), closed, covered)
  P22_DCP_L3_h12 = polyline(z=-1.27mm, xy in mm: (27.3758, -1.0005) (26.9727, -0.8821) (26.735, -0.5012) (26.8785, -0.2266) (27.0938, -0.04) (27.5139, -0.04) (27.7292, -0.2266) (27.8727, -0.4988) (27.7292, -0.7734) (27.5139, -0.96) (27.3758, -1.0005), closed, covered)
  P22_DCP_L3_h13 = polyline(z=-1.27mm, xy in mm: (26.1912, -1.0005) (25.7881, -0.8821) (25.5504, -0.5012) (25.6939, -0.2266) (25.9092, -0.04) (26.3293, -0.04) (26.5446, -0.2266) (26.688, -0.4988) (26.5446, -0.7734) (26.3293, -0.96) (26.1912, -1.0005), closed, covered)
  P22_DCP_L3_h14 = polyline(z=-1.27mm, xy in mm: (25.0066, -1.0005) (24.6035, -0.8821) (24.3658, -0.5012) (24.5092, -0.2266) (24.7246, -0.04) (25.1447, -0.04) (25.36, -0.2266) (25.5034, -0.4988) (25.36, -0.7734) (25.1447, -0.96) (25.0066, -1.0005), closed, covered)
  P22_DCP_L3_h15 = polyline(z=-1.27mm, xy in mm: (23.822, -1.0005) (23.4189, -0.8821) (23.1812, -0.5012) (23.3246, -0.2266) (23.5399, -0.04) (23.9601, -0.04) (24.1754, -0.2266) (24.3188, -0.4988) (24.1754, -0.7734) (23.9601, -0.96) (23.822, -1.0005), closed, covered)
  P22_DCP_L3_h16 = polyline(z=-1.27mm, xy in mm: (22.6373, -1.0005) (22.2343, -0.8821) (21.9966, -0.5012) (22.14, -0.2266) (22.3553, -0.04) (22.7754, -0.04) (22.9908, -0.2266) (23.1342, -0.4988) (22.9908, -0.7734) (22.7754, -0.96) (22.6373, -1.0005), closed, covered)
  P22_DCP_L3_h17 = polyline(z=-1.27mm, xy in mm: (21.4527, -1.0005) (21.0496, -0.8821) (20.812, -0.5012) (20.9554, -0.2266) (21.1707, -0.04) (21.5908, -0.04) (21.8061, -0.2266) (21.9496, -0.4988) (21.8061, -0.7734) (21.5908, -0.96) (21.4527, -1.0005), closed, covered)
  P22_DCP_L3_h18 = polyline(z=-1.27mm, xy in mm: (20.2681, -1.0005) (19.865, -0.8821) (19.6273, -0.5012) (19.7708, -0.2266) (19.9861, -0.04) (20.4062, -0.04) (20.6215, -0.2266) (20.765, -0.4988) (20.6215, -0.7734) (20.4062, -0.96) (20.2681, -1.0005), closed, covered)
  P22_DCP_L3_h19 = polyline(z=-1.27mm, xy in mm: (19.0835, -1.0005) (18.6804, -0.8821) (18.4427, -0.5012) (18.5862, -0.2266) (18.8015, -0.04) (19.2216, -0.04) (19.4369, -0.2266) (19.5804, -0.4988) (19.4369, -0.7734) (19.2216, -0.96) (19.0835, -1.0005), closed, covered)
  P22_DCP_L3_h20 = polyline(z=-1.27mm, xy in mm: (17.8989, -1.0005) (17.4958, -0.8821) (17.2581, -0.5012) (17.4015, -0.2266) (17.6169, -0.04) (18.037, -0.04) (18.2523, -0.2266) (18.3957, -0.4988) (18.2523, -0.7734) (18.037, -0.96) (17.8989, -1.0005), closed, covered)
  P22_DCP_L3_h21 = polyline(z=-1.27mm, xy in mm: (16.7143, -1.0005) (16.3112, -0.8821) (16.0735, -0.5012) (16.2169, -0.2266) (16.4323, -0.04) (16.8524, -0.04) (17.0677, -0.2266) (17.2111, -0.4988) (17.0677, -0.7734) (16.8524, -0.96) (16.7143, -1.0005), closed, covered)
  P22_DCP_L3_h22 = polyline(z=-1.27mm, xy in mm: (15.5297, -1.0005) (15.1266, -0.8821) (14.8889, -0.5012) (15.0323, -0.2266) (15.2476, -0.04) (15.6678, -0.04) (15.8831, -0.2266) (16.0265, -0.4988) (15.8831, -0.7734) (15.6677, -0.96) (15.5297, -1.0005), closed, covered)
  P22_DCP_L3_h23 = polyline(z=-1.27mm, xy in mm: (14.345, -1.0005) (13.9419, -0.8821) (13.7043, -0.5012) (13.8477, -0.2266) (14.063, -0.04) (14.4831, -0.04) (14.6985, -0.2266) (14.8419, -0.4988) (14.6985, -0.7734) (14.4831, -0.96) (14.345, -1.0005), closed, covered)
  P22_DCP_L3_h24 = polyline(z=-1.27mm, xy in mm: (13.1604, -1.0005) (12.7573, -0.8821) (12.5196, -0.5012) (12.6631, -0.2266) (12.8784, -0.04) (13.2985, -0.04) (13.5138, -0.2266) (13.6573, -0.4988) (13.5138, -0.7734) (13.2985, -0.96) (13.1604, -1.0005), closed, covered)
  P22_DCP_L3_h25 = polyline(z=-1.27mm, xy in mm: (11.9758, -1.0005) (11.5727, -0.8821) (11.335, -0.5012) (11.4785, -0.2266) (11.6938, -0.04) (12.1139, -0.04) (12.3292, -0.2266) (12.4727, -0.4988) (12.3292, -0.7734) (12.1139, -0.96) (11.9758, -1.0005), closed, covered)
  P22_DCP_L3_h26 = polyline(z=-1.27mm, xy in mm: (10.7912, -1.0005) (10.3881, -0.8821) (10.1504, -0.5012) (10.2939, -0.2266) (10.5092, -0.04) (10.9293, -0.04) (11.1446, -0.2266) (11.288, -0.4988) (11.1446, -0.7734) (10.9293, -0.96) (10.7912, -1.0005), closed, covered)
  P22_DCP_L3_h27 = polyline(z=-1.27mm, xy in mm: (9.6066, -1.0005) (9.2035, -0.8821) (8.9658, -0.5012) (9.1092, -0.2266) (9.3246, -0.04) (9.7447, -0.04) (9.96, -0.2266) (10.1034, -0.4988) (9.96, -0.7734) (9.7447, -0.96) (9.6066, -1.0005), closed, covered)
  P22_DCP_L3_h28 = polyline(z=-1.27mm, xy in mm: (8.422, -1.0005) (8.1399, -0.96) (7.8648, -0.6425) (7.8648, -0.3575) (8.1399, -0.04) (8.5601, -0.04) (8.7754, -0.2266) (8.9188, -0.4988) (8.7754, -0.7734) (8.56, -0.96) (8.422, -1.0005), closed, covered)
  P22_DCP_L3_h29 = polyline(z=-1.27mm, xy in mm: (7.222, -1.0005) (6.9399, -0.96) (6.6648, -0.6425) (6.6648, -0.3575) (6.9399, -0.04) (7.3601, -0.04) (7.6352, -0.3575) (7.6352, -0.6425) (7.3601, -0.96) (7.222, -1.0005), closed, covered)
  P22_DCP_L3_h30 = polyline(z=-1.27mm, xy in mm: (6.022, -1.0005) (5.7399, -0.96) (5.4648, -0.6425) (5.4648, -0.3575) (5.7399, -0.04) (6.1601, -0.04) (6.4352, -0.3575) (6.4352, -0.6425) (6.1601, -0.96) (6.022, -1.0005), closed, covered)
  P22_DCP_L3_h31 = polyline(z=-1.27mm, xy in mm: (4.822, -1.0005) (4.5399, -0.96) (4.2648, -0.6425) (4.2648, -0.3575) (4.5399, -0.04) (4.9601, -0.04) (5.2352, -0.3575) (5.2352, -0.6425) (4.9601, -0.96) (4.822, -1.0005), closed, covered)
  P22_DCP_L3_h32 = polyline(z=-1.27mm, xy in mm: (3.622, -1.0005) (3.3399, -0.96) (3.0648, -0.6425) (3.0648, -0.3575) (3.3399, -0.04) (3.7601, -0.04) (4.0352, -0.3575) (4.0352, -0.6425) (3.7601, -0.96) (3.622, -1.0005), closed, covered)
  P22_DCP_L3_h33 = polyline(z=-1.27mm, xy in mm: (2.422, -1.0005) (2.1399, -0.96) (1.8648, -0.6425) (1.8648, -0.3575) (2.1399, -0.04) (2.5601, -0.04) (2.8352, -0.3575) (2.8352, -0.6425) (2.56, -0.96) (2.422, -1.0005), closed, covered)
  P22_DCP_L3_h34 = polyline(z=-1.27mm, xy in mm: (1.222, -1.0005) (0.9399, -0.96) (0.6648, -0.6425) (0.6648, -0.3575) (0.9399, -0.04) (1.3601, -0.04) (1.6352, -0.3575) (1.6352, -0.6425) (1.3601, -0.96) (1.222, -1.0005), closed, covered)
  P22_DCP_L3_h35 = polyline(z=-1.27mm, xy in mm: (0.022, -1.0005) (-0.2601, -0.96) (-0.5352, -0.6425) (-0.5352, -0.3575) (-0.2601, -0.04) (0.1601, -0.04) (0.4352, -0.3575) (0.4352, -0.6425) (0.1601, -0.96) (0.022, -1.0005), closed, covered)
  P22_DCP_L3_h36 = polyline(z=-1.27mm, xy in mm: (-1.178, -1.0005) (-1.4601, -0.96) (-1.7352, -0.6425) (-1.7352, -0.3575) (-1.4601, -0.04) (-1.0399, -0.04) (-0.7648, -0.3575) (-0.7648, -0.6425) (-1.0399, -0.96) (-1.178, -1.0005), closed, covered)
  P22_DCP_L3_h37 = polyline(z=-1.27mm, xy in mm: (-2.378, -1.0005) (-2.6601, -0.96) (-2.9352, -0.6425) (-2.9352, -0.3575) (-2.6601, -0.04) (-2.2399, -0.04) (-1.9648, -0.3575) (-1.9648, -0.6425) (-2.2399, -0.96) (-2.378, -1.0005), closed, covered)
  P22_DCP_L3_h38 = polyline(z=-1.27mm, xy in mm: (-3.578, -1.0005) (-3.8601, -0.96) (-4.1352, -0.6425) (-4.1352, -0.3575) (-3.8601, -0.04) (-3.4399, -0.04) (-3.1648, -0.3575) (-3.1648, -0.6425) (-3.4399, -0.96) (-3.578, -1.0005), closed, covered)
  P22_DCP_L3_h39 = polyline(z=-1.27mm, xy in mm: (-4.778, -1.0005) (-5.0601, -0.96) (-5.3352, -0.6425) (-5.3352, -0.3575) (-5.0601, -0.04) (-4.6399, -0.04) (-4.3648, -0.3575) (-4.3648, -0.6425) (-4.6399, -0.96) (-4.778, -1.0005), closed, covered)
  P22_DCP_L3_h40 = polyline(z=-1.27mm, xy in mm: (-5.978, -1.0005) (-6.2601, -0.96) (-6.5352, -0.6425) (-6.5352, -0.3575) (-6.2601, -0.04) (-5.8399, -0.04) (-5.5648, -0.3575) (-5.5648, -0.6425) (-5.8399, -0.96) (-5.978, -1.0005), closed, covered)
  P22_DCP_L3_h41 = polyline(z=-1.27mm, xy in mm: (-8.278, -1.0005) (-8.6811, -0.8821) (-8.9188, -0.5012) (-8.7754, -0.2266) (-8.5601, -0.04) (-8.1399, -0.04) (-7.8648, -0.3575) (-7.8648, -0.6425) (-8.1399, -0.96) (-8.278, -1.0005), closed, covered)
  P22_DCP_L3_h42 = polyline(z=-1.27mm, xy in mm: (-9.4626, -1.0005) (-9.8657, -0.8821) (-10.1034, -0.5012) (-9.96, -0.2266) (-9.7447, -0.04) (-9.3246, -0.04) (-9.1092, -0.2266) (-8.9658, -0.4988) (-9.1092, -0.7734) (-9.3246, -0.96) (-9.4626, -1.0005), closed, covered)
  P22_DCP_L3_h43 = polyline(z=-1.27mm, xy in mm: (-10.6473, -1.0005) (-11.0504, -0.8821) (-11.288, -0.5012) (-11.1446, -0.2266) (-10.9293, -0.04) (-10.5092, -0.04) (-10.2939, -0.2266) (-10.1504, -0.4988) (-10.2939, -0.7734) (-10.5092, -0.96) (-10.6473, -1.0005), closed, covered)
  P22_DCP_L3_h44 = polyline(z=-1.27mm, xy in mm: (-11.8319, -1.0005) (-12.235, -0.8821) (-12.4727, -0.5012) (-12.3292, -0.2266) (-12.1139, -0.04) (-11.6938, -0.04) (-11.4785, -0.2266) (-11.335, -0.4988) (-11.4785, -0.7734) (-11.6938, -0.96) (-11.8319, -1.0005), closed, covered)
  P22_DCP_L3_h45 = polyline(z=-1.27mm, xy in mm: (-13.0165, -1.0005) (-13.4196, -0.8821) (-13.6573, -0.5012) (-13.5138, -0.2266) (-13.2985, -0.04) (-12.8784, -0.04) (-12.6631, -0.2266) (-12.5196, -0.4988) (-12.6631, -0.7734) (-12.8784, -0.96) (-13.0165, -1.0005), closed, covered)
  P22_DCP_L3_h46 = polyline(z=-1.27mm, xy in mm: (-14.2011, -1.0005) (-14.6042, -0.8821) (-14.8419, -0.5012) (-14.6985, -0.2266) (-14.4831, -0.04) (-14.063, -0.04) (-13.8477, -0.2266) (-13.7043, -0.4988) (-13.8477, -0.7734) (-14.063, -0.96) (-14.2011, -1.0005), closed, covered)
  P22_DCP_L3_h47 = polyline(z=-1.27mm, xy in mm: (-15.3857, -1.0005) (-15.7888, -0.8821) (-16.0265, -0.5012) (-15.8831, -0.2266) (-15.6677, -0.04) (-15.2476, -0.04) (-15.0323, -0.2266) (-14.8889, -0.4988) (-15.0323, -0.7734) (-15.2476, -0.96) (-15.3857, -1.0005), closed, covered)
  P22_DCP_L3_h48 = polyline(z=-1.27mm, xy in mm: (-16.5703, -1.0005) (-16.9734, -0.8821) (-17.2111, -0.5012) (-17.0677, -0.2266) (-16.8524, -0.04) (-16.4322, -0.04) (-16.2169, -0.2266) (-16.0735, -0.4988) (-16.2169, -0.7734) (-16.4323, -0.96) (-16.5703, -1.0005), closed, covered)
  P22_DCP_L3_h49 = polyline(z=-1.27mm, xy in mm: (-17.755, -1.0005) (-18.1581, -0.8821) (-18.3957, -0.5012) (-18.2523, -0.2266) (-18.037, -0.04) (-17.6169, -0.04) (-17.4015, -0.2266) (-17.2581, -0.4988) (-17.4015, -0.7734) (-17.6169, -0.96) (-17.755, -1.0005), closed, covered)
  P22_DCP_L3_h50 = polyline(z=-1.27mm, xy in mm: (-18.9396, -1.0005) (-19.3427, -0.8821) (-19.5804, -0.5012) (-19.4369, -0.2266) (-19.2216, -0.04) (-18.8015, -0.04) (-18.5862, -0.2266) (-18.4427, -0.4988) (-18.5862, -0.7734) (-18.8015, -0.96) (-18.9396, -1.0005), closed, covered)
  P22_DCP_L3_h51 = polyline(z=-1.27mm, xy in mm: (-20.1242, -1.0005) (-20.5273, -0.8821) (-20.765, -0.5012) (-20.6215, -0.2266) (-20.4062, -0.04) (-19.9861, -0.04) (-19.7708, -0.2266) (-19.6273, -0.4988) (-19.7708, -0.7734) (-19.9861, -0.96) (-20.1242, -1.0005), closed, covered)
  P22_DCP_L3_h52 = polyline(z=-1.27mm, xy in mm: (-21.3088, -1.0005) (-21.7119, -0.8821) (-21.9496, -0.5012) (-21.8061, -0.2266) (-21.5908, -0.04) (-21.1707, -0.04) (-20.9554, -0.2266) (-20.812, -0.4988) (-20.9554, -0.7734) (-21.1707, -0.96) (-21.3088, -1.0005), closed, covered)
  P22_DCP_L3_h53 = polyline(z=-1.27mm, xy in mm: (-22.4934, -1.0005) (-22.8965, -0.8821) (-23.1342, -0.5012) (-22.9908, -0.2266) (-22.7754, -0.04) (-22.3553, -0.04) (-22.14, -0.2266) (-21.9966, -0.4988) (-22.14, -0.7734) (-22.3553, -0.96) (-22.4934, -1.0005), closed, covered)
  P22_DCP_L3_h54 = polyline(z=-1.27mm, xy in mm: (-23.678, -1.0005) (-24.0811, -0.8821) (-24.3188, -0.5012) (-24.1754, -0.2266) (-23.9601, -0.04) (-23.5399, -0.04) (-23.3246, -0.2266) (-23.1812, -0.4988) (-23.3246, -0.7734) (-23.5399, -0.96) (-23.678, -1.0005), closed, covered)
  P22_DCP_L3_h55 = polyline(z=-1.27mm, xy in mm: (-24.8627, -1.0005) (-25.2657, -0.8821) (-25.5034, -0.5012) (-25.36, -0.2266) (-25.1447, -0.04) (-24.7246, -0.04) (-24.5092, -0.2266) (-24.3658, -0.4988) (-24.5092, -0.7734) (-24.7246, -0.96) (-24.8627, -1.0005), closed, covered)
  P22_DCP_L3_h56 = polyline(z=-1.27mm, xy in mm: (-26.0473, -1.0005) (-26.4504, -0.8821) (-26.688, -0.5012) (-26.5446, -0.2266) (-26.3293, -0.04) (-25.9092, -0.04) (-25.6939, -0.2266) (-25.5504, -0.4988) (-25.6939, -0.7734) (-25.9092, -0.96) (-26.0473, -1.0005), closed, covered)
  P22_DCP_L3_h57 = polyline(z=-1.27mm, xy in mm: (-27.2319, -1.0005) (-27.635, -0.8821) (-27.8727, -0.5012) (-27.7292, -0.2266) (-27.5139, -0.04) (-27.0938, -0.04) (-26.8785, -0.2266) (-26.735, -0.4988) (-26.8785, -0.7734) (-27.0938, -0.96) (-27.2319, -1.0005), closed, covered)
  P22_DCP_L3_h58 = polyline(z=-1.27mm, xy in mm: (-28.4165, -1.0005) (-28.8196, -0.8821) (-29.0573, -0.5012) (-28.9138, -0.2266) (-28.6985, -0.04) (-28.2784, -0.04) (-28.0631, -0.2266) (-27.9196, -0.4988) (-28.0631, -0.7734) (-28.2784, -0.96) (-28.4165, -1.0005), closed, covered)
  P22_DCP_L3_h59 = polyline(z=-1.27mm, xy in mm: (-29.6011, -1.0005) (-30.0042, -0.8821) (-30.2419, -0.5012) (-30.0985, -0.2266) (-29.8831, -0.04) (-29.463, -0.04) (-29.2477, -0.2266) (-29.1043, -0.4988) (-29.2477, -0.7734) (-29.463, -0.96) (-29.6011, -1.0005), closed, covered)
  P22_DCP_L3_h60 = polyline(z=-1.27mm, xy in mm: (-30.7857, -1.0005) (-31.1888, -0.8821) (-31.4265, -0.5012) (-31.2831, -0.2266) (-31.0677, -0.04) (-30.6476, -0.04) (-30.4323, -0.2266) (-30.2889, -0.4988) (-30.4323, -0.7734) (-30.6476, -0.96) (-30.7857, -1.0005), closed, covered)
  P22_DCP_L3_h61 = polyline(z=-1.27mm, xy in mm: (-31.9703, -1.0005) (-32.3734, -0.8821) (-32.6111, -0.5012) (-32.4677, -0.2266) (-32.2524, -0.04) (-31.8322, -0.04) (-31.6169, -0.2266) (-31.4735, -0.4988) (-31.6169, -0.7734) (-31.8323, -0.96) (-31.9703, -1.0005), closed, covered)
  P22_DCP_L3_h62 = polyline(z=-1.27mm, xy in mm: (-33.155, -1.0005) (-33.5581, -0.8821) (-33.7957, -0.5012) (-33.6523, -0.2266) (-33.437, -0.04) (-33.0169, -0.04) (-32.8015, -0.2266) (-32.6581, -0.4988) (-32.8015, -0.7734) (-33.0169, -0.96) (-33.155, -1.0005), closed, covered)
  P22_DCP_L3_h63 = polyline(z=-1.27mm, xy in mm: (-34.3396, -1.0005) (-34.7427, -0.8821) (-34.9804, -0.5012) (-34.8369, -0.2266) (-34.6216, -0.04) (-34.2015, -0.04) (-33.9862, -0.2266) (-33.8427, -0.4988) (-33.9862, -0.7734) (-34.2015, -0.96) (-34.3396, -1.0005), closed, covered)
  P22_DCP_L3_h64 = polyline(z=-1.27mm, xy in mm: (-35.5242, -1.0005) (-35.9273, -0.8821) (-36.165, -0.5012) (-36.0215, -0.2266) (-35.8062, -0.04) (-35.3861, -0.04) (-35.1708, -0.2266) (-35.0273, -0.4988) (-35.1708, -0.7734) (-35.3861, -0.96) (-35.5242, -1.0005), closed, covered)
  P22_DCP_L3_h65 = polyline(z=-1.27mm, xy in mm: (-36.7088, -1.0005) (-37.1119, -0.8821) (-37.3496, -0.5012) (-37.2061, -0.2266) (-36.9908, -0.04) (-36.5707, -0.04) (-36.3554, -0.2266) (-36.212, -0.4988) (-36.3554, -0.7734) (-36.5707, -0.96) (-36.7088, -1.0005), closed, covered)
  P22_DCP_L3_h66 = polyline(z=-1.27mm, xy in mm: (-37.8934, -1.0005) (-38.2965, -0.8821) (-38.5342, -0.5012) (-38.3908, -0.2266) (-38.1754, -0.04) (-37.7553, -0.04) (-37.54, -0.2266) (-37.3966, -0.4988) (-37.54, -0.7734) (-37.7553, -0.96) (-37.8934, -1.0005), closed, covered)
  P22_DCP_L3.subtract(P22_DCP_L3_h0..P22_DCP_L3_h66)
  P22_DCP_L3.sweep_along_vector((0mm, 0mm, 0.07mm))
  P23_DCP_L4 = polyline(z=-1.44mm, xy in mm: (28.549, 1.45) (37.9816, 1.4548) (38.05, 1.549) (38.0452, 3.2316) (37.951, 3.3) (28.5184, 3.2952) (28.45, 3.201) (28.4908, 1.4689) (28.549, 1.45), closed, covered)
  P23_DCP_L4.sweep_along_vector((0mm, 0mm, 0.07mm))
  P24_DCP_L4 = polyline(z=-1.44mm, xy in mm: (11.5341, 1.45) (18.9816, 1.4548) (19.05, 1.549) (19.0452, 3.2316) (18.951, 3.3) (18.35, 3.2392) (18.1152, 3.3) (15.1255, 3.3) (14.8832, 3.1559) (14.4857, 3.1495) (14.1055, 3.3) (13.8632, 3.1559) (13.4657, 3.1495) (13.1745, 3.3) (12.5805, 3.3) (12.1597, 2.9724) (11.5077, 2.9695) (11.4138, 2.9018) (11.5755, 2.5243) (11.5755, 1.8657) (11.44, 1.5796) (11.4759, 1.4689) (11.5341, 1.45), closed, covered)
  P24_DCP_L4.sweep_along_vector((0mm, 0mm, 0.07mm))
  P25_DCP_L4 = polyline(z=-1.44mm, xy in mm: (-18.951, 1.45) (-9.5184, 1.4548) (-9.45, 1.549) (-9.4548, 3.2316) (-9.549, 3.3) (-18.9816, 3.2952) (-19.05, 3.201) (-19.0092, 1.4689) (-18.951, 1.45), closed, covered)
  P25_DCP_L4.sweep_along_vector((0mm, 0mm, 0.07mm))
  P26_DCP_L4 = polyline(z=-1.44mm, xy in mm: (-35.9659, 1.45) (-28.5184, 1.4548) (-28.45, 1.549) (-28.4548, 3.2316) (-28.549, 3.3) (-29.15, 3.2392) (-29.3848, 3.3) (-32.3745, 3.3) (-32.6168, 3.1559) (-33.0143, 3.1495) (-33.3945, 3.3) (-33.6368, 3.1559) (-34.0343, 3.1495) (-34.3255, 3.3) (-34.9195, 3.3) (-35.3403, 2.9724) (-35.9923, 2.9695) (-36.0862, 2.9018) (-35.9245, 2.5243) (-35.9245, 1.8657) (-36.06, 1.5796) (-36.0241, 1.4689) (-35.9659, 1.45), closed, covered)
  P26_DCP_L4.sweep_along_vector((0mm, 0mm, 0.07mm))
  P27_AC1_L1 [copper] = polyline(z=0.17mm, xy in mm: (36.4525, 5.2) (37.7311, 5.2408) (37.7092, 8.8811) (35.1189, 8.8952) (35.0505, 8.801) (35.0505, 7.4389) (34.9764, 7.2736) (34.8112, 7.1995) (34.1614, 7.2149) (34.0149, 7.3614) (33.9995, 8.801) (33.9005, 8.9) (33.3694, 8.8592) (33.3505, 7.4389) (33.2764, 7.2736) (33.1112, 7.1995) (32.4614, 7.2149) (32.3149, 7.3614) (32.2587, 8.8811) (31.6684, 8.8592) (31.6465, 7.4377) (31.5175, 7.2494) (31.3854, 7.1995) (30.4106, 7.1995) (30.1964, 7.3315) (30.1057, 8.8811) (28.7689, 8.8592) (28.7908, 6.4994) (29.15, 6.5608) (29.4231, 6.4805) (30.0781, 6.4853) (30.1964, 6.7685) (30.4106, 6.9005) (32.3386, 6.8851) (32.5005, 6.6612) (32.5053, 5.2684) (32.5995, 5.2) (33.0505, 5.2) (33.1495, 5.299) (33.1649, 6.7386) (33.3889, 6.9005) (34.0386, 6.8851) (34.2005, 6.6612) (34.2053, 5.2684) (34.2995, 5.2) (34.7515, 5.2) (34.8505, 5.299) (34.9004, 6.7685) (35.1146, 6.9005) (36.1153, 6.8975) (36.3505, 6.6623) (36.3943, 5.2189) (36.4525, 5.2), closed, covered)
  P27_AC1_L1.sweep_along_vector((0mm, 0mm, 0.07mm))
  P28_AC2_L1 [copper] = polyline(z=0.17mm, xy in mm: (17.4525, 5.2) (18.7311, 5.2408) (18.7092, 7.6006) (18.35, 7.5392) (18.0769, 7.6195) (17.4525, 7.6195) (17.3724, 7.5787) (17.3036, 7.3315) (17.1153, 7.2025) (16.0887, 7.2025) (15.8535, 7.4377) (15.9029, 8.6191) (15.8457, 8.8316) (15.7515, 8.9) (15.2995, 8.9) (15.2005, 8.801) (15.1851, 7.3614) (14.9612, 7.1995) (14.3114, 7.2149) (14.1495, 7.4388) (14.1447, 8.8316) (14.0505, 8.9) (13.5995, 8.9) (13.5005, 8.801) (13.4851, 7.3614) (13.3386, 7.2149) (12.6889, 7.1995) (12.5236, 7.2736) (12.4495, 7.4388) (12.4087, 8.8811) (9.7689, 8.8592) (9.7908, 5.2189) (11.1276, 5.2408) (11.1495, 6.6623) (11.3847, 6.8975) (12.3854, 6.9005) (12.5996, 6.7685) (12.6495, 5.299) (12.7485, 5.2) (13.2806, 5.2408) (13.2995, 6.6611) (13.3736, 6.8264) (13.5389, 6.9005) (14.1886, 6.8851) (14.3505, 6.6612) (14.3553, 5.2684) (14.4495, 5.2) (14.9005, 5.2) (14.9995, 5.299) (14.9995, 6.6611) (15.0736, 6.8264) (15.2389, 6.9005) (17.0894, 6.9005) (17.2215, 6.8506) (17.3505, 6.6623) (17.3943, 5.2189) (17.4525, 5.2), closed, covered)
  P28_AC2_L1.sweep_along_vector((0mm, 0mm, 0.07mm))
  P29_AC3_L1 [copper] = polyline(z=0.17mm, xy in mm: (-11.0475, 5.2) (-9.7689, 5.2408) (-9.7908, 8.8811) (-12.3811, 8.8952) (-12.4495, 8.801) (-12.4495, 7.4389) (-12.5236, 7.2736) (-12.6888, 7.1995) (-13.3386, 7.2149) (-13.4851, 7.3614) (-13.5005, 8.801) (-13.5995, 8.9) (-14.1306, 8.8592) (-14.1495, 7.4389) (-14.2236, 7.2736) (-14.3888, 7.1995) (-15.0386, 7.2149) (-15.1851, 7.3614) (-15.2413, 8.8811) (-15.8316, 8.8592) (-15.8535, 7.4377) (-15.9825, 7.2494) (-16.1146, 7.1995) (-17.0894, 7.1995) (-17.3036, 7.3315) (-17.3943, 8.8811) (-18.7311, 8.8592) (-18.7092, 6.4994) (-18.35, 6.5608) (-18.0769, 6.4805) (-17.4219, 6.4853) (-17.3036, 6.7685) (-17.0894, 6.9005) (-15.1614, 6.8851) (-14.9995, 6.6612) (-14.9947, 5.2684) (-14.9005, 5.2) (-14.4495, 5.2) (-14.3505, 5.299) (-14.3351, 6.7386) (-14.1111, 6.9005) (-13.4614, 6.8851) (-13.2995, 6.6612) (-13.2947, 5.2684) (-13.2005, 5.2) (-12.7485, 5.2) (-12.6495, 5.299) (-12.5996, 6.7685) (-12.3854, 6.9005) (-11.3847, 6.8975) (-11.1495, 6.6623) (-11.1057, 5.2189) (-11.0475, 5.2), closed, covered)
  P29_AC3_L1.sweep_along_vector((0mm, 0mm, 0.07mm))
  P30_AC4_L1 [copper] = polyline(z=0.17mm, xy in mm: (-30.0475, 5.2) (-28.7689, 5.2408) (-28.7908, 7.6006) (-29.15, 7.5392) (-29.4231, 7.6195) (-30.0475, 7.6195) (-30.1276, 7.5787) (-30.1964, 7.3315) (-30.3847, 7.2025) (-31.4113, 7.2025) (-31.6465, 7.4377) (-31.5971, 8.6191) (-31.6543, 8.8316) (-31.7485, 8.9) (-32.2005, 8.9) (-32.2995, 8.801) (-32.3149, 7.3614) (-32.5388, 7.1995) (-33.1886, 7.2149) (-33.3505, 7.4388) (-33.3553, 8.8316) (-33.4495, 8.9) (-33.9005, 8.9) (-33.9995, 8.801) (-34.0149, 7.3614) (-34.1614, 7.2149) (-34.8111, 7.1995) (-34.9764, 7.2736) (-35.0505, 7.4388) (-35.0913, 8.8811) (-37.7311, 8.8592) (-37.7092, 5.2189) (-36.3724, 5.2408) (-36.3505, 6.6623) (-36.1153, 6.8975) (-35.1146, 6.9005) (-34.9004, 6.7685) (-34.8505, 5.299) (-34.7515, 5.2) (-34.2194, 5.2408) (-34.2005, 6.6611) (-34.1264, 6.8264) (-33.9611, 6.9005) (-33.3114, 6.8851) (-33.1495, 6.6612) (-33.1447, 5.2684) (-33.0505, 5.2) (-32.5995, 5.2) (-32.5005, 5.299) (-32.5005, 6.6611) (-32.4264, 6.8264) (-32.2611, 6.9005) (-30.4106, 6.9005) (-30.2785, 6.8506) (-30.1495, 6.6623) (-30.1057, 5.2189) (-30.0475, 5.2), closed, covered)
  P30_AC4_L1.sweep_along_vector((0mm, 0mm, 0.07mm))
  P31_AC1_L3 = polyline(z=-1.27mm, xy in mm: (30.3251, 5.2) (43.6311, 5.2408) (43.65, 18.5474) (43.5425, 18.646) (43.078, 18.4995) (42.6276, 18.758) (42.3601, 18.54) (42.078, 18.4995) (41.6276, 18.758) (41.3601, 18.54) (41.078, 18.4995) (40.6276, 18.758) (40.3601, 18.54) (40.078, 18.4995) (39.6276, 18.758) (39.3601, 18.54) (39.078, 18.4995) (38.6276, 18.758) (38.3601, 18.54) (38.078, 18.4995) (37.6276, 18.758) (37.3601, 18.54) (37.078, 18.4995) (36.6276, 18.758) (36.3601, 18.54) (36.078, 18.4995) (35.6276, 18.758) (35.3601, 18.54) (35.078, 18.4995) (34.6276, 18.758) (34.3601, 18.54) (34.078, 18.4995) (33.6276, 18.758) (33.3601, 18.54) (33.078, 18.4995) (32.6276, 18.758) (32.3601, 18.54) (32.078, 18.4995) (31.6276, 18.758) (31.3601, 18.54) (31.078, 18.4995) (30.6276, 18.758) (30.3601, 18.54) (30.078, 18.4995) (29.8189, 18.6179) (29.6648, 18.8575) (29.6648, 19.1425) (29.7803, 19.3835) (29.6444, 19.75) (29.7246, 20.0234) (29.9399, 20.21) (30.222, 20.2505) (30.6724, 19.992) (30.9399, 20.21) (31.222, 20.2505) (31.6724, 19.992) (31.9399, 20.21) (32.222, 20.2505) (32.6724, 19.992) (32.9399, 20.21) (33.222, 20.2505) (33.6724, 19.992) (33.9399, 20.21) (34.222, 20.2505) (34.6724, 19.992) (34.9399, 20.21) (35.222, 20.2505) (35.6724, 19.992) (35.9399, 20.21) (36.222, 20.2505) (36.6724, 19.992) (36.9399, 20.21) (37.222, 20.2505) (37.6724, 19.992) (37.9399, 20.21) (38.222, 20.2505) (38.6724, 19.992) (38.9399, 20.21) (39.222, 20.2505) (39.6724, 19.992) (39.9399, 20.21) (40.222, 20.2505) (40.6724, 19.992) (40.9399, 20.21) (41.222, 20.2505) (41.6724, 19.992) (41.9399, 20.21) (42.222, 20.2505) (42.6724, 19.992) (43.078, 20.2505) (43.5816, 20.1084) (43.65, 20.2026) (43.65, 20.6) (29.15, 20.6) (29.15, 10.9454) (29.4985, 10.6832) (29.5808, 10.43) (29.4985, 10.1768) (29.15, 9.9146) (29.15, 6.6454) (29.4985, 6.3832) (29.5808, 6.13) (29.4985, 5.8768) (29.1689, 5.6728) (29.15, 5.299) (29.1908, 5.2189) (29.4159, 5.2108) (29.5948, 5.4285) (29.848, 5.5108) (30.1012, 5.4285) (30.2669, 5.2189) (30.3251, 5.2), closed, covered)
  P31_AC1_L3_h0 = polyline(z=-1.27mm, xy in mm: (37.297, 11.7245) (37.0149, 11.765) (36.7398, 12.0825) (36.7398, 12.3675) (37.0149, 12.685) (37.4351, 12.685) (37.7102, 12.3675) (37.7102, 12.0825) (37.4351, 11.765) (37.297, 11.7245), closed, covered)
  P31_AC1_L3_h1 = polyline(z=-1.27mm, xy in mm: (29.848, 8.9492) (29.4995, 9.1268) (29.4172, 9.38) (29.4995, 9.6332) (29.7149, 9.7897) (30.1012, 9.7285) (30.2577, 9.5131) (30.1965, 9.1268) (29.9811, 8.9703) (29.848, 8.9492), closed, covered)
  P31_AC1_L3.subtract(P31_AC1_L3_h0, P31_AC1_L3_h1)
  P31_AC1_L3.sweep_along_vector((0mm, 0mm, 0.07mm))
  P32_AC2_L3 = polyline(z=-1.27mm, xy in mm: (3.949, 5.2) (18.3311, 5.2408) (18.3488, 7.4701) (18.0015, 7.7168) (17.9192, 7.97) (18.0015, 8.2232) (18.35, 8.4854) (18.35, 10.5005) (17.9689, 10.7179) (17.7944, 11.1) (17.9689, 11.4821) (18.35, 11.6995) (18.35, 20.6) (3.85, 20.6) (3.8979, 20.1178) (4.422, 20.2505) (4.8724, 19.992) (5.278, 20.2505) (5.5601, 20.21) (5.8724, 19.992) (6.1399, 20.21) (6.422, 20.2505) (6.8724, 19.992) (7.1399, 20.21) (7.422, 20.2505) (7.8724, 19.992) (8.1399, 20.21) (8.422, 20.2505) (8.8724, 19.992) (9.1399, 20.21) (9.422, 20.2505) (9.8724, 19.992) (10.1399, 20.21) (10.422, 20.2505) (10.8724, 19.992) (11.1399, 20.21) (11.422, 20.2505) (11.8724, 19.992) (12.1399, 20.21) (12.422, 20.2505) (12.8724, 19.992) (13.1399, 20.21) (13.422, 20.2505) (13.8724, 19.992) (14.1399, 20.21) (14.422, 20.2505) (14.8724, 19.992) (15.1399, 20.21) (15.422, 20.2505) (15.8724, 19.992) (16.1399, 20.21) (16.422, 20.2505) (16.8724, 19.992) (17.1399, 20.21) (17.422, 20.2505) (17.7056, 20.104) (17.8556, 19.75) (17.7197, 19.3665) (17.8352, 19.1425) (17.8352, 18.8575) (17.6811, 18.6179) (17.422, 18.4995) (17.1399, 18.54) (16.8276, 18.758) (16.422, 18.4995) (16.1399, 18.54) (15.8276, 18.758) (15.422, 18.4995) (15.1399, 18.54) (14.8276, 18.758) (14.422, 18.4995) (14.1399, 18.54) (13.8276, 18.758) (13.422, 18.4995) (13.1399, 18.54) (12.8276, 18.758) (12.422, 18.4995) (12.1399, 18.54) (11.8276, 18.758) (11.422, 18.4995) (11.1399, 18.54) (10.8276, 18.758) (10.422, 18.4995) (10.1399, 18.54) (9.8276, 18.758) (9.422, 18.4995) (9.1399, 18.54) (8.8276, 18.758) (8.422, 18.4995) (8.1399, 18.54) (7.8276, 18.758) (7.422, 18.4995) (7.1399, 18.54) (6.8276, 18.758) (6.422, 18.4995) (6.1399, 18.54) (5.8276, 18.758) (5.422, 18.4995) (5.1399, 18.54) (4.8276, 18.758) (4.422, 18.4995) (3.9796, 18.6416) (3.8689, 18.6056) (3.8908, 5.2189) (3.949, 5.2), closed, covered)
  P32_AC2_L3_h0 = polyline(z=-1.27mm, xy in mm: (10.272, 10.5995) (9.8689, 10.7179) (9.6944, 11.1) (9.7746, 11.3734) (10.1247, 11.6625) (9.8496, 11.9516) (9.7898, 12.3675) (9.9439, 12.6071) (10.203, 12.7255) (10.6061, 12.6071) (10.7806, 12.225) (10.7004, 11.9516) (10.3503, 11.6625) (10.6254, 11.3734) (10.7056, 11.1) (10.6254, 10.8266) (10.4101, 10.64) (10.272, 10.5995), closed, covered)
  P32_AC2_L3_h1 = polyline(z=-1.27mm, xy in mm: (17.652, 8.5892) (17.3035, 8.7668) (17.2212, 9.02) (17.3035, 9.2732) (17.5189, 9.4297) (17.9052, 9.3685) (18.0617, 9.1531) (18.0005, 8.7668) (17.7851, 8.6103) (17.652, 8.5892), closed, covered)
  P32_AC2_L3.subtract(P32_AC2_L3_h0, P32_AC2_L3_h1)
  P32_AC2_L3.sweep_along_vector((0mm, 0mm, 0.07mm))
  P33_AC3_L3 = polyline(z=-1.27mm, xy in mm: (-17.1749, 5.2) (-3.8689, 5.2408) (-3.85, 18.5474) (-3.9575, 18.646) (-4.422, 18.4995) (-4.7754, 18.7266) (-4.8556, 19) (-4.7197, 19.3835) (-4.8556, 19.75) (-4.7754, 20.0234) (-4.5601, 20.21) (-4.278, 20.2505) (-3.9796, 20.1084) (-3.8689, 20.1444) (-3.85, 20.6) (-18.35, 20.6) (-18.35, 10.9454) (-18.0015, 10.6832) (-17.9192, 10.43) (-18.0015, 10.1768) (-18.35, 9.9146) (-18.35, 6.6454) (-18.0015, 6.3832) (-17.9192, 6.13) (-18.0015, 5.8768) (-18.3311, 5.6728) (-18.35, 5.299) (-18.3092, 5.2189) (-18.0841, 5.2108) (-17.9052, 5.4285) (-17.652, 5.5108) (-17.3988, 5.4285) (-17.2331, 5.2189) (-17.1749, 5.2), closed, covered)
  P33_AC3_L3_h0 = polyline(z=-1.27mm, xy in mm: (-7.278, 18.4995) (-7.5601, 18.54) (-7.8724, 18.758) (-8.1399, 18.54) (-8.422, 18.4995) (-8.8724, 18.758) (-9.1399, 18.54) (-9.422, 18.4995) (-9.8724, 18.758) (-10.1399, 18.54) (-10.422, 18.4995) (-10.8724, 18.758) (-11.1399, 18.54) (-11.422, 18.4995) (-11.8724, 18.758) (-12.1399, 18.54) (-12.422, 18.4995) (-12.8724, 18.758) (-13.1399, 18.54) (-13.422, 18.4995) (-13.8724, 18.758) (-14.1399, 18.54) (-14.422, 18.4995) (-14.8724, 18.758) (-15.1399, 18.54) (-15.422, 18.4995) (-15.8724, 18.758) (-16.1399, 18.54) (-16.422, 18.4995) (-16.8724, 18.758) (-17.1399, 18.54) (-17.422, 18.4995) (-17.6811, 18.6179) (-17.8352, 18.8575) (-17.8352, 19.1425) (-17.7197, 19.3835) (-17.8556, 19.75) (-17.7754, 20.0234) (-17.422, 20.2505) (-17.1399, 20.21) (-16.8276, 19.992) (-16.5601, 20.21) (-16.278, 20.2505) (-15.8276, 19.992) (-15.5601, 20.21) (-15.278, 20.2505) (-14.8276, 19.992) (-14.5601, 20.21) (-14.278, 20.2505) (-13.8276, 19.992) (-13.5601, 20.21) (-13.278, 20.2505) (-12.8276, 19.992) (-12.5601, 20.21) (-12.278, 20.2505) (-11.8276, 19.992) (-11.5601, 20.21) (-11.278, 20.2505) (-10.8276, 19.992) (-10.5601, 20.21) (-10.278, 20.2505) (-9.8276, 19.992) (-9.5601, 20.21) (-9.278, 20.2505) (-8.8276, 19.992) (-8.5601, 20.21) (-8.278, 20.2505) (-7.8276, 19.992) (-7.5601, 20.21) (-7.278, 20.2505) (-6.9246, 20.0234) (-6.8444, 19.75) (-6.9803, 19.3665) (-6.8648, 19.1425) (-6.8648, 18.8575) (-7.1399, 18.54) (-7.278, 18.4995), closed, covered)
  P33_AC3_L3_h1 = polyline(z=-1.27mm, xy in mm: (-10.203, 11.7245) (-10.4851, 11.765) (-10.7602, 12.0825) (-10.7602, 12.3675) (-10.4851, 12.685) (-10.0649, 12.685) (-9.7898, 12.3675) (-9.7898, 12.0825) (-10.0649, 11.765) (-10.203, 11.7245), closed, covered)
  P33_AC3_L3_h2 = polyline(z=-1.27mm, xy in mm: (-17.652, 8.9492) (-18.0005, 9.1268) (-18.0828, 9.38) (-18.0005, 9.6332) (-17.7851, 9.7897) (-17.3988, 9.7285) (-17.2423, 9.5131) (-17.3035, 9.1268) (-17.5189, 8.9703) (-17.652, 8.9492), closed, covered)
  P33_AC3_L3.subtract(P33_AC3_L3_h0, P33_AC3_L3_h1, P33_AC3_L3_h2)
  P33_AC3_L3.sweep_along_vector((0mm, 0mm, 0.07mm))
  P34_AC4_L3 = polyline(z=-1.27mm, xy in mm: (-43.551, 5.2) (-29.1689, 5.2408) (-29.1512, 7.4701) (-29.4985, 7.7168) (-29.5808, 7.97) (-29.4985, 8.2232) (-29.15, 8.4854) (-29.15, 10.5005) (-29.5311, 10.7179) (-29.7056, 11.1) (-29.5311, 11.4821) (-29.15, 11.6995) (-29.15, 20.6) (-43.65, 20.6) (-43.6021, 20.1178) (-43.078, 20.2505) (-42.6276, 19.992) (-42.222, 20.2505) (-41.9399, 20.21) (-41.6276, 19.992) (-41.3601, 20.21) (-41.078, 20.2505) (-40.6276, 19.992) (-40.3601, 20.21) (-40.078, 20.2505) (-39.6276, 19.992) (-39.3601, 20.21) (-39.078, 20.2505) (-38.6276, 19.992) (-38.3601, 20.21) (-38.078, 20.2505) (-37.6276, 19.992) (-37.3601, 20.21) (-37.078, 20.2505) (-36.6276, 19.992) (-36.3601, 20.21) (-36.078, 20.2505) (-35.6276, 19.992) (-35.3601, 20.21) (-35.078, 20.2505) (-34.6276, 19.992) (-34.3601, 20.21) (-34.078, 20.2505) (-33.6276, 19.992) (-33.3601, 20.21) (-33.078, 20.2505) (-32.6276, 19.992) (-32.3601, 20.21) (-32.078, 20.2505) (-31.6276, 19.992) (-31.3601, 20.21) (-31.078, 20.2505) (-30.6276, 19.992) (-30.3601, 20.21) (-30.078, 20.2505) (-29.7944, 20.104) (-29.6444, 19.75) (-29.7803, 19.3665) (-29.6648, 19.1425) (-29.6648, 18.8575) (-29.8189, 18.6179) (-30.078, 18.4995) (-30.3601, 18.54) (-30.6724, 18.758) (-31.078, 18.4995) (-31.3601, 18.54) (-31.6724, 18.758) (-32.078, 18.4995) (-32.3601, 18.54) (-32.6724, 18.758) (-33.078, 18.4995) (-33.3601, 18.54) (-33.6724, 18.758) (-34.078, 18.4995) (-34.3601, 18.54) (-34.6724, 18.758) (-35.078, 18.4995) (-35.3601, 18.54) (-35.6724, 18.758) (-36.078, 18.4995) (-36.3601, 18.54) (-36.6724, 18.758) (-37.078, 18.4995) (-37.3601, 18.54) (-37.6724, 18.758) (-38.078, 18.4995) (-38.3601, 18.54) (-38.6724, 18.758) (-39.078, 18.4995) (-39.3601, 18.54) (-39.6724, 18.758) (-40.078, 18.4995) (-40.3601, 18.54) (-40.6724, 18.758) (-41.078, 18.4995) (-41.3601, 18.54) (-41.6724, 18.758) (-42.078, 18.4995) (-42.3601, 18.54) (-42.6724, 18.758) (-43.078, 18.4995) (-43.5204, 18.6416) (-43.6311, 18.6056) (-43.6092, 5.2189) (-43.551, 5.2), closed, covered)
  P34_AC4_L3_h0 = polyline(z=-1.27mm, xy in mm: (-37.228, 10.5995) (-37.6311, 10.7179) (-37.8056, 11.1) (-37.7254, 11.3734) (-37.3753, 11.6625) (-37.6504, 11.9516) (-37.7102, 12.3675) (-37.5561, 12.6071) (-37.297, 12.7255) (-36.8939, 12.6071) (-36.7194, 12.225) (-36.7996, 11.9516) (-37.1497, 11.6625) (-36.8746, 11.3734) (-36.7944, 11.1) (-36.8746, 10.8266) (-37.0899, 10.64) (-37.228, 10.5995), closed, covered)
  P34_AC4_L3_h1 = polyline(z=-1.27mm, xy in mm: (-29.848, 8.5892) (-30.1965, 8.7668) (-30.2788, 9.02) (-30.1965, 9.2732) (-29.9811, 9.4297) (-29.5948, 9.3685) (-29.4383, 9.1531) (-29.4995, 8.7668) (-29.7149, 8.6103) (-29.848, 8.5892), closed, covered)
  P34_AC4_L3.subtract(P34_AC4_L3_h0, P34_AC4_L3_h1)
  P34_AC4_L3.sweep_along_vector((0mm, 0mm, 0.07mm))
  P35_AC1_L4 = polyline(z=-1.44mm, xy in mm: (38.6245, 4.6) (43.6311, 4.6408) (43.6422, 18.5859) (43.5425, 18.646) (43.078, 18.4995) (42.6276, 18.758) (42.3601, 18.54) (42.078, 18.4995) (41.6276, 18.758) (41.3601, 18.54) (41.078, 18.4995) (40.6276, 18.758) (40.3601, 18.54) (40.078, 18.4995) (39.6276, 18.758) (39.3601, 18.54) (39.078, 18.4995) (38.6276, 18.758) (38.3601, 18.54) (38.078, 18.4995) (37.6276, 18.758) (37.3601, 18.54) (37.078, 18.4995) (36.6276, 18.758) (36.3601, 18.54) (36.078, 18.4995) (35.6276, 18.758) (35.3601, 18.54) (35.078, 18.4995) (34.6276, 18.758) (34.3601, 18.54) (34.078, 18.4995) (33.6276, 18.758) (33.3601, 18.54) (33.078, 18.4995) (32.6276, 18.758) (32.3601, 18.54) (32.078, 18.4995) (31.6276, 18.758) (31.3601, 18.54) (31.078, 18.4995) (30.6276, 18.758) (30.3601, 18.54) (30.078, 18.4995) (29.8189, 18.6179) (29.6648, 18.8575) (29.6648, 19.1425) (29.7803, 19.3835) (29.6648, 19.6075) (29.6648, 19.8925) (29.8189, 20.1321) (30.078, 20.2505) (30.3601, 20.21) (30.6724, 19.992) (30.9399, 20.21) (31.222, 20.2505) (31.6724, 19.992) (31.9399, 20.21) (32.222, 20.2505) (32.6724, 19.992) (32.9399, 20.21) (33.222, 20.2505) (33.6724, 19.992) (33.9399, 20.21) (34.222, 20.2505) (34.6724, 19.992) (34.9399, 20.21) (35.222, 20.2505) (35.6724, 19.992) (35.9399, 20.21) (36.222, 20.2505) (36.6724, 19.992) (36.9399, 20.21) (37.222, 20.2505) (37.6724, 19.992) (37.9399, 20.21) (38.222, 20.2505) (38.6724, 19.992) (38.9399, 20.21) (39.222, 20.2505) (39.6724, 19.992) (39.9399, 20.21) (40.222, 20.2505) (40.6724, 19.992) (40.9399, 20.21) (41.222, 20.2505) (41.6724, 19.992) (41.9399, 20.21) (42.222, 20.2505) (42.6724, 19.992) (43.078, 20.2505) (43.5816, 20.1084) (43.65, 20.2026) (43.65, 20.6) (29.15, 20.6) (29.15, 15) (28.449, 15) (28.35, 14.901) (28.35, 10) (27.0689, 9.9592) (27.0908, 8.7194) (27.6806, 8.7413) (27.7055, 9.4672) (27.8317, 9.6604) (28.0207, 9.7341) (29.5749, 9.7305) (29.848, 9.8108) (30.1651, 9.7055) (38.2505, 9.7106) (38.2988, 9.8633) (38.1039, 10.1045) (34.3627, 10.1045) (34.0343, 9.9095) (33.6368, 9.9159) (33.3621, 10.1193) (33.0143, 9.9095) (32.6168, 9.9159) (32.3373, 10.1045) (29.4671, 10.1045) (29.15, 9.9992) (28.8968, 10.0815) (28.7403, 10.2969) (28.7403, 10.5631) (28.8968, 10.7785) (29.15, 10.8608) (29.4671, 10.7555) (32.3373, 10.7555) (32.6168, 10.9441) (33.0143, 10.9505) (33.3379, 10.7407) (33.6368, 10.9441) (34.0343, 10.9505) (34.3627, 10.7555) (38.1039, 10.7555) (38.4121, 11.0828) (39.1923, 11.1305) (39.2862, 11.1982) (39.1274, 11.5453) (39.1245, 12.2343) (39.3621, 12.5828) (41.3293, 12.6305) (41.6778, 12.3929) (41.7226, 11.5453) (41.4879, 11.2272) (40.8444, 11.1387) (40.8255, 9.7795) (40.9245, 9.6805) (41.3597, 9.6776) (41.5972, 9.5521) (41.7226, 9.3147) (41.7226, 8.5953) (41.5971, 8.3578) (41.3597, 8.2324) (39.5207, 8.2295) (39.1722, 8.4671) (39.1197, 8.9861) (39.0255, 9.0545) (30.1651, 9.0545) (29.848, 8.9492) (29.5749, 9.0295) (28.4689, 9.0247) (28.4005, 8.9305) (28.3945, 8.2628) (28.2683, 8.0696) (28.0793, 7.9959) (27.0689, 7.9587) (27.0548, 6.1689) (27.149, 6.1005) (28.2191, 6.0625) (28.3754, 5.8927) (28.4053, 5.4989) (28.4995, 5.4305) (29.5749, 5.4305) (29.848, 5.5108) (30.1651, 5.4055) (35.0505, 5.4106) (35.0988, 5.5633) (34.9039, 5.8045) (34.3627, 5.8045) (34.0343, 5.6095) (33.6368, 5.6159) (33.3621, 5.8193) (33.0143, 5.6095) (32.6168, 5.6159) (32.3373, 5.8045) (29.4671, 5.8045) (29.0169, 5.7203) (28.8015, 5.8768) (28.7192, 6.13) (28.8968, 6.4785) (29.15, 6.5608) (29.4671, 6.4555) (32.3373, 6.4555) (32.6168, 6.6441) (33.0143, 6.6505) (33.3379, 6.4407) (33.6368, 6.6441) (34.0343, 6.6505) (34.3627, 6.4555) (34.9039, 6.4555) (35.2121, 6.7828) (35.9923, 6.8305) (36.0862, 6.8982) (35.9274, 7.2453) (35.9245, 7.9343) (36.1621, 8.2828) (38.1597, 8.3276) (38.3972, 8.2021) (38.5226, 7.9647) (38.5226, 7.2453) (38.2879, 6.9272) (37.6444, 6.8387) (37.6255, 5.4795) (37.7245, 5.3805) (38.1597, 5.3776) (38.3971, 5.2522) (38.5226, 5.0147) (38.5663, 4.6189) (38.6245, 4.6), closed, covered)
  P35_AC1_L4_h0 = polyline(z=-1.44mm, xy in mm: (37.297, 11.7245) (37.0149, 11.765) (36.7996, 11.9516) (36.7194, 12.225) (36.8245, 12.564) (36.7837, 12.6806) (36.2903, 12.7024) (35.9722, 12.9371) (35.9245, 13.7543) (36.0864, 14.0699) (36.0505, 14.1806) (35.3403, 14.2024) (35.1029, 14.3278) (34.9039, 14.5745) (34.3627, 14.5745) (34.0832, 14.3859) (33.6857, 14.3795) (33.5296, 14.4359) (33.3959, 14.6268) (33.3959, 15.1732) (33.6368, 15.4141) (34.0832, 15.4141) (34.3627, 15.2255) (34.9039, 15.2255) (35.1029, 15.4721) (35.3403, 15.5976) (36.0499, 15.619) (36.0867, 15.7294) (35.9274, 16.0153) (35.9274, 16.7347) (36.0529, 16.9721) (36.2903, 17.0976) (38.1597, 17.0976) (38.3972, 16.9721) (38.5226, 16.7347) (38.5226, 16.0153) (38.3972, 15.7779) (38.1597, 15.6524) (37.6444, 15.6087) (37.6255, 14.2495) (37.7245, 14.1505) (38.1597, 14.1476) (38.3972, 14.0221) (38.5226, 13.7847) (38.5226, 13.0653) (38.2879, 12.7472) (37.6444, 12.6587) (37.7102, 12.0825) (37.4351, 11.765) (37.297, 11.7245), closed, covered)
  P35_AC1_L4.subtract(P35_AC1_L4_h0)
  P35_AC1_L4.sweep_along_vector((0mm, 0mm, 0.07mm))
  P36_AC2_L4 = polyline(z=-1.44mm, xy in mm: (3.949, 4.6) (8.9049, 4.6) (8.9975, 4.6705) (9.0222, 5.6329) (9.3707, 5.8705) (11.3379, 5.8228) (11.5278, 5.6329) (11.5803, 5.1139) (11.6745, 5.0455) (17.3349, 5.0455) (17.652, 5.1508) (17.9251, 5.0705) (19.0005, 5.0705) (19.0995, 5.1695) (19.1055, 5.8372) (19.2317, 6.0304) (19.4207, 6.1041) (20.4311, 6.1413) (20.4452, 7.9311) (20.351, 7.9995) (19.2809, 8.0375) (19.1246, 8.2073) (19.0947, 8.6011) (19.0005, 8.6695) (17.9251, 8.6695) (17.652, 8.5892) (17.3349, 8.6945) (9.2808, 8.6945) (9.1818, 8.5948) (9.3961, 8.2955) (13.1373, 8.2955) (13.4657, 8.4905) (13.8632, 8.4841) (14.1379, 8.2807) (14.4857, 8.4905) (14.8832, 8.4841) (15.1627, 8.2955) (18.0329, 8.2955) (18.35, 8.4008) (18.6032, 8.3185) (18.7597, 8.1031) (18.7597, 7.8369) (18.6032, 7.6215) (18.35, 7.5392) (18.0329, 7.6445) (15.1627, 7.6445) (14.8832, 7.4559) (14.4857, 7.4495) (14.1621, 7.6593) (13.8632, 7.4559) (13.4657, 7.4495) (13.1373, 7.6445) (9.3961, 7.6445) (9.0879, 7.3172) (8.3077, 7.2695) (8.2138, 7.2018) (8.3726, 6.8547) (8.3755, 6.1657) (8.1379, 5.8172) (6.1403, 5.7724) (5.9029, 5.8978) (5.7774, 6.1353) (5.7774, 6.8547) (5.9029, 7.0922) (6.1403, 7.2176) (6.6061, 7.2253) (6.6745, 7.3195) (6.6697, 8.6511) (6.5755, 8.7195) (6.0121, 8.7672) (5.7774, 9.0853) (5.7774, 9.8047) (5.9029, 10.0422) (6.1403, 10.1676) (8.1379, 10.1228) (8.3278, 9.9329) (8.3803, 9.4139) (8.4745, 9.3455) (17.3349, 9.3455) (17.652, 9.4508) (17.9251, 9.3705) (19.5085, 9.3705) (19.7754, 9.1627) (19.8413, 8.7194) (20.4311, 8.7413) (20.4092, 9.9811) (19.15, 10) (19.1452, 14.9316) (19.051, 15) (18.35, 15) (18.35, 20.6) (3.85, 20.6) (3.8979, 20.1178) (4.422, 20.2505) (4.8724, 19.992) (5.278, 20.2505) (5.5601, 20.21) (5.8724, 19.992) (6.1399, 20.21) (6.422, 20.2505) (6.8724, 19.992) (7.1399, 20.21) (7.422, 20.2505) (7.8724, 19.992) (8.1399, 20.21) (8.422, 20.2505) (8.8724, 19.992) (9.1399, 20.21) (9.422, 20.2505) (9.8724, 19.992) (10.1399, 20.21) (10.422, 20.2505) (10.8724, 19.992) (11.1399, 20.21) (11.422, 20.2505) (11.8724, 19.992) (12.1399, 20.21) (12.422, 20.2505) (12.8724, 19.992) (13.1399, 20.21) (13.422, 20.2505) (13.8724, 19.992) (14.1399, 20.21) (14.422, 20.2505) (14.8724, 19.992) (15.1399, 20.21) (15.422, 20.2505) (15.8724, 19.992) (16.1399, 20.21) (16.422, 20.2505) (16.8724, 19.992) (17.1399, 20.21) (17.422, 20.2505) (17.7056, 20.104) (17.8556, 19.75) (17.7197, 19.3665) (17.8352, 19.1425) (17.8352, 18.8575) (17.6811, 18.6179) (17.422, 18.4995) (17.1399, 18.54) (16.8276, 18.758) (16.422, 18.4995) (16.1399, 18.54) (15.8276, 18.758) (15.422, 18.4995) (15.1399, 18.54) (14.8276, 18.758) (14.422, 18.4995) (14.1399, 18.54) (13.8276, 18.758) (13.422, 18.4995) (13.1399, 18.54) (12.8276, 18.758) (12.422, 18.4995) (12.1399, 18.54) (11.8276, 18.758) (11.422, 18.4995) (11.1399, 18.54) (10.8276, 18.758) (10.422, 18.4995) (10.1399, 18.54) (9.8276, 18.758) (9.422, 18.4995) (9.1399, 18.54) (8.8276, 18.758) (8.422, 18.4995) (8.1399, 18.54) (7.8276, 18.758) (7.422, 18.4995) (7.1399, 18.54) (6.8276, 18.758) (6.422, 18.4995) (6.1399, 18.54) (5.8276, 18.758) (5.422, 18.4995) (5.1399, 18.54) (4.8276, 18.758) (4.422, 18.4995) (3.9796, 18.6416) (3.8689, 18.6056) (3.8908, 4.6189) (3.949, 4.6), closed, covered)
  P36_AC2_L4_h0 = polyline(z=-1.44mm, xy in mm: (10.272, 10.5995) (9.9899, 10.64) (9.7148, 10.9575) (9.7746, 11.3734) (10.1247, 11.6625) (9.7898, 12.0825) (9.8697, 12.6311) (9.7755, 12.6995) (9.2121, 12.7472) (8.9774, 13.0653) (8.9774, 13.7847) (9.1028, 14.0221) (9.3403, 14.1476) (9.8061, 14.1553) (9.8745, 14.2495) (9.8697, 15.5811) (9.7755, 15.6495) (9.2121, 15.6972) (8.9774, 16.0153) (8.9774, 16.7347) (9.1028, 16.9721) (9.3403, 17.0976) (11.3379, 17.0528) (11.5755, 16.7043) (11.5726, 16.0153) (11.4136, 15.7301) (11.4495, 15.6194) (12.1597, 15.5976) (12.3971, 15.4722) (12.5961, 15.2255) (13.1373, 15.2255) (13.4168, 15.4141) (13.8143, 15.4205) (13.9704, 15.3641) (14.1041, 15.1732) (14.1041, 14.6268) (13.8632, 14.3859) (13.4168, 14.3859) (13.1373, 14.5745) (12.5961, 14.5745) (12.3971, 14.3278) (12.1597, 14.2024) (11.4501, 14.181) (11.4133, 14.0706) (11.5726, 13.7847) (11.5726, 13.0653) (11.3379, 12.7472) (10.6944, 12.6587) (10.7602, 12.0825) (10.6061, 11.8429) (10.3503, 11.6625) (10.6254, 11.3734) (10.7056, 11.1) (10.6254, 10.8266) (10.4101, 10.64) (10.272, 10.5995), closed, covered)
  P36_AC2_L4_h1 = polyline(z=-1.44mm, xy in mm: (18.372, 10.5995) (18.0899, 10.64) (17.8148, 10.9575) (17.8148, 11.2425) (18.0899, 11.56) (18.5101, 11.56) (18.7852, 11.2425) (18.7852, 10.9575) (18.5101, 10.64) (18.372, 10.5995), closed, covered)
  P36_AC2_L4.subtract(P36_AC2_L4_h0, P36_AC2_L4_h1)
  P36_AC2_L4.sweep_along_vector((0mm, 0mm, 0.07mm))
  P37_AC3_L4 = polyline(z=-1.44mm, xy in mm: (-8.8755, 4.6) (-3.949, 4.6) (-3.85, 4.699) (-3.85, 18.5474) (-3.9575, 18.646) (-4.422, 18.4995) (-4.7754, 18.7266) (-4.8556, 19) (-4.7197, 19.3835) (-4.8556, 19.75) (-4.7754, 20.0234) (-4.5601, 20.21) (-4.278, 20.2505) (-3.9796, 20.1084) (-3.8689, 20.1444) (-3.85, 20.6) (-18.35, 20.6) (-18.35, 15) (-19.051, 15) (-19.15, 14.901) (-19.15, 10) (-20.4311, 9.9592) (-20.4092, 8.7194) (-19.8194, 8.7413) (-19.7945, 9.4672) (-19.6683, 9.6604) (-19.4793, 9.7341) (-17.9251, 9.7305) (-17.652, 9.8108) (-17.3349, 9.7055) (-9.2495, 9.7106) (-9.2012, 9.8633) (-9.3961, 10.1045) (-13.1373, 10.1045) (-13.4657, 9.9095) (-13.8632, 9.9159) (-14.1379, 10.1193) (-14.4857, 9.9095) (-14.8832, 9.9159) (-15.1627, 10.1045) (-18.0329, 10.1045) (-18.35, 9.9992) (-18.6032, 10.0815) (-18.7597, 10.2969) (-18.7597, 10.5631) (-18.6032, 10.7785) (-18.35, 10.8608) (-18.0329, 10.7555) (-15.1627, 10.7555) (-14.8832, 10.9441) (-14.4857, 10.9505) (-14.1621, 10.7407) (-13.8632, 10.9441) (-13.4657, 10.9505) (-13.1373, 10.7555) (-9.3961, 10.7555) (-9.0879, 11.0828) (-8.3077, 11.1305) (-8.2138, 11.1982) (-8.3726, 11.5453) (-8.3755, 12.2343) (-8.1379, 12.5828) (-6.1707, 12.6305) (-5.8222, 12.3929) (-5.7774, 11.5453) (-6.0121, 11.2272) (-6.6556, 11.1387) (-6.6745, 9.7795) (-6.5755, 9.6805) (-6.1403, 9.6776) (-5.9028, 9.5521) (-5.7774, 9.3147) (-5.7774, 8.5953) (-5.9029, 8.3578) (-6.1403, 8.2324) (-7.9793, 8.2295) (-8.3278, 8.4671) (-8.3803, 8.9861) (-8.4745, 9.0545) (-17.3349, 9.0545) (-17.652, 8.9492) (-17.9251, 9.0295) (-19.0311, 9.0247) (-19.0995, 8.9305) (-19.1055, 8.2628) (-19.2317, 8.0696) (-19.4207, 7.9959) (-20.4311, 7.9587) (-20.4452, 6.1689) (-20.351, 6.1005) (-19.2809, 6.0625) (-19.1246, 5.8927) (-19.0947, 5.4989) (-19.0005, 5.4305) (-17.9251, 5.4305) (-17.652, 5.5108) (-17.3349, 5.4055) (-12.4495, 5.4106) (-12.4012, 5.5633) (-12.5961, 5.8045) (-13.1373, 5.8045) (-13.4657, 5.6095) (-13.8632, 5.6159) (-14.1379, 5.8193) (-14.4857, 5.6095) (-14.8832, 5.6159) (-15.1627, 5.8045) (-18.0329, 5.8045) (-18.4831, 5.7203) (-18.6985, 5.8768) (-18.7808, 6.13) (-18.6032, 6.4785) (-18.35, 6.5608) (-18.0329, 6.4555) (-15.1627, 6.4555) (-14.8832, 6.6441) (-14.4857, 6.6505) (-14.1621, 6.4407) (-13.8632, 6.6441) (-13.4657, 6.6505) (-13.1373, 6.4555) (-12.5961, 6.4555) (-12.2879, 6.7828) (-11.5077, 6.8305) (-11.4138, 6.8982) (-11.5726, 7.2453) (-11.5755, 7.9343) (-11.3379, 8.2828) (-9.3403, 8.3276) (-9.1028, 8.2022) (-8.9774, 7.9647) (-8.9774, 7.2453) (-9.2121, 6.9272) (-9.8556, 6.8387) (-9.8745, 5.4795) (-9.7755, 5.3805) (-9.3403, 5.3776) (-9.1028, 5.2522) (-8.9774, 5.0147) (-8.9337, 4.6189) (-8.8755, 4.6), closed, covered)
  P37_AC3_L4_h0 = polyline(z=-1.44mm, xy in mm: (-7.278, 18.4995) (-7.5601, 18.54) (-7.8724, 18.758) (-8.1399, 18.54) (-8.422, 18.4995) (-8.8724, 18.758) (-9.1399, 18.54) (-9.422, 18.4995) (-9.8724, 18.758) (-10.1399, 18.54) (-10.422, 18.4995) (-10.8724, 18.758) (-11.1399, 18.54) (-11.422, 18.4995) (-11.8724, 18.758) (-12.1399, 18.54) (-12.422, 18.4995) (-12.8724, 18.758) (-13.1399, 18.54) (-13.422, 18.4995) (-13.8724, 18.758) (-14.1399, 18.54) (-14.422, 18.4995) (-14.8724, 18.758) (-15.1399, 18.54) (-15.422, 18.4995) (-15.8724, 18.758) (-16.1399, 18.54) (-16.422, 18.4995) (-16.8724, 18.758) (-17.1399, 18.54) (-17.422, 18.4995) (-17.6811, 18.6179) (-17.8352, 18.8575) (-17.8352, 19.1425) (-17.7197, 19.3835) (-17.8556, 19.75) (-17.7754, 20.0234) (-17.422, 20.2505) (-17.1399, 20.21) (-16.8276, 19.992) (-16.5601, 20.21) (-16.278, 20.2505) (-15.8276, 19.992) (-15.5601, 20.21) (-15.278, 20.2505) (-14.8276, 19.992) (-14.5601, 20.21) (-14.278, 20.2505) (-13.8276, 19.992) (-13.5601, 20.21) (-13.278, 20.2505) (-12.8276, 19.992) (-12.5601, 20.21) (-12.278, 20.2505) (-11.8276, 19.992) (-11.5601, 20.21) (-11.278, 20.2505) (-10.8276, 19.992) (-10.5601, 20.21) (-10.278, 20.2505) (-9.8276, 19.992) (-9.5601, 20.21) (-9.278, 20.2505) (-8.8276, 19.992) (-8.5601, 20.21) (-8.278, 20.2505) (-7.8276, 19.992) (-7.5601, 20.21) (-7.278, 20.2505) (-6.9246, 20.0234) (-6.8444, 19.75) (-6.9803, 19.3665) (-6.8648, 19.1425) (-6.8648, 18.8575) (-7.1399, 18.54) (-7.278, 18.4995), closed, covered)
  P37_AC3_L4_h1 = polyline(z=-1.44mm, xy in mm: (-10.203, 11.7245) (-10.4851, 11.765) (-10.7004, 11.9516) (-10.7806, 12.225) (-10.6755, 12.564) (-10.7163, 12.6806) (-11.2097, 12.7024) (-11.5278, 12.9371) (-11.5755, 13.7543) (-11.4136, 14.0699) (-11.4495, 14.1806) (-12.1597, 14.2024) (-12.3972, 14.3278) (-12.5961, 14.5745) (-13.1373, 14.5745) (-13.4168, 14.3859) (-13.8143, 14.3795) (-13.9704, 14.4359) (-14.1041, 14.6268) (-14.1041, 15.1732) (-13.8632, 15.4141) (-13.4168, 15.4141) (-13.1373, 15.2255) (-12.5961, 15.2255) (-12.3972, 15.4721) (-12.1597, 15.5976) (-11.4501, 15.619) (-11.4133, 15.7294) (-11.5726, 16.0153) (-11.5726, 16.7347) (-11.4471, 16.9721) (-11.2097, 17.0976) (-9.3403, 17.0976) (-9.1028, 16.9721) (-8.9774, 16.7347) (-8.9774, 16.0153) (-9.1028, 15.7779) (-9.3403, 15.6524) (-9.8556, 15.6087) (-9.8745, 14.2495) (-9.7755, 14.1505) (-9.3403, 14.1476) (-9.1028, 14.0221) (-8.9774, 13.7847) (-8.9774, 13.0653) (-9.2121, 12.7472) (-9.8556, 12.6587) (-9.7898, 12.0825) (-10.0649, 11.765) (-10.203, 11.7245), closed, covered)
  P37_AC3_L4.subtract(P37_AC3_L4_h0, P37_AC3_L4_h1)
  P37_AC3_L4.sweep_along_vector((0mm, 0mm, 0.07mm))
  P38_AC4_L4 = polyline(z=-1.44mm, xy in mm: (-43.551, 4.6) (-38.5951, 4.6) (-38.5025, 4.6705) (-38.4778, 5.6329) (-38.1293, 5.8705) (-36.1621, 5.8228) (-35.9722, 5.6329) (-35.9197, 5.1139) (-35.8255, 5.0455) (-30.1651, 5.0455) (-29.848, 5.1508) (-29.5749, 5.0705) (-28.4995, 5.0705) (-28.4005, 5.1695) (-28.3945, 5.8372) (-28.2683, 6.0304) (-28.0793, 6.1041) (-27.0689, 6.1413) (-27.0548, 7.9311) (-27.149, 7.9995) (-28.2191, 8.0375) (-28.3754, 8.2073) (-28.4053, 8.6011) (-28.4995, 8.6695) (-29.5749, 8.6695) (-29.848, 8.5892) (-30.1651, 8.6945) (-38.2192, 8.6945) (-38.3182, 8.5948) (-38.1039, 8.2955) (-34.3627, 8.2955) (-34.0343, 8.4905) (-33.6368, 8.4841) (-33.3621, 8.2807) (-33.0143, 8.4905) (-32.6168, 8.4841) (-32.3373, 8.2955) (-29.4671, 8.2955) (-29.15, 8.4008) (-28.8968, 8.3185) (-28.7403, 8.1031) (-28.7403, 7.8369) (-28.8968, 7.6215) (-29.15, 7.5392) (-29.4671, 7.6445) (-32.3373, 7.6445) (-32.6168, 7.4559) (-33.0143, 7.4495) (-33.3379, 7.6593) (-33.6368, 7.4559) (-34.0343, 7.4495) (-34.3627, 7.6445) (-38.1039, 7.6445) (-38.4121, 7.3172) (-39.1923, 7.2695) (-39.2862, 7.2018) (-39.1274, 6.8547) (-39.1245, 6.1657) (-39.3621, 5.8172) (-41.3597, 5.7724) (-41.5971, 5.8978) (-41.7226, 6.1353) (-41.7226, 6.8547) (-41.5971, 7.0922) (-41.3597, 7.2176) (-40.8939, 7.2253) (-40.8255, 7.3195) (-40.8303, 8.6511) (-40.9245, 8.7195) (-41.4879, 8.7672) (-41.7226, 9.0853) (-41.7226, 9.8047) (-41.5971, 10.0422) (-41.3597, 10.1676) (-39.3621, 10.1228) (-39.1722, 9.9329) (-39.1197, 9.4139) (-39.0255, 9.3455) (-30.1651, 9.3455) (-29.848, 9.4508) (-29.5749, 9.3705) (-27.9915, 9.3705) (-27.7246, 9.1627) (-27.6587, 8.7194) (-27.0689, 8.7413) (-27.0908, 9.9811) (-28.35, 10) (-28.3548, 14.9316) (-28.449, 15) (-29.15, 15) (-29.15, 20.6) (-43.65, 20.6) (-43.6021, 20.1178) (-43.078, 20.2505) (-42.6276, 19.992) (-42.222, 20.2505) (-41.9399, 20.21) (-41.6276, 19.992) (-41.3601, 20.21) (-41.078, 20.2505) (-40.6276, 19.992) (-40.3601, 20.21) (-40.078, 20.2505) (-39.6276, 19.992) (-39.3601, 20.21) (-39.078, 20.2505) (-38.6276, 19.992) (-38.3601, 20.21) (-38.078, 20.2505) (-37.6276, 19.992) (-37.3601, 20.21) (-37.078, 20.2505) (-36.6276, 19.992) (-36.3601, 20.21) (-36.078, 20.2505) (-35.6276, 19.992) (-35.3601, 20.21) (-35.078, 20.2505) (-34.6276, 19.992) (-34.3601, 20.21) (-34.078, 20.2505) (-33.6276, 19.992) (-33.3601, 20.21) (-33.078, 20.2505) (-32.6276, 19.992) (-32.3601, 20.21) (-32.078, 20.2505) (-31.6276, 19.992) (-31.3601, 20.21) (-31.078, 20.2505) (-30.6276, 19.992) (-30.3601, 20.21) (-30.078, 20.2505) (-29.7944, 20.104) (-29.6444, 19.75) (-29.7803, 19.3665) (-29.6648, 19.1425) (-29.6648, 18.8575) (-29.8189, 18.6179) (-30.078, 18.4995) (-30.3601, 18.54) (-30.6724, 18.758) (-31.078, 18.4995) (-31.3601, 18.54) (-31.6724, 18.758) (-32.078, 18.4995) (-32.3601, 18.54) (-32.6724, 18.758) (-33.078, 18.4995) (-33.3601, 18.54) (-33.6724, 18.758) (-34.078, 18.4995) (-34.3601, 18.54) (-34.6724, 18.758) (-35.078, 18.4995) (-35.3601, 18.54) (-35.6724, 18.758) (-36.078, 18.4995) (-36.3601, 18.54) (-36.6724, 18.758) (-37.078, 18.4995) (-37.3601, 18.54) (-37.6724, 18.758) (-38.078, 18.4995) (-38.3601, 18.54) (-38.6724, 18.758) (-39.078, 18.4995) (-39.3601, 18.54) (-39.6724, 18.758) (-40.078, 18.4995) (-40.3601, 18.54) (-40.6724, 18.758) (-41.078, 18.4995) (-41.3601, 18.54) (-41.6724, 18.758) (-42.078, 18.4995) (-42.3601, 18.54) (-42.6724, 18.758) (-43.078, 18.4995) (-43.5204, 18.6416) (-43.6311, 18.6056) (-43.6092, 4.6189) (-43.551, 4.6), closed, covered)
  P38_AC4_L4_h0 = polyline(z=-1.44mm, xy in mm: (-37.228, 10.5995) (-37.5101, 10.64) (-37.7852, 10.9575) (-37.7254, 11.3734) (-37.3753, 11.6625) (-37.7102, 12.0825) (-37.6303, 12.6311) (-37.7245, 12.6995) (-38.2879, 12.7472) (-38.5226, 13.0653) (-38.5226, 13.7847) (-38.3972, 14.0221) (-38.1597, 14.1476) (-37.6939, 14.1553) (-37.6255, 14.2495) (-37.6303, 15.5811) (-37.7245, 15.6495) (-38.2879, 15.6972) (-38.5226, 16.0153) (-38.5226, 16.7347) (-38.3972, 16.9721) (-38.1597, 17.0976) (-36.1621, 17.0528) (-35.9245, 16.7043) (-35.9274, 16.0153) (-36.0864, 15.7301) (-36.0505, 15.6194) (-35.3403, 15.5976) (-35.1029, 15.4722) (-34.9039, 15.2255) (-34.3627, 15.2255) (-34.0832, 15.4141) (-33.6857, 15.4205) (-33.5296, 15.3641) (-33.3959, 15.1732) (-33.3959, 14.6268) (-33.6368, 14.3859) (-34.0832, 14.3859) (-34.3627, 14.5745) (-34.9039, 14.5745) (-35.1029, 14.3278) (-35.3403, 14.2024) (-36.0499, 14.181) (-36.0867, 14.0706) (-35.9274, 13.7847) (-35.9274, 13.0653) (-36.1621, 12.7472) (-36.8056, 12.6587) (-36.7398, 12.0825) (-36.8939, 11.8429) (-37.1497, 11.6625) (-36.8746, 11.3734) (-36.7944, 11.1) (-36.8746, 10.8266) (-37.0899, 10.64) (-37.228, 10.5995), closed, covered)
  P38_AC4_L4_h1 = polyline(z=-1.44mm, xy in mm: (-29.128, 10.5995) (-29.4101, 10.64) (-29.6852, 10.9575) (-29.6852, 11.2425) (-29.4101, 11.56) (-28.9899, 11.56) (-28.7148, 11.2425) (-28.7148, 10.9575) (-28.9899, 10.64) (-29.128, 10.5995), closed, covered)
  P38_AC4_L4.subtract(P38_AC4_L4_h0, P38_AC4_L4_h1)
  P38_AC4_L4.sweep_along_vector((0mm, 0mm, 0.07mm))
  V0_DCP = cylinder(axis=Z, base_centre=(12.9mm, 2.5mm, -1.44mm), radius=0.15mm, height=1.68mm)
  V1_DCP = cylinder(axis=Z, base_centre=(-34.6mm, 2.5mm, -1.44mm), radius=0.15mm, height=1.68mm)
  V2_DCP = cylinder(axis=Z, base_centre=(14.7mm, 2.5mm, -1.44mm), radius=0.15mm, height=1.68mm)
  V3_DCP = cylinder(axis=Z, base_centre=(-17.4mm, 2.5mm, -1.44mm), radius=0.15mm, height=1.68mm)
  V4_DCP = cylinder(axis=Z, base_centre=(16.5mm, 2.5mm, -1.44mm), radius=0.15mm, height=1.68mm)
  V5_DCP = cylinder(axis=Z, base_centre=(-15.6mm, 2.5mm, -1.44mm), radius=0.15mm, height=1.68mm)
  V6_DCP = cylinder(axis=Z, base_centre=(15.6mm, 2.5mm, -1.44mm), radius=0.15mm, height=1.68mm)
  V7_DCP = cylinder(axis=Z, base_centre=(-14.7mm, 2.5mm, -1.44mm), radius=0.15mm, height=1.68mm)
  V8_DCP = cylinder(axis=Z, base_centre=(29.2mm, 2.5mm, -1.44mm), radius=0.15mm, height=1.68mm)
  V9_DCP = cylinder(axis=Z, base_centre=(-35.5mm, 2.5mm, -1.44mm), radius=0.15mm, height=1.68mm)
  V10_DCP = cylinder(axis=Z, base_centre=(31.9mm, 2.5mm, -1.44mm), radius=0.15mm, height=1.68mm)
  V11_DCP = cylinder(axis=Z, base_centre=(-12.9mm, 2.5mm, -1.44mm), radius=0.15mm, height=1.68mm)
  V12_DCP = cylinder(axis=Z, base_centre=(17.4mm, 2.5mm, -1.44mm), radius=0.15mm, height=1.68mm)
  V13_DCP = cylinder(axis=Z, base_centre=(35.5mm, 2.5mm, -1.44mm), radius=0.15mm, height=1.68mm)
  V14_DCP = cylinder(axis=Z, base_centre=(-16.5mm, 2.5mm, -1.44mm), radius=0.15mm, height=1.68mm)
  V15_DCP = cylinder(axis=Z, base_centre=(12mm, 2.5mm, -1.44mm), radius=0.15mm, height=1.68mm)
  V16_DCP = cylinder(axis=Z, base_centre=(33.7mm, 2.5mm, -1.44mm), radius=0.15mm, height=1.68mm)
  V17_DCP = cylinder(axis=Z, base_centre=(30.1mm, 2.5mm, -1.44mm), radius=0.15mm, height=1.68mm)
  V18_DCP = cylinder(axis=Z, base_centre=(-33.7mm, 2.5mm, -1.44mm), radius=0.15mm, height=1.68mm)
  V19_DCP = cylinder(axis=Z, base_centre=(-13.8mm, 2.5mm, -1.44mm), radius=0.15mm, height=1.68mm)
  V20_DCP = cylinder(axis=Z, base_centre=(-29.2mm, 2.5mm, -1.44mm), radius=0.15mm, height=1.68mm)
  V21_DCP = cylinder(axis=Z, base_centre=(-31mm, 2.5mm, -1.44mm), radius=0.15mm, height=1.68mm)
  V22_DCP = cylinder(axis=Z, base_centre=(36.4mm, 2.5mm, -1.44mm), radius=0.15mm, height=1.68mm)
  V23_DCP = cylinder(axis=Z, base_centre=(-18.3mm, 2.5mm, -1.44mm), radius=0.15mm, height=1.68mm)
  V24_DCP = cylinder(axis=Z, base_centre=(32.8mm, 2.5mm, -1.44mm), radius=0.15mm, height=1.68mm)
  V25_DCP = cylinder(axis=Z, base_centre=(-30.1mm, 2.5mm, -1.44mm), radius=0.15mm, height=1.68mm)
  V26_DCP = cylinder(axis=Z, base_centre=(37.3mm, 2.5mm, -1.44mm), radius=0.15mm, height=1.68mm)
  V27_DCP = cylinder(axis=Z, base_centre=(18.3mm, 2.5mm, -1.44mm), radius=0.15mm, height=1.68mm)
  V28_DCP = cylinder(axis=Z, base_centre=(-10.2mm, 2.5mm, -1.44mm), radius=0.15mm, height=1.68mm)
  V29_DCP = cylinder(axis=Z, base_centre=(-31.9mm, 2.5mm, -1.44mm), radius=0.15mm, height=1.68mm)
  V30_DCP = cylinder(axis=Z, base_centre=(-12mm, 2.5mm, -1.44mm), radius=0.15mm, height=1.68mm)
  V31_DCP = cylinder(axis=Z, base_centre=(13.8mm, 2.5mm, -1.44mm), radius=0.15mm, height=1.68mm)
  V32_DCP = cylinder(axis=Z, base_centre=(34.6mm, 2.5mm, -1.44mm), radius=0.15mm, height=1.68mm)
  V33_DCP = cylinder(axis=Z, base_centre=(31mm, 2.5mm, -1.44mm), radius=0.15mm, height=1.68mm)
  V34_DCP = cylinder(axis=Z, base_centre=(-32.8mm, 2.5mm, -1.44mm), radius=0.15mm, height=1.68mm)
  V35_DCP = cylinder(axis=Z, base_centre=(-11.1mm, 2.5mm, -1.44mm), radius=0.15mm, height=1.68mm)
  V36_DCN = cylinder(axis=Z, base_centre=(-12.975mm, 8.12mm, 0mm), radius=0.15mm, height=0.24mm)
  V37_DCN = cylinder(axis=Z, base_centre=(-37.15mm, 19mm, -1.44mm), radius=0.15mm, height=1.68mm)
  V38_DCN = cylinder(axis=Z, base_centre=(-37.9654mm, -0.5mm, -1.44mm), radius=0.15mm, height=1.68mm)
  V39_DCN = cylinder(axis=Z, base_centre=(8.35mm, 19.75mm, -1.44mm), radius=0.15mm, height=1.68mm)
  V40_DCN = cylinder(axis=Z, base_centre=(6.35mm, 19.75mm, -1.44mm), radius=0.15mm, height=1.68mm)
  V41_DCN = cylinder(axis=Z, base_centre=(37.9654mm, -0.5mm, -1.44mm), radius=0.15mm, height=1.68mm)
  V42_DCN = cylinder(axis=Z, base_centre=(-27.3038mm, -0.5mm, -1.44mm), radius=0.15mm, height=1.68mm)
  V43_DCN = cylinder(axis=Z, base_centre=(-13.35mm, 19.75mm, -1.44mm), radius=0.15mm, height=1.68mm)
  V44_DCN = cylinder(axis=Z, base_centre=(5.95mm, -0.5mm, -1.44mm), radius=0.15mm, height=1.68mm)
  V45_DCN = cylinder(axis=Z, base_centre=(-36.15mm, 19.75mm, -1.44mm), radius=0.15mm, height=1.68mm)
  V46_DCN = cylinder(axis=Z, base_centre=(-34.15mm, 19mm, -1.44mm), radius=0.15mm, height=1.68mm)
  V47_DCN = cylinder(axis=Z, base_centre=(10.35mm, 19mm, -1.44mm), radius=0.15mm, height=1.68mm)
  V48_DCN = cylinder(axis=Z, base_centre=(-38.15mm, 19mm, -1.44mm), radius=0.15mm, height=1.68mm)
  V49_DCN = cylinder(axis=Z, base_centre=(16.35mm, 19.75mm, -1.44mm), radius=0.15mm, height=1.68mm)
  V50_DCN = cylinder(axis=Z, base_centre=(-12.35mm, 19mm, -1.44mm), radius=0.15mm, height=1.68mm)
  V51_DCN = cylinder(axis=Z, base_centre=(-21.3808mm, -0.5mm, -1.44mm), radius=0.15mm, height=1.68mm)
  V52_DCN = cylinder(axis=Z, base_centre=(-4.35mm, 19.75mm, -1.44mm), radius=0.15mm, height=1.68mm)
  V53_DCN = cylinder(axis=Z, base_centre=(-34.4115mm, -0.5mm, -1.44mm), radius=0.15mm, height=1.68mm)
  V54_DCN = cylinder(axis=Z, base_centre=(12.35mm, 19mm, -1.44mm), radius=0.15mm, height=1.68mm)
  V55_DCN = cylinder(axis=Z, base_centre=(-15.35mm, 19mm, -1.44mm), radius=0.15mm, height=1.68mm)
  V56_DCN = cylinder(axis=Z, base_centre=(32.825mm, 9.2mm, 0mm), radius=0.15mm, height=0.24mm)
  V57_DCN = cylinder(axis=Z, base_centre=(-43.15mm, 19mm, -1.44mm), radius=0.15mm, height=1.68mm)
  V58_DCN = cylinder(axis=Z, base_centre=(-4.35mm, 19mm, -1.44mm), radius=0.15mm, height=1.68mm)
  V59_DCN = cylinder(axis=Z, base_centre=(12.35mm, 19.75mm, -1.44mm), radius=0.15mm, height=1.68mm)
  V60_DCN = cylinder(axis=Z, base_centre=(-37.15mm, 19.75mm, -1.44mm), radius=0.15mm, height=1.68mm)
  V61_DCN = cylinder(axis=Z, base_centre=(35.15mm, 19mm, -1.44mm), radius=0.15mm, height=1.68mm)
  V62_DCN = cylinder(axis=Z, base_centre=(-17.35mm, 19mm, -1.44mm), radius=0.15mm, height=1.68mm)
  V63_DCN = cylinder(axis=Z, base_centre=(-39.15mm, 19mm, -1.44mm), radius=0.15mm, height=1.68mm)
  V64_DCN = cylinder(axis=Z, base_centre=(-26.1192mm, -0.5mm, -1.44mm), radius=0.15mm, height=1.68mm)
  V65_DCN = cylinder(axis=Z, base_centre=(43.15mm, 19.75mm, -1.44mm), radius=0.15mm, height=1.68mm)
  V66_DCN = cylinder(axis=Z, base_centre=(33.15mm, 19mm, -1.44mm), radius=0.15mm, height=1.68mm)
  V67_DCN = cylinder(axis=Z, base_centre=(-10.35mm, 19.75mm, -1.44mm), radius=0.15mm, height=1.68mm)
  V68_DCN = cylinder(axis=Z, base_centre=(34.525mm, 8.12mm, 0mm), radius=0.15mm, height=0.24mm)
  V69_DCN = cylinder(axis=Z, base_centre=(12.975mm, 8.12mm, 0mm), radius=0.15mm, height=0.24mm)
  V70_DCN = cylinder(axis=Z, base_centre=(-1.25mm, -0.5mm, -1.44mm), radius=0.15mm, height=1.68mm)
  V71_DCN = cylinder(axis=Z, base_centre=(-40.15mm, 19mm, -1.44mm), radius=0.15mm, height=1.68mm)
  V72_DCN = cylinder(axis=Z, base_centre=(14.35mm, 19mm, -1.44mm), radius=0.15mm, height=1.68mm)
  V73_DCN = cylinder(axis=Z, base_centre=(35.15mm, 19.75mm, -1.44mm), radius=0.15mm, height=1.68mm)
  V74_DCN = cylinder(axis=Z, base_centre=(-41.15mm, 19mm, -1.44mm), radius=0.15mm, height=1.68mm)
  V75_DCN = cylinder(axis=Z, base_centre=(-34.15mm, 19.75mm, -1.44mm), radius=0.15mm, height=1.68mm)
  V76_DCN = cylinder(axis=Z, base_centre=(-8.35mm, 19.75mm, -1.44mm), radius=0.15mm, height=1.68mm)
  V77_DCN = cylinder(axis=Z, base_centre=(34.15mm, 19.75mm, -1.44mm), radius=0.15mm, height=1.68mm)
  V78_DCN = cylinder(axis=Z, base_centre=(37.15mm, 19mm, -1.44mm), radius=0.15mm, height=1.68mm)
  V79_DCN = cylinder(axis=Z, base_centre=(7.15mm, -0.5mm, -1.44mm), radius=0.15mm, height=1.68mm)
  V80_DCN = cylinder(axis=Z, base_centre=(-16.6423mm, -0.5mm, -1.44mm), radius=0.15mm, height=1.68mm)
  V81_DCN = cylinder(axis=Z, base_centre=(42.15mm, 19mm, -1.44mm), radius=0.15mm, height=1.68mm)
  V82_DCN = cylinder(axis=Z, base_centre=(21.3808mm, -0.5mm, -1.44mm), radius=0.15mm, height=1.68mm)
  V83_DCN = cylinder(axis=Z, base_centre=(-34.525mm, 8.12mm, 0mm), radius=0.15mm, height=0.24mm)
  V84_DCN = cylinder(axis=Z, base_centre=(24.9346mm, -0.5mm, -1.44mm), radius=0.15mm, height=1.68mm)
  V85_DCN = cylinder(axis=Z, base_centre=(1.15mm, -0.5mm, -1.44mm), radius=0.15mm, height=1.68mm)
  V86_DCN = cylinder(axis=Z, base_centre=(-29.6731mm, -0.5mm, -1.44mm), radius=0.15mm, height=1.68mm)
  V87_DCN = cylinder(axis=Z, base_centre=(32.15mm, 19.75mm, -1.44mm), radius=0.15mm, height=1.68mm)
  V88_DCN = cylinder(axis=Z, base_centre=(-37.3mm, 11.1mm, -1.44mm), radius=0.15mm, height=1.68mm)
  V89_DCN = cylinder(axis=Z, base_centre=(-12.975mm, 10.28mm, 0mm), radius=0.15mm, height=0.24mm)
  V90_DCN = cylinder(axis=Z, base_centre=(-4.85mm, -0.5mm, -1.44mm), radius=0.15mm, height=1.68mm)
  V91_DCN = cylinder(axis=Z, base_centre=(20.1962mm, -0.5mm, -1.44mm), radius=0.15mm, height=1.68mm)
  V92_DCN = cylinder(axis=Z, base_centre=(22.5654mm, -0.5mm, -1.44mm), radius=0.15mm, height=1.68mm)
  V93_DCN = cylinder(axis=Z, base_centre=(18.3mm, 11.1mm, -1.44mm), radius=0.15mm, height=1.68mm)
  V94_DCN = cylinder(axis=Z, base_centre=(-30.8577mm, -0.5mm, -1.44mm), radius=0.15mm, height=1.68mm)
  V95_DCN = cylinder(axis=Z, base_centre=(-9.5346mm, -0.5mm, -1.44mm), radius=0.15mm, height=1.68mm)
  V96_DCN = cylinder(axis=Z, base_centre=(17.35mm, 19.75mm, -1.44mm), radius=0.15mm, height=1.68mm)
  V97_DCN = cylinder(axis=Z, base_centre=(9.5346mm, -0.5mm, -1.44mm), radius=0.15mm, height=1.68mm)
  V98_DCN = cylinder(axis=Z, base_centre=(40.15mm, 19mm, -1.44mm), radius=0.15mm, height=1.68mm)
  V99_DCN = cylinder(axis=Z, base_centre=(-30.15mm, 19mm, -1.44mm), radius=0.15mm, height=1.68mm)
  V100_DCN = cylinder(axis=Z, base_centre=(-37.225mm, 12.225mm, -1.44mm), radius=0.15mm, height=1.68mm)
  V101_DCN = cylinder(axis=Z, base_centre=(-2.45mm, -0.5mm, -1.44mm), radius=0.15mm, height=1.68mm)
  V102_DCN = cylinder(axis=Z, base_centre=(15.35mm, 19mm, -1.44mm), radius=0.15mm, height=1.68mm)
  V103_DCN = cylinder(axis=Z, base_centre=(-22.5654mm, -0.5mm, -1.44mm), radius=0.15mm, height=1.68mm)
  V104_DCN = cylinder(axis=Z, base_centre=(19.0115mm, -0.5mm, -1.44mm), radius=0.15mm, height=1.68mm)
  V105_DCN = cylinder(axis=Z, base_centre=(-3.65mm, -0.5mm, -1.44mm), radius=0.15mm, height=1.68mm)
  V106_DCN = cylinder(axis=Z, base_centre=(-19.0115mm, -0.5mm, -1.44mm), radius=0.15mm, height=1.68mm)
  V107_DCN = cylinder(axis=Z, base_centre=(-35.15mm, 19mm, -1.44mm), radius=0.15mm, height=1.68mm)
  V108_DCN = cylinder(axis=Z, base_centre=(11.35mm, 19mm, -1.44mm), radius=0.15mm, height=1.68mm)
  V109_DCN = cylinder(axis=Z, base_centre=(-14.675mm, 9.2mm, 0mm), radius=0.15mm, height=0.24mm)
  V110_DCN = cylinder(axis=Z, base_centre=(-42.15mm, 19.75mm, -1.44mm), radius=0.15mm, height=1.68mm)
  V111_DCN = cylinder(axis=Z, base_centre=(4.35mm, 19mm, -1.44mm), radius=0.15mm, height=1.68mm)
  V112_DCN = cylinder(axis=Z, base_centre=(-42.15mm, 19mm, -1.44mm), radius=0.15mm, height=1.68mm)
  V113_DCN = cylinder(axis=Z, base_centre=(-43.15mm, 19.75mm, -1.44mm), radius=0.15mm, height=1.68mm)
  V114_DCN = cylinder(axis=Z, base_centre=(-16.35mm, 19.75mm, -1.44mm), radius=0.15mm, height=1.68mm)
  V115_DCN = cylinder(axis=Z, base_centre=(-40.15mm, 19.75mm, -1.44mm), radius=0.15mm, height=1.68mm)
  V116_DCN = cylinder(axis=Z, base_centre=(-0.05mm, -0.5mm, -1.44mm), radius=0.15mm, height=1.68mm)
  V117_DCN = cylinder(axis=Z, base_centre=(5.35mm, 19mm, -1.44mm), radius=0.15mm, height=1.68mm)
  V118_DCN = cylinder(axis=Z, base_centre=(16.6423mm, -0.5mm, -1.44mm), radius=0.15mm, height=1.68mm)
  V119_DCN = cylinder(axis=Z, base_centre=(34.15mm, 19mm, -1.44mm), radius=0.15mm, height=1.68mm)
  V120_DCN = cylinder(axis=Z, base_centre=(-7.35mm, 19.75mm, -1.44mm), radius=0.15mm, height=1.68mm)
  V121_DCN = cylinder(axis=Z, base_centre=(40.15mm, 19.75mm, -1.44mm), radius=0.15mm, height=1.68mm)
  V122_DCN = cylinder(axis=Z, base_centre=(-8.35mm, -0.5mm, -1.44mm), radius=0.15mm, height=1.68mm)
  V123_DCN = cylinder(axis=Z, base_centre=(14.2731mm, -0.5mm, -1.44mm), radius=0.15mm, height=1.68mm)
  V124_DCN = cylinder(axis=Z, base_centre=(31.15mm, 19.75mm, -1.44mm), radius=0.15mm, height=1.68mm)
  V125_DCN = cylinder(axis=Z, base_centre=(10.35mm, 19.75mm, -1.44mm), radius=0.15mm, height=1.68mm)
  V126_DCN = cylinder(axis=Z, base_centre=(35.5962mm, -0.5mm, -1.44mm), radius=0.15mm, height=1.68mm)
  V127_DCN = cylinder(axis=Z, base_centre=(-14.35mm, 19mm, -1.44mm), radius=0.15mm, height=1.68mm)
  V128_DCN = cylinder(axis=Z, base_centre=(-33.15mm, 19.75mm, -1.44mm), radius=0.15mm, height=1.68mm)
  V129_DCN = cylinder(axis=Z, base_centre=(-14.675mm, 8.12mm, 0mm), radius=0.15mm, height=0.24mm)
  V130_DCN = cylinder(axis=Z, base_centre=(7.35mm, 19mm, -1.44mm), radius=0.15mm, height=1.68mm)
  V131_DCN = cylinder(axis=Z, base_centre=(-38.15mm, 19.75mm, -1.44mm), radius=0.15mm, height=1.68mm)
  V132_DCN = cylinder(axis=Z, base_centre=(32.0423mm, -0.5mm, -1.44mm), radius=0.15mm, height=1.68mm)
  V133_DCN = cylinder(axis=Z, base_centre=(41.15mm, 19.75mm, -1.44mm), radius=0.15mm, height=1.68mm)
  V134_DCN = cylinder(axis=Z, base_centre=(27.3038mm, -0.5mm, -1.44mm), radius=0.15mm, height=1.68mm)
  V135_DCN = cylinder(axis=Z, base_centre=(13.35mm, 19mm, -1.44mm), radius=0.15mm, height=1.68mm)
  V136_DCN = cylinder(axis=Z, base_centre=(14.35mm, 19.75mm, -1.44mm), radius=0.15mm, height=1.68mm)
  V137_DCN = cylinder(axis=Z, base_centre=(-39.15mm, -0.5mm, -1.44mm), radius=0.15mm, height=1.68mm)
  V138_DCN = cylinder(axis=Z, base_centre=(-13.35mm, 19mm, -1.44mm), radius=0.15mm, height=1.68mm)
  V139_DCN = cylinder(axis=Z, base_centre=(2.35mm, -0.5mm, -1.44mm), radius=0.15mm, height=1.68mm)
  V140_DCN = cylinder(axis=Z, base_centre=(-32.0423mm, -0.5mm, -1.44mm), radius=0.15mm, height=1.68mm)
  V141_DCN = cylinder(axis=Z, base_centre=(-10.275mm, 12.225mm, -1.44mm), radius=0.15mm, height=1.68mm)
  V142_DCN = cylinder(axis=Z, base_centre=(-12.975mm, 9.2mm, 0mm), radius=0.15mm, height=0.24mm)
  V143_DCN = cylinder(axis=Z, base_centre=(3.55mm, -0.5mm, -1.44mm), radius=0.15mm, height=1.68mm)
  V144_DCN = cylinder(axis=Z, base_centre=(-10.35mm, 19mm, -1.44mm), radius=0.15mm, height=1.68mm)
  V145_DCN = cylinder(axis=Z, base_centre=(-33.2269mm, -0.5mm, -1.44mm), radius=0.15mm, height=1.68mm)
  V146_DCN = cylinder(axis=Z, base_centre=(-14.2731mm, -0.5mm, -1.44mm), radius=0.15mm, height=1.68mm)
  V147_DCN = cylinder(axis=Z, base_centre=(30.15mm, 19.75mm, -1.44mm), radius=0.15mm, height=1.68mm)
  V148_DCN = cylinder(axis=Z, base_centre=(12.975mm, 10.28mm, 0mm), radius=0.15mm, height=0.24mm)
  V149_DCN = cylinder(axis=Z, base_centre=(33.2269mm, -0.5mm, -1.44mm), radius=0.15mm, height=1.68mm)
  V150_DCN = cylinder(axis=Z, base_centre=(-9.35mm, 19.75mm, -1.44mm), radius=0.15mm, height=1.68mm)
  V151_DCN = cylinder(axis=Z, base_centre=(-29.2mm, 11.1mm, -1.44mm), radius=0.15mm, height=1.68mm)
  V152_DCN = cylinder(axis=Z, base_centre=(13.35mm, 19.75mm, -1.44mm), radius=0.15mm, height=1.68mm)
  V153_DCN = cylinder(axis=Z, base_centre=(31.15mm, 19mm, -1.44mm), radius=0.15mm, height=1.68mm)
  V154_DCN = cylinder(axis=Z, base_centre=(10.7192mm, -0.5mm, -1.44mm), radius=0.15mm, height=1.68mm)
  V155_DCN = cylinder(axis=Z, base_centre=(-31.15mm, 19.75mm, -1.44mm), radius=0.15mm, height=1.68mm)
  V156_DCN = cylinder(axis=Z, base_centre=(6.35mm, 19mm, -1.44mm), radius=0.15mm, height=1.68mm)
  V157_DCN = cylinder(axis=Z, base_centre=(-24.9346mm, -0.5mm, -1.44mm), radius=0.15mm, height=1.68mm)
  V158_DCN = cylinder(axis=Z, base_centre=(38.15mm, 19.75mm, -1.44mm), radius=0.15mm, height=1.68mm)
  V159_DCN = cylinder(axis=Z, base_centre=(-30.15mm, 19.75mm, -1.44mm), radius=0.15mm, height=1.68mm)
  V160_DCN = cylinder(axis=Z, base_centre=(9.35mm, 19mm, -1.44mm), radius=0.15mm, height=1.68mm)
  V161_DCN = cylinder(axis=Z, base_centre=(-32.825mm, 9.2mm, 0mm), radius=0.15mm, height=0.24mm)
  V162_DCN = cylinder(axis=Z, base_centre=(15.4577mm, -0.5mm, -1.44mm), radius=0.15mm, height=1.68mm)
  V163_DCN = cylinder(axis=Z, base_centre=(-15.4577mm, -0.5mm, -1.44mm), radius=0.15mm, height=1.68mm)
  V164_DCN = cylinder(axis=Z, base_centre=(-32.825mm, 8.12mm, 0mm), radius=0.15mm, height=0.24mm)
  V165_DCN = cylinder(axis=Z, base_centre=(12.975mm, 9.2mm, 0mm), radius=0.15mm, height=0.24mm)
  V166_DCN = cylinder(axis=Z, base_centre=(14.675mm, 9.2mm, 0mm), radius=0.15mm, height=0.24mm)
  V167_DCN = cylinder(axis=Z, base_centre=(30.8577mm, -0.5mm, -1.44mm), radius=0.15mm, height=1.68mm)
  V168_DCN = cylinder(axis=Z, base_centre=(42.15mm, 19.75mm, -1.44mm), radius=0.15mm, height=1.68mm)
  V169_DCN = cylinder(axis=Z, base_centre=(-32.15mm, 19.75mm, -1.44mm), radius=0.15mm, height=1.68mm)
  V170_DCN = cylinder(axis=Z, base_centre=(37.15mm, 19.75mm, -1.44mm), radius=0.15mm, height=1.68mm)
  V171_DCN = cylinder(axis=Z, base_centre=(29.6731mm, -0.5mm, -1.44mm), radius=0.15mm, height=1.68mm)
  V172_DCN = cylinder(axis=Z, base_centre=(-33.15mm, 19mm, -1.44mm), radius=0.15mm, height=1.68mm)
  V173_DCN = cylinder(axis=Z, base_centre=(16.35mm, 19mm, -1.44mm), radius=0.15mm, height=1.68mm)
  V174_DCN = cylinder(axis=Z, base_centre=(34.525mm, 10.28mm, 0mm), radius=0.15mm, height=0.24mm)
  V175_DCN = cylinder(axis=Z, base_centre=(36.7808mm, -0.5mm, -1.44mm), radius=0.15mm, height=1.68mm)
  V176_DCN = cylinder(axis=Z, base_centre=(-31.15mm, 19mm, -1.44mm), radius=0.15mm, height=1.68mm)
  V177_DCN = cylinder(axis=Z, base_centre=(-7.35mm, 19mm, -1.44mm), radius=0.15mm, height=1.68mm)
  V178_DCN = cylinder(axis=Z, base_centre=(15.35mm, 19.75mm, -1.44mm), radius=0.15mm, height=1.68mm)
  V179_DCN = cylinder(axis=Z, base_centre=(-6.05mm, -0.5mm, -1.44mm), radius=0.15mm, height=1.68mm)
  V180_DCN = cylinder(axis=Z, base_centre=(8.35mm, -0.5mm, -1.44mm), radius=0.15mm, height=1.68mm)
  V181_DCN = cylinder(axis=Z, base_centre=(-34.525mm, 9.2mm, 0mm), radius=0.15mm, height=0.24mm)
  V182_DCN = cylinder(axis=Z, base_centre=(37.225mm, 12.225mm, -1.44mm), radius=0.15mm, height=1.68mm)
  V183_DCN = cylinder(axis=Z, base_centre=(-20.1962mm, -0.5mm, -1.44mm), radius=0.15mm, height=1.68mm)
  V184_DCN = cylinder(axis=Z, base_centre=(-32.825mm, 10.28mm, 0mm), radius=0.15mm, height=0.24mm)
  V185_DCN = cylinder(axis=Z, base_centre=(-17.8269mm, -0.5mm, -1.44mm), radius=0.15mm, height=1.68mm)
  V186_DCN = cylinder(axis=Z, base_centre=(9.35mm, 19.75mm, -1.44mm), radius=0.15mm, height=1.68mm)
  V187_DCN = cylinder(axis=Z, base_centre=(32.825mm, 10.28mm, 0mm), radius=0.15mm, height=0.24mm)
  V188_DCN = cylinder(axis=Z, base_centre=(13.0885mm, -0.5mm, -1.44mm), radius=0.15mm, height=1.68mm)
  V189_DCN = cylinder(axis=Z, base_centre=(-15.35mm, 19.75mm, -1.44mm), radius=0.15mm, height=1.68mm)
  V190_DCN = cylinder(axis=Z, base_centre=(-14.35mm, 19.75mm, -1.44mm), radius=0.15mm, height=1.68mm)
  V191_DCN = cylinder(axis=Z, base_centre=(4.35mm, 19.75mm, -1.44mm), radius=0.15mm, height=1.68mm)
  V192_DCN = cylinder(axis=Z, base_centre=(32.15mm, 19mm, -1.44mm), radius=0.15mm, height=1.68mm)
  V193_DCN = cylinder(axis=Z, base_centre=(41.15mm, 19mm, -1.44mm), radius=0.15mm, height=1.68mm)
  V194_DCN = cylinder(axis=Z, base_centre=(8.35mm, 19mm, -1.44mm), radius=0.15mm, height=1.68mm)
  V195_DCN = cylinder(axis=Z, base_centre=(17.35mm, 19mm, -1.44mm), radius=0.15mm, height=1.68mm)
  V196_DCN = cylinder(axis=Z, base_centre=(30.15mm, 19mm, -1.44mm), radius=0.15mm, height=1.68mm)
  V197_DCN = cylinder(axis=Z, base_centre=(-8.35mm, 19mm, -1.44mm), radius=0.15mm, height=1.68mm)
  V198_DCN = cylinder(axis=Z, base_centre=(-35.15mm, 19.75mm, -1.44mm), radius=0.15mm, height=1.68mm)
  V199_DCN = cylinder(axis=Z, base_centre=(39.15mm, -0.5mm, -1.44mm), radius=0.15mm, height=1.68mm)
  V200_DCN = cylinder(axis=Z, base_centre=(10.275mm, 12.225mm, -1.44mm), radius=0.15mm, height=1.68mm)
  V201_DCN = cylinder(axis=Z, base_centre=(-11.9038mm, -0.5mm, -1.44mm), radius=0.15mm, height=1.68mm)
  V202_DCN = cylinder(axis=Z, base_centre=(28.4885mm, -0.5mm, -1.44mm), radius=0.15mm, height=1.68mm)
  V203_DCN = cylinder(axis=Z, base_centre=(-17.35mm, 19.75mm, -1.44mm), radius=0.15mm, height=1.68mm)
  V204_DCN = cylinder(axis=Z, base_centre=(39.15mm, 19.75mm, -1.44mm), radius=0.15mm, height=1.68mm)
  V205_DCN = cylinder(axis=Z, base_centre=(43.15mm, 19mm, -1.44mm), radius=0.15mm, height=1.68mm)
  V206_DCN = cylinder(axis=Z, base_centre=(36.15mm, 19mm, -1.44mm), radius=0.15mm, height=1.68mm)
  V207_DCN = cylinder(axis=Z, base_centre=(10.2mm, 11.1mm, -1.44mm), radius=0.15mm, height=1.68mm)
  V208_DCN = cylinder(axis=Z, base_centre=(-9.35mm, 19mm, -1.44mm), radius=0.15mm, height=1.68mm)
  V209_DCN = cylinder(axis=Z, base_centre=(-32.15mm, 19mm, -1.44mm), radius=0.15mm, height=1.68mm)
  V210_DCN = cylinder(axis=Z, base_centre=(14.675mm, 10.28mm, 0mm), radius=0.15mm, height=0.24mm)
  V211_DCN = cylinder(axis=Z, base_centre=(23.75mm, -0.5mm, -1.44mm), radius=0.15mm, height=1.68mm)
  V212_DCN = cylinder(axis=Z, base_centre=(11.35mm, 19.75mm, -1.44mm), radius=0.15mm, height=1.68mm)
  V213_DCN = cylinder(axis=Z, base_centre=(-11.35mm, 19.75mm, -1.44mm), radius=0.15mm, height=1.68mm)
  V214_DCN = cylinder(axis=Z, base_centre=(-36.7808mm, -0.5mm, -1.44mm), radius=0.15mm, height=1.68mm)
  V215_DCN = cylinder(axis=Z, base_centre=(5.35mm, 19.75mm, -1.44mm), radius=0.15mm, height=1.68mm)
  V216_DCN = cylinder(axis=Z, base_centre=(-41.15mm, 19.75mm, -1.44mm), radius=0.15mm, height=1.68mm)
  V217_DCN = cylinder(axis=Z, base_centre=(-36.15mm, 19mm, -1.44mm), radius=0.15mm, height=1.68mm)
  V218_DCN = cylinder(axis=Z, base_centre=(34.525mm, 9.2mm, 0mm), radius=0.15mm, height=0.24mm)
  V219_DCN = cylinder(axis=Z, base_centre=(7.35mm, 19.75mm, -1.44mm), radius=0.15mm, height=1.68mm)
  V220_DCN = cylinder(axis=Z, base_centre=(-16.35mm, 19mm, -1.44mm), radius=0.15mm, height=1.68mm)
  V221_DCN = cylinder(axis=Z, base_centre=(26.1192mm, -0.5mm, -1.44mm), radius=0.15mm, height=1.68mm)
  V222_DCN = cylinder(axis=Z, base_centre=(38.15mm, 19mm, -1.44mm), radius=0.15mm, height=1.68mm)
  V223_DCN = cylinder(axis=Z, base_centre=(-7mm, 4mm, -1.44mm), radius=0.15mm, height=1.68mm)
  V224_DCN = cylinder(axis=Z, base_centre=(-14.675mm, 10.28mm, 0mm), radius=0.15mm, height=0.24mm)
  V225_DCN = cylinder(axis=Z, base_centre=(33.15mm, 19.75mm, -1.44mm), radius=0.15mm, height=1.68mm)
  V226_DCN = cylinder(axis=Z, base_centre=(14.675mm, 8.12mm, 0mm), radius=0.15mm, height=0.24mm)
  V227_DCN = cylinder(axis=Z, base_centre=(-35.5962mm, -0.5mm, -1.44mm), radius=0.15mm, height=1.68mm)
  V228_DCN = cylinder(axis=Z, base_centre=(4.75mm, -0.5mm, -1.44mm), radius=0.15mm, height=1.68mm)
  V229_DCN = cylinder(axis=Z, base_centre=(-23.75mm, -0.5mm, -1.44mm), radius=0.15mm, height=1.68mm)
  V230_DCN = cylinder(axis=Z, base_centre=(-13.0885mm, -0.5mm, -1.44mm), radius=0.15mm, height=1.68mm)
  V231_DCN = cylinder(axis=Z, base_centre=(11.9038mm, -0.5mm, -1.44mm), radius=0.15mm, height=1.68mm)
  V232_DCN = cylinder(axis=Z, base_centre=(-39.15mm, 19.75mm, -1.44mm), radius=0.15mm, height=1.68mm)
  V233_DCN = cylinder(axis=Z, base_centre=(-28.4885mm, -0.5mm, -1.44mm), radius=0.15mm, height=1.68mm)
  V234_DCN = cylinder(axis=Z, base_centre=(17.8269mm, -0.5mm, -1.44mm), radius=0.15mm, height=1.68mm)
  V235_DCN = cylinder(axis=Z, base_centre=(-12.35mm, 19.75mm, -1.44mm), radius=0.15mm, height=1.68mm)
  V236_DCN = cylinder(axis=Z, base_centre=(34.4115mm, -0.5mm, -1.44mm), radius=0.15mm, height=1.68mm)
  V237_DCN = cylinder(axis=Z, base_centre=(-11.35mm, 19mm, -1.44mm), radius=0.15mm, height=1.68mm)
  V238_DCN = cylinder(axis=Z, base_centre=(-10.7192mm, -0.5mm, -1.44mm), radius=0.15mm, height=1.68mm)
  V239_DCN = cylinder(axis=Z, base_centre=(39.15mm, 19mm, -1.44mm), radius=0.15mm, height=1.68mm)
  V240_DCN = cylinder(axis=Z, base_centre=(36.15mm, 19.75mm, -1.44mm), radius=0.15mm, height=1.68mm)
  V241_DCN = cylinder(axis=Z, base_centre=(-34.525mm, 10.28mm, 0mm), radius=0.15mm, height=0.24mm)
  V242_DCN = cylinder(axis=Z, base_centre=(32.825mm, 8.12mm, 0mm), radius=0.15mm, height=0.24mm)
  V243_AC2 = cylinder(axis=Z, base_centre=(10.2mm, 7.05mm, -1.44mm), radius=0.15mm, height=1.68mm)
  V244_AC1 = cylinder(axis=Z, base_centre=(29.2mm, 7.05mm, -1.44mm), radius=0.15mm, height=1.68mm)
  V245_AC3 = cylinder(axis=Z, base_centre=(-18.3mm, 7.05mm, -1.44mm), radius=0.15mm, height=1.68mm)
  V246_AC4 = cylinder(axis=Z, base_centre=(-29.2mm, 7.05mm, -1.44mm), radius=0.15mm, height=1.68mm)
  V247_AC4 = cylinder(axis=Z, base_centre=(-37.3mm, 7.05mm, -1.44mm), radius=0.15mm, height=1.68mm)
  V248_AC2 = cylinder(axis=Z, base_centre=(18.3mm, 7.05mm, -1.44mm), radius=0.15mm, height=1.68mm)
  Q2_3 = box(corner=(15.2mm, 3.1mm, 0.17mm), size=(0.65mm, 3.6mm, 0.105mm))
  Q2_4 = box(corner=(14.35mm, 3.1mm, 0.17mm), size=(0.65mm, 3.6mm, 0.105mm))
  Q2_5 = box(corner=(13.5mm, 3.1mm, 0.17mm), size=(0.65mm, 3.6mm, 0.105mm))
  Q2_6 = box(corner=(12.65mm, 3.1mm, 0.17mm), size=(0.65mm, 3.6mm, 0.105mm))
  Q2_7 = box(corner=(11.347mm, 3.1mm, 0.17mm), size=(1.102mm, 3.6mm, 0.105mm))
  Q4_3 = box(corner=(15.2mm, 7.4mm, 0.17mm), size=(0.65mm, 3.6mm, 0.105mm))
  Q4_4 = box(corner=(14.35mm, 7.4mm, 0.17mm), size=(0.65mm, 3.6mm, 0.105mm))
  Q4_5 = box(corner=(13.5mm, 7.4mm, 0.17mm), size=(0.65mm, 3.6mm, 0.105mm))
  Q4_6 = box(corner=(12.65mm, 7.4mm, 0.17mm), size=(0.65mm, 3.6mm, 0.105mm))
  Q4_7 = box(corner=(11.347mm, 7.4mm, 0.17mm), size=(1.102mm, 3.6mm, 0.105mm))
  Q3_3 = box(corner=(31.65mm, 7.4mm, 0.17mm), size=(0.65mm, 3.6mm, 0.105mm))
  Q3_4 = box(corner=(32.5mm, 7.4mm, 0.17mm), size=(0.65mm, 3.6mm, 0.105mm))
  Q3_5 = box(corner=(33.35mm, 7.4mm, 0.17mm), size=(0.65mm, 3.6mm, 0.105mm))
  Q3_6 = box(corner=(34.2mm, 7.4mm, 0.17mm), size=(0.65mm, 3.6mm, 0.105mm))
  Q3_7 = box(corner=(35.051mm, 7.4mm, 0.17mm), size=(1.102mm, 3.6mm, 0.105mm))
  Q6_3 = box(corner=(-32.3mm, 3.1mm, 0.17mm), size=(0.65mm, 3.6mm, 0.105mm))
  Q6_4 = box(corner=(-33.15mm, 3.1mm, 0.17mm), size=(0.65mm, 3.6mm, 0.105mm))
  Q6_5 = box(corner=(-34mm, 3.1mm, 0.17mm), size=(0.65mm, 3.6mm, 0.105mm))
  Q6_6 = box(corner=(-34.85mm, 3.1mm, 0.17mm), size=(0.65mm, 3.6mm, 0.105mm))
  Q6_7 = box(corner=(-36.153mm, 3.1mm, 0.17mm), size=(1.102mm, 3.6mm, 0.105mm))
  Q7_3 = box(corner=(-15.85mm, 7.4mm, 0.17mm), size=(0.65mm, 3.6mm, 0.105mm))
  Q7_4 = box(corner=(-15mm, 7.4mm, 0.17mm), size=(0.65mm, 3.6mm, 0.105mm))
  Q7_5 = box(corner=(-14.15mm, 7.4mm, 0.17mm), size=(0.65mm, 3.6mm, 0.105mm))
  Q7_6 = box(corner=(-13.3mm, 7.4mm, 0.17mm), size=(0.65mm, 3.6mm, 0.105mm))
  Q7_7 = box(corner=(-12.449mm, 7.4mm, 0.17mm), size=(1.102mm, 3.6mm, 0.105mm))
  Q1_3 = box(corner=(31.65mm, 3.1mm, 0.17mm), size=(0.65mm, 3.6mm, 0.105mm))
  Q1_4 = box(corner=(32.5mm, 3.1mm, 0.17mm), size=(0.65mm, 3.6mm, 0.105mm))
  Q1_5 = box(corner=(33.35mm, 3.1mm, 0.17mm), size=(0.65mm, 3.6mm, 0.105mm))
  Q1_6 = box(corner=(34.2mm, 3.1mm, 0.17mm), size=(0.65mm, 3.6mm, 0.105mm))
  Q1_7 = box(corner=(35.051mm, 3.1mm, 0.17mm), size=(1.102mm, 3.6mm, 0.105mm))
  Q8_3 = box(corner=(-32.3mm, 7.4mm, 0.17mm), size=(0.65mm, 3.6mm, 0.105mm))
  Q8_4 = box(corner=(-33.15mm, 7.4mm, 0.17mm), size=(0.65mm, 3.6mm, 0.105mm))
  Q8_5 = box(corner=(-34mm, 7.4mm, 0.17mm), size=(0.65mm, 3.6mm, 0.105mm))
  Q8_6 = box(corner=(-34.85mm, 7.4mm, 0.17mm), size=(0.65mm, 3.6mm, 0.105mm))
  Q8_7 = box(corner=(-36.153mm, 7.4mm, 0.17mm), size=(1.102mm, 3.6mm, 0.105mm))
  Q5_3 = box(corner=(-15.85mm, 3.1mm, 0.17mm), size=(0.65mm, 3.6mm, 0.105mm))
  Q5_4 = box(corner=(-15mm, 3.1mm, 0.17mm), size=(0.65mm, 3.6mm, 0.105mm))
  Q5_5 = box(corner=(-14.15mm, 3.1mm, 0.17mm), size=(0.65mm, 3.6mm, 0.105mm))
  Q5_6 = box(corner=(-13.3mm, 3.1mm, 0.17mm), size=(0.65mm, 3.6mm, 0.105mm))
  Q5_7 = box(corner=(-12.449mm, 3.1mm, 0.17mm), size=(1.102mm, 3.6mm, 0.105mm))
  C46_1 = box(corner=(-37.975mm, 1.65mm, 0.17mm), size=(1.45mm, 1mm, 0.105mm))
  C46_2 = box(corner=(-37.975mm, -0.25mm, 0.17mm), size=(1.45mm, 1mm, 0.105mm))
  C12_1 = box(corner=(9.525mm, 1.65mm, 0.17mm), size=(1.45mm, 1mm, 0.105mm))
  C12_2 = box(corner=(9.525mm, -0.25mm, 0.17mm), size=(1.45mm, 1mm, 0.105mm))
  C11_1 = box(corner=(11.125mm, 1.65mm, 0.17mm), size=(1.45mm, 1mm, 0.105mm))
  C11_2 = box(corner=(11.125mm, -0.25mm, 0.17mm), size=(1.45mm, 1mm, 0.105mm))
  C5_1 = box(corner=(30.125mm, 1.65mm, 0.17mm), size=(1.45mm, 1mm, 0.105mm))
  C5_2 = box(corner=(30.125mm, -0.25mm, 0.17mm), size=(1.45mm, 1mm, 0.105mm))
  C45_1 = box(corner=(-36.375mm, 1.65mm, 0.17mm), size=(1.45mm, 1mm, 0.105mm))
  C45_2 = box(corner=(-36.375mm, -0.25mm, 0.17mm), size=(1.45mm, 1mm, 0.105mm))
  C4_1 = box(corner=(31.725mm, 1.65mm, 0.17mm), size=(1.45mm, 1mm, 0.105mm))
  C4_2 = box(corner=(31.725mm, -0.25mm, 0.17mm), size=(1.45mm, 1mm, 0.105mm))
  C10_1 = box(corner=(12.725mm, 1.65mm, 0.17mm), size=(1.45mm, 1mm, 0.105mm))
  C10_2 = box(corner=(12.725mm, -0.25mm, 0.17mm), size=(1.45mm, 1mm, 0.105mm))
  C44_1 = box(corner=(-34.775mm, 1.65mm, 0.17mm), size=(1.45mm, 1mm, 0.105mm))
  C44_2 = box(corner=(-34.775mm, -0.25mm, 0.17mm), size=(1.45mm, 1mm, 0.105mm))
  C39_1 = box(corner=(-17.375mm, 1.65mm, 0.17mm), size=(1.45mm, 1mm, 0.105mm))
  C39_2 = box(corner=(-17.375mm, -0.25mm, 0.17mm), size=(1.45mm, 1mm, 0.105mm))
  C7_1 = box(corner=(17.525mm, 1.65mm, 0.17mm), size=(1.45mm, 1mm, 0.105mm))
  C7_2 = box(corner=(17.525mm, -0.25mm, 0.17mm), size=(1.45mm, 1mm, 0.105mm))
  C1_1 = box(corner=(36.525mm, 1.65mm, 0.17mm), size=(1.45mm, 1mm, 0.105mm))
  C1_2 = box(corner=(36.525mm, -0.25mm, 0.17mm), size=(1.45mm, 1mm, 0.105mm))
  C3_1 = box(corner=(33.325mm, 1.65mm, 0.17mm), size=(1.45mm, 1mm, 0.105mm))
  C3_2 = box(corner=(33.325mm, -0.25mm, 0.17mm), size=(1.45mm, 1mm, 0.105mm))
  C36_1 = box(corner=(-12.575mm, 1.65mm, 0.17mm), size=(1.45mm, 1mm, 0.105mm))
  C36_2 = box(corner=(-12.575mm, -0.25mm, 0.17mm), size=(1.45mm, 1mm, 0.105mm))
  C8_1 = box(corner=(15.925mm, 1.65mm, 0.17mm), size=(1.45mm, 1mm, 0.105mm))
  C8_2 = box(corner=(15.925mm, -0.25mm, 0.17mm), size=(1.45mm, 1mm, 0.105mm))
  C40_1 = box(corner=(-18.975mm, 1.65mm, 0.17mm), size=(1.45mm, 1mm, 0.105mm))
  C40_2 = box(corner=(-18.975mm, -0.25mm, 0.17mm), size=(1.45mm, 1mm, 0.105mm))
  C35_1 = box(corner=(-10.975mm, 1.65mm, 0.17mm), size=(1.45mm, 1mm, 0.105mm))
  C35_2 = box(corner=(-10.975mm, -0.25mm, 0.17mm), size=(1.45mm, 1mm, 0.105mm))
  C6_1 = box(corner=(28.525mm, 1.65mm, 0.17mm), size=(1.45mm, 1mm, 0.105mm))
  C6_2 = box(corner=(28.525mm, -0.25mm, 0.17mm), size=(1.45mm, 1mm, 0.105mm))
  C9_1 = box(corner=(14.325mm, 1.65mm, 0.17mm), size=(1.45mm, 1mm, 0.105mm))
  C9_2 = box(corner=(14.325mm, -0.25mm, 0.17mm), size=(1.45mm, 1mm, 0.105mm))
  C43_1 = box(corner=(-33.175mm, 1.65mm, 0.17mm), size=(1.45mm, 1mm, 0.105mm))
  C43_2 = box(corner=(-33.175mm, -0.25mm, 0.17mm), size=(1.45mm, 1mm, 0.105mm))
  C2_1 = box(corner=(34.925mm, 1.65mm, 0.17mm), size=(1.45mm, 1mm, 0.105mm))
  C2_2 = box(corner=(34.925mm, -0.25mm, 0.17mm), size=(1.45mm, 1mm, 0.105mm))
  C41_1 = box(corner=(-29.975mm, 1.65mm, 0.17mm), size=(1.45mm, 1mm, 0.105mm))
  C41_2 = box(corner=(-29.975mm, -0.25mm, 0.17mm), size=(1.45mm, 1mm, 0.105mm))
  C37_1 = box(corner=(-14.175mm, 1.65mm, 0.17mm), size=(1.45mm, 1mm, 0.105mm))
  C37_2 = box(corner=(-14.175mm, -0.25mm, 0.17mm), size=(1.45mm, 1mm, 0.105mm))
  C38_1 = box(corner=(-15.775mm, 1.65mm, 0.17mm), size=(1.45mm, 1mm, 0.105mm))
  C38_2 = box(corner=(-15.775mm, -0.25mm, 0.17mm), size=(1.45mm, 1mm, 0.105mm))
  C42_1 = box(corner=(-31.575mm, 1.65mm, 0.17mm), size=(1.45mm, 1mm, 0.105mm))
  C42_2 = box(corner=(-31.575mm, -0.25mm, 0.17mm), size=(1.45mm, 1mm, 0.105mm))
  C27_1 = box(corner=(33.325mm, -0.25mm, -1.475mm), size=(1.45mm, 1mm, 0.105mm))
  C27_2 = box(corner=(33.325mm, 1.65mm, -1.475mm), size=(1.45mm, 1mm, 0.105mm))
  C34_1 = box(corner=(17.525mm, -0.25mm, -1.475mm), size=(1.45mm, 1mm, 0.105mm))
  C34_2 = box(corner=(17.525mm, 1.65mm, -1.475mm), size=(1.45mm, 1mm, 0.105mm))
  C32_1 = box(corner=(14.325mm, -0.25mm, -1.475mm), size=(1.45mm, 1mm, 0.105mm))
  C32_2 = box(corner=(14.325mm, 1.65mm, -1.475mm), size=(1.45mm, 1mm, 0.105mm))
  C65_1 = box(corner=(-34.775mm, -0.25mm, -1.475mm), size=(1.45mm, 1mm, 0.105mm))
  C65_2 = box(corner=(-34.775mm, 1.65mm, -1.475mm), size=(1.45mm, 1mm, 0.105mm))
  C61_1 = box(corner=(-14.175mm, -0.25mm, -1.475mm), size=(1.45mm, 1mm, 0.105mm))
  C61_2 = box(corner=(-14.175mm, 1.65mm, -1.475mm), size=(1.45mm, 1mm, 0.105mm))
  C29_1 = box(corner=(30.125mm, -0.25mm, -1.475mm), size=(1.45mm, 1mm, 0.105mm))
  C29_2 = box(corner=(30.125mm, 1.65mm, -1.475mm), size=(1.45mm, 1mm, 0.105mm))
  C63_1 = box(corner=(-17.375mm, -0.25mm, -1.475mm), size=(1.45mm, 1mm, 0.105mm))
  C63_2 = box(corner=(-17.375mm, 1.65mm, -1.475mm), size=(1.45mm, 1mm, 0.105mm))
  C33_1 = box(corner=(15.925mm, -0.25mm, -1.475mm), size=(1.45mm, 1mm, 0.105mm))
  C33_2 = box(corner=(15.925mm, 1.65mm, -1.475mm), size=(1.45mm, 1mm, 0.105mm))
  C31_1 = box(corner=(12.725mm, -0.25mm, -1.475mm), size=(1.45mm, 1mm, 0.105mm))
  C31_2 = box(corner=(12.725mm, 1.65mm, -1.475mm), size=(1.45mm, 1mm, 0.105mm))
  C28_1 = box(corner=(31.725mm, -0.25mm, -1.475mm), size=(1.45mm, 1mm, 0.105mm))
  C28_2 = box(corner=(31.725mm, 1.65mm, -1.475mm), size=(1.45mm, 1mm, 0.105mm))
  C64_1 = box(corner=(-18.975mm, -0.25mm, -1.475mm), size=(1.45mm, 1mm, 0.105mm))
  C64_2 = box(corner=(-18.975mm, 1.65mm, -1.475mm), size=(1.45mm, 1mm, 0.105mm))
  C62_1 = box(corner=(-15.775mm, -0.25mm, -1.475mm), size=(1.45mm, 1mm, 0.105mm))
  C62_2 = box(corner=(-15.775mm, 1.65mm, -1.475mm), size=(1.45mm, 1mm, 0.105mm))
  C66_1 = box(corner=(-33.175mm, -0.25mm, -1.475mm), size=(1.45mm, 1mm, 0.105mm))
  C66_2 = box(corner=(-33.175mm, 1.65mm, -1.475mm), size=(1.45mm, 1mm, 0.105mm))
  C68_1 = box(corner=(-29.975mm, -0.25mm, -1.475mm), size=(1.45mm, 1mm, 0.105mm))
  C68_2 = box(corner=(-29.975mm, 1.65mm, -1.475mm), size=(1.45mm, 1mm, 0.105mm))
  C67_1 = box(corner=(-31.575mm, -0.25mm, -1.475mm), size=(1.45mm, 1mm, 0.105mm))
  C67_2 = box(corner=(-31.575mm, 1.65mm, -1.475mm), size=(1.45mm, 1mm, 0.105mm))
  C30_1 = box(corner=(28.525mm, -0.25mm, -1.475mm), size=(1.45mm, 1mm, 0.105mm))
  C30_2 = box(corner=(28.525mm, 1.65mm, -1.475mm), size=(1.45mm, 1mm, 0.105mm))
  P27_AC1_L1.unite(P31_AC1_L3, P35_AC1_L4, V244_AC1, Q3_3, Q3_5, Q3_7, Q1_4, Q1_6)
  P27_AC1_L1.separate_bodies()
  P28_AC2_L1.unite(P32_AC2_L3, P36_AC2_L4, V243_AC2, V248_AC2, Q2_4, Q2_6, Q4_3, Q4_5, Q4_7)
  P28_AC2_L1.separate_bodies()
  P29_AC3_L1.unite(P33_AC3_L3, P37_AC3_L4, V245_AC3, Q7_3, Q7_5, Q7_7, Q5_4, Q5_6)
  P29_AC3_L1.separate_bodies()
  P0_DCN_L1.unite(P1_DCN_L1, P2_DCN_L1, P3_DCN_L1, P4_DCN_L1, P5_DCN_L1, P6_DCN_L1, P7_DCN_L1, P8_DCN_L1, P9_DCN_L2, P10_DCN_L4, P11_DCN_L4, P12_DCN_L4, P13_DCN_L4, P14_DCN_L4, P15_DCN_L4, P16_DCN_L4, P17_DCN_L4, V36_DCN, V37_DCN, V38_DCN, V39_DCN, V40_DCN, V41_DCN, V42_DCN, V43_DCN, V44_DCN, V45_DCN, V46_DCN, V47_DCN, V48_DCN, V49_DCN, V50_DCN, V51_DCN, V52_DCN, V53_DCN, V54_DCN, V55_DCN, V56_DCN, V57_DCN, V58_DCN, V59_DCN, V60_DCN, V61_DCN, V62_DCN, V63_DCN, V64_DCN, V65_DCN, V66_DCN, V67_DCN, V68_DCN, V69_DCN, V70_DCN, V71_DCN, V72_DCN, V73_DCN, V74_DCN, V75_DCN, V76_DCN, V77_DCN, V78_DCN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)
  P0_DCN_L1.separate_bodies()
  P30_AC4_L1.unite(P34_AC4_L3, P38_AC4_L4, V246_AC4, V247_AC4, Q6_4, Q6_6, Q8_3, Q8_5, Q8_7)
  P30_AC4_L1.separate_bodies()
  P18_DCP_L1.unite(P19_DCP_L1, P20_DCP_L1, P21_DCP_L1, P22_DCP_L3, P23_DCP_L4, P24_DCP_L4, P25_DCP_L4, P26_DCP_L4, V0_DCP, V1_DCP, V2_DCP, V3_DCP, V4_DCP, V5_DCP, V6_DCP, V7_DCP, V8_DCP, V9_DCP, V10_DCP, V11_DCP, V12_DCP, V13_DCP, V14_DCP, V15_DCP, V16_DCP, V17_DCP, V18_DCP, V19_DCP, V20_DCP, V21_DCP, V22_DCP, V23_DCP, V24_DCP, V25_DCP, V26_DCP, V27_DCP, V28_DCP, V29_DCP, V30_DCP, V31_DCP, V32_DCP, V33_DCP, V34_DCP, V35_DCP, Q2_3, Q2_5, Q2_7, Q6_3, Q6_5, Q6_7, Q1_3, Q1_5, Q1_7, Q5_3, Q5_5, Q5_7, C46_1, C12_1, C11_1, C5_1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)
  P18_DCP_L1.separate_bodies()
boundaries and excitations:
  AC1: SignalNet Objects=P27_AC1_L1
  AC2: SignalNet Objects=P28_AC2_L1
  AC3: SignalNet Objects=P29_AC3_L1
  DCN: SignalNet Objects=P0_DCN_L1
  AC4: SignalNet Objects=P30_AC4_L1
  DCP: SignalNet Objects=P18_DCP_L1
  CapN_2: Source Faces=P0_DCN_L1.face(at (10.25, 0.25, 0.275), at (11.85, 0.25, 0.275), at (13.45, 0.25, 0.275), at (18.25, 0.25, 0.275), at (16.65, 0.25, 0.275), at (15.05, 0.25, 0.275)) TerminalType=ConstantVoltage Net=DCN
  CapN_3: Source Faces=P0_DCN_L1.face(at (-16.65, 0.25, 0.275), at (-11.85, 0.25, 0.275), at (-18.25, 0.25, 0.275), at (-10.25, 0.25, 0.275), at (-13.45, 0.25, 0.275), at (-15.05, 0.25, 0.275)) TerminalType=ConstantVoltage Net=DCN
  CapN_4: Source Faces=P0_DCN_L1.face(at (-37.25, 0.25, 0.275), at (-35.65, 0.25, 0.275), at (-34.05, 0.25, 0.275), at (-32.45, 0.25, 0.275), at (-29.25, 0.25, 0.275), at (-30.85, 0.25, 0.275)) TerminalType=ConstantVoltage Net=DCN
  CapNb_1: Source Faces=P0_DCN_L1.face(at (34.05, 0.25, -1.475), at (30.85, 0.25, -1.475), at (32.45, 0.25, -1.475), at (29.25, 0.25, -1.475)) TerminalType=ConstantVoltage Net=DCN
  CapNb_2: Source Faces=P0_DCN_L1.face(at (18.25, 0.25, -1.475), at (15.05, 0.25, -1.475), at (16.65, 0.25, -1.475), at (13.45, 0.25, -1.475)) TerminalType=ConstantVoltage Net=DCN
  CapNb_3: Source Faces=P0_DCN_L1.face(at (-13.45, 0.25, -1.475), at (-16.65, 0.25, -1.475), at (-18.25, 0.25, -1.475), at (-15.05, 0.25, -1.475)) TerminalType=ConstantVoltage Net=DCN
  CapNb_4: Source Faces=P0_DCN_L1.face(at (-34.05, 0.25, -1.475), at (-32.45, 0.25, -1.475), at (-29.25, 0.25, -1.475), at (-30.85, 0.25, -1.475)) TerminalType=ConstantVoltage Net=DCN
  CapP_2: Source Faces=P18_DCP_L1.face(at (10.25, 2.15, 0.275), at (11.85, 2.15, 0.275), at (13.45, 2.15, 0.275), at (18.25, 2.15, 0.275), at (16.65, 2.15, 0.275), at (15.05, 2.15, 0.275)) TerminalType=ConstantVoltage Net=DCP
  CapP_3: Source Faces=P18_DCP_L1.face(at (-16.65, 2.15, 0.275), at (-11.85, 2.15, 0.275), at (-18.25, 2.15, 0.275), at (-10.25, 2.15, 0.275), at (-13.45, 2.15, 0.275), at (-15.05, 2.15, 0.275)) TerminalType=ConstantVoltage Net=DCP
  CapP_4: Source Faces=P18_DCP_L1.face(at (-37.25, 2.15, 0.275), at (-35.65, 2.15, 0.275), at (-34.05, 2.15, 0.275), at (-32.45, 2.15, 0.275), at (-29.25, 2.15, 0.275), at (-30.85, 2.15, 0.275)) TerminalType=ConstantVoltage Net=DCP
  CapPb_1: Source Faces=P18_DCP_L1.face(at (34.05, 2.15, -1.475), at (30.85, 2.15, -1.475), at (32.45, 2.15, -1.475), at (29.25, 2.15, -1.475)) TerminalType=ConstantVoltage Net=DCP
  CapPb_2: Source Faces=P18_DCP_L1.face(at (18.25, 2.15, -1.475), at (15.05, 2.15, -1.475), at (16.65, 2.15, -1.475), at (13.45, 2.15, -1.475)) TerminalType=ConstantVoltage Net=DCP
  CapPb_3: Source Faces=P18_DCP_L1.face(at (-13.45, 2.15, -1.475), at (-16.65, 2.15, -1.475), at (-18.25, 2.15, -1.475), at (-15.05, 2.15, -1.475)) TerminalType=ConstantVoltage Net=DCP
  CapPb_4: Source Faces=P18_DCP_L1.face(at (-34.05, 2.15, -1.475), at (-32.45, 2.15, -1.475), at (-29.25, 2.15, -1.475), at (-30.85, 2.15, -1.475)) TerminalType=ConstantVoltage Net=DCP
  QH_D_1: Source Faces=P18_DCP_L1.face(at (31.975, 4.9, 0.275), at (33.675, 4.9, 0.275), at (35.602, 4.9, 0.275)) TerminalType=ConstantVoltage Net=DCP
  QH_D_2: Source Faces=P18_DCP_L1.face(at (15.525, 4.9, 0.275), at (13.825, 4.9, 0.275), at (11.898, 4.9, 0.275)) TerminalType=ConstantVoltage Net=DCP
  QH_D_3: Source Faces=P18_DCP_L1.face(at (-15.525, 4.9, 0.275), at (-13.825, 4.9, 0.275), at (-11.898, 4.9, 0.275)) TerminalType=ConstantVoltage Net=DCP
  QH_D_4: Source Faces=P18_DCP_L1.face(at (-31.975, 4.9, 0.275), at (-33.675, 4.9, 0.275), at (-35.602, 4.9, 0.275)) TerminalType=ConstantVoltage Net=DCP
  QL_D_1: Source Faces=P27_AC1_L1.face(at (31.975, 9.2, 0.275), at (33.675, 9.2, 0.275), at (35.602, 9.2, 0.275)) TerminalType=ConstantVoltage Net=AC1
  QL_D_2: Source Faces=P28_AC2_L1.face(at (15.525, 9.2, 0.275), at (13.825, 9.2, 0.275), at (11.898, 9.2, 0.275)) TerminalType=ConstantVoltage Net=AC2
  QL_D_3: Source Faces=P29_AC3_L1.face(at (-15.525, 9.2, 0.275), at (-13.825, 9.2, 0.275), at (-11.898, 9.2, 0.275)) TerminalType=ConstantVoltage Net=AC3
  QL_D_4: Source Faces=P30_AC4_L1.face(at (-31.975, 9.2, 0.275), at (-33.675, 9.2, 0.275), at (-35.602, 9.2, 0.275)) TerminalType=ConstantVoltage Net=AC4
  QL_S_1: Source Faces=P0_DCN_L1.face(at (32.825, 9.2, 0.275), at (34.525, 9.2, 0.275)) TerminalType=ConstantVoltage Net=DCN
  QL_S_2: Source Faces=P0_DCN_L1.face(at (14.675, 9.2, 0.275), at (12.975, 9.2, 0.275)) TerminalType=ConstantVoltage Net=DCN
  QL_S_3: Source Faces=P0_DCN_L1.face(at (-14.675, 9.2, 0.275), at (-12.975, 9.2, 0.275)) TerminalType=ConstantVoltage Net=DCN
  QL_S_4: Source Faces=P0_DCN_L1.face(at (-32.825, 9.2, 0.275), at (-34.525, 9.2, 0.275)) TerminalType=ConstantVoltage Net=DCN
  CapN_1: Sink Faces=P0_DCN_L1.face(at (30.85, 0.25, 0.275), at (32.45, 0.25, 0.275), at (37.25, 0.25, 0.275), at (34.05, 0.25, 0.275), at (29.25, 0.25, 0.275), at (35.65, 0.25, 0.275)) TerminalType=ConstantVoltage Net=DCN
  CapP_1: Sink Faces=P18_DCP_L1.face(at (30.85, 2.15, 0.275), at (32.45, 2.15, 0.275), at (37.25, 2.15, 0.275), at (34.05, 2.15, 0.275), at (29.25, 2.15, 0.275), at (35.65, 2.15, 0.275)) TerminalType=ConstantVoltage Net=DCP
  QH_S_1: Sink Faces=P27_AC1_L1.face(at (32.825, 4.9, 0.275), at (34.525, 4.9, 0.275)) TerminalType=ConstantVoltage Net=AC1
  QH_S_2: Sink Faces=P28_AC2_L1.face(at (14.675, 4.9, 0.275), at (12.975, 4.9, 0.275)) TerminalType=ConstantVoltage Net=AC2
  QH_S_3: Sink Faces=P29_AC3_L1.face(at (-14.675, 4.9, 0.275), at (-12.975, 4.9, 0.275)) TerminalType=ConstantVoltage Net=AC3
  QH_S_4: Sink Faces=P30_AC4_L1.face(at (-32.825, 4.9, 0.275), at (-34.525, 4.9, 0.275)) TerminalType=ConstantVoltage Net=AC4
setups:
  Setup1: Matrix AdaptiveFreq=100MHz Cap{MaxPass=1 MinPass=1 MinConvPass=1 PerError=30 PerRefine=30 AutoIncreaseAccuracy AccuracyLevel=High Solver_Type=Iterative} DC{Cond{MaxPass=3 MinPass=1 MinConvPass=1 PerError=5 PerRefine=30} Mult{MaxPass=1 MinPass=1 MinConvPass=1 PerError=1 PerRefine=30} AccuracyLevel=Normal} AC{MaxPass=8 MinPass=2 MinConvPass=1 PerError=2 PerRefine=30 ACRLSolverType=ACA} ErrorValue=0.1
source amplitudes:
  AC1:QL_D_1, AC2:QL_D_2, AC3:QL_D_3, AC4:QL_D_4, DCN:CapN_3, DCN:CapN_4, DCN:CapNb_1..DCN:CapNb_4, DCN:QL_S_1..DCN:QL_S_4, DCP:CapP_2, DCP:CapP_3, DCP:CapP_4, DCP:CapPb_1..DCP:CapPb_4, DCP:QH_D_1..DCP:QH_D_4: AC R/L Fields 0A
  DCN:CapN_2: AC R/L Fields 1A
  AC1: CG Fields 1V 0deg
  AC2, AC3, AC4, DCN, DCP: CG Fields 0V 0deg
  AC1:QL_D_1, AC2:QL_D_2, AC3:QL_D_3, AC4:QL_D_4, DCN:CapN_3, DCN:CapN_4, DCN:CapNb_1..DCN:CapNb_4, DCN:QL_S_1..DCN:QL_S_4, DCP:CapP_2, DCP:CapP_3, DCP:CapP_4, DCP:CapPb_1..DCP:CapPb_4, DCP:QH_D_1..DCP:QH_D_4: DC R/L Fields 0A
  DCN:CapN_2: DC R/L Fields 1A
