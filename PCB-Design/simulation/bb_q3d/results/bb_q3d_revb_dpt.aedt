# Ansys Electronics Desktop project, version 2024.2
materials:
  vacuum: permittivity=1
  copper: permeability=0.999991 conductivity=58000000

design BB_PL_REVB_dpt (Q3D Extractor, model units mm)
options: SParamCalcMethod=EqTransLine Calculate_Lossy_Dielectrics
geometry:
  P0_DCN_L1 [copper] = polyline(z=0.17mm, xy in mm: (-28.6908, 12.9189) (-28.65, 20.101) (-28.7184, 20.1952) (-43.551, 20.2) (-43.6452, 20.1316) (-43.65, 12.999) (-43.5816, 12.9048) (-28.749, 12.9) (-28.6908, 12.9189), closed, covered)
  P0_DCN_L1.sweep_along_vector((0mm, 0mm, 0.07mm))
  P1_DCN_L1 = polyline(z=0.17mm, xy in mm: (-3.8908, 12.9189) (-3.85, 20.101) (-3.9184, 20.1952) (-18.751, 20.2) (-18.8452, 20.1316) (-18.85, 12.999) (-18.7816, 12.9048) (-3.949, 12.9) (-3.8908, 12.9189), closed, covered)
  P1_DCN_L1.sweep_along_vector((0mm, 0mm, 0.07mm))
  P2_DCN_L1 = polyline(z=0.17mm, xy in mm: (18.8092, 12.9189) (18.85, 20.101) (18.7816, 20.1952) (3.949, 20.2) (3.8548, 20.1316) (3.85, 12.999) (3.9184, 12.9048) (18.751, 12.9) (18.8092, 12.9189), closed, covered)
  P2_DCN_L1.sweep_along_vector((0mm, 0mm, 0.07mm))
  P3_DCN_L1 = polyline(z=0.17mm, xy in mm: (43.6092, 12.9189) (43.65, 20.101) (43.5816, 20.1952) (28.749, 20.2) (28.6548, 20.1316) (28.65, 12.999) (28.7184, 12.9048) (43.551, 12.9) (43.6092, 12.9189), closed, covered)
  P3_DCN_L1.sweep_along_vector((0mm, 0mm, 0.07mm))
  P4_DCN_L1 = polyline(z=0.17mm, xy in mm: (-7.75, -4.2) (39.651, -4.2) (39.75, -4.101) (39.75, 0.801) (39.651, 0.9) (-39.651, 0.9) (-39.75, 0.801) (-39.75, -4.101) (-39.651, -4.2) (-7.75, -4.2), closed, covered)
  P4_DCN_L1.sweep_along_vector((0mm, 0mm, 0.07mm))
  P5_DCN_L1 = polyline(z=0.17mm, xy in mm: (41.3621, -12.2) (41.0621, -11.9) (42.5621, -10.4) (42.35, -10.1879) (40.85, -11.6879) (40.3, -11.1379) (40.3, -11.05) (40.15, -10.9879) (40.0879, -11.05) (39.75, -11.05) (39.75, -8.3045) (39.651, -8.2055) (-39.651, -8.2055) (-39.75, -8.3045) (-39.75, -11.301) (-39.651, -11.4) (40.0879, -11.35) (41.15, -12.4121) (41.3621, -12.2), closed, covered)
  P5_DCN_L1.sweep_along_vector((0mm, 0mm, 0.07mm))
  P6_DCN_L2 = polyline(z=0mm, xy in mm: (39.75, 11.9) (43.951, 11.9) (44.0452, 11.9684) (44.0311, 20.5592) (28.6908, 20.5756) (28.65, 11.9) (28.3548, 11.8316) (28.35, 10) (27.149, 10) (27.0548, 9.9316) (27.05, 3.3) (20.45, 3.3) (20.45, 9.901) (20.351, 10) (19.15, 10) (19.15, 11.801) (19.0816, 11.8952) (18.85, 11.9) (18.8311, 20.5537) (6.4245, 20.6) (6.3255, 20.501) (6.3255, 2.7456) (6.5056, 2.32) (6.4254, 2.0466) (6.2101, 1.86) (5.7899, 1.86) (5.5746, 2.0466) (5.4944, 2.32) (5.6745, 2.7456) (5.6745, 20.501) (5.5755, 20.6) (-1.45, 20.6) (-1.45, 25.3227) (0.2092, 26.5049) (0.0351, 26.7492) (-1.648, 25.55) (-1.75, 25.55) (-1.8092, 25.4351) (-1.75, 25.352) (-1.75, 20.6) (-18.8092, 20.5756) (-18.85, 11.9) (-19.1452, 11.8316) (-19.15, 10) (-20.351, 10) (-20.4452, 9.9316) (-20.45, 3.3) (-27.05, 3.3) (-27.05, 9.901) (-27.149, 10) (-28.35, 10) (-28.35, 11.801) (-28.4184, 11.8952) (-28.65, 11.9) (-28.6689, 20.5537) (-43.951, 20.6) (-44.05, 20.501) (-44.0311, 11.9408) (-39.75, 11.9) (-39.75, -5.1627) (-39.6204, -5.2569) (-39.3601, -5.04) (-39.078, -4.9995) (-38.8189, -5.1179) (-38.5812, -5.5012) (-38.8189, -5.8821) (-39.078, -6.0005) (-39.3601, -5.96) (-39.6286, -5.7408) (-39.75, -5.8373) (-39.75, -11.201) (-39.651, -11.3) (-35.75, -11.3) (-35.7311, -12.1087) (-35.265, -12.2679) (-35.0273, -12.6512) (-35.265, -13.0321) (-35.7092, -13.1694) (-35.75, -13.2495) (-35.75, -23.301) (-35.651, -23.4) (-10.0101, -23.4) (-9.9159, -23.2704) (-10.4268, -22.7521) (-10.6603, -22.2672) (-10.7405, -21.735) (-10.6603, -21.2028) (-10.4268, -20.7179) (-10.0607, -20.3234) (-9.5946, -20.0543) (-9.0699, -19.9345) (-8.5332, -19.9747) (-8.0322, -20.1713) (-7.5161, -20.6264) (-7.2097, -21.2028) (-7.1295, -21.735) (-7.2097, -22.2672) (-7.4432, -22.7521) (-7.9531, -23.2676) (-7.8629, -23.4) (-4.0819, -23.3811) (-4.0459, -23.2704) (-4.5568, -22.7521) (-4.7903, -22.2672) (-4.8705, -21.735) (-4.7903, -21.2028) (-4.5568, -20.7179) (-4.1907, -20.3234) (-3.7246, -20.0543) (-3.1999, -19.9345) (-2.6632, -19.9747) (-2.1622, -20.1713) (-1.6461, -20.6264) (-1.3397, -21.2028) (-1.2595, -21.735) (-1.3397, -22.2672) (-1.5732, -22.7521) (-2.0831, -23.2676) (-1.9929, -23.4) (35.7092, -23.3811) (35.75, -13.2495) (35.6816, -13.1553) (35.265, -13.0321) (35.0273, -12.6488) (35.265, -12.2679) (35.7452, -12.0811) (35.75, -11.3) (39.651, -11.3) (39.75, -11.201) (39.75, -5.8373) (39.6204, -5.7431) (39.3601, -5.96) (39.078, -6.0005) (38.8189, -5.8821) (38.5812, -5.4988) (38.8189, -5.1179) (39.078, -4.9995) (39.3601, -5.04) (39.6286, -5.2592) (39.75, -5.1627) (39.75, 11.9) (39.75, 11.9), closed, covered)
  P6_DCN_L2_h0 = polyline(z=0mm, xy in mm: (18.2169, 10.0203) (18.0015, 10.1768) (17.9403, 10.5631) (18.0968, 10.7785) (18.4831, 10.8397) (18.6985, 10.6832) (18.7808, 10.43) (18.6985, 10.1768) (18.35, 9.9992) (18.2169, 10.0203), closed, covered)
  P6_DCN_L2_h1 = polyline(z=0mm, xy in mm: (17.5189, 8.9703) (17.3035, 9.1268) (17.2423, 9.5131) (17.3988, 9.7285) (17.7851, 9.7897) (18.0005, 9.6332) (18.0828, 9.38) (18.0005, 9.1268) (17.652, 8.9492) (17.5189, 8.9703), closed, covered)
  P6_DCN_L2_h2 = polyline(z=0mm, xy in mm: (18.2169, 5.7203) (17.9403, 5.9969) (17.9403, 6.2631) (18.1029, 6.5114) (17.8746, 6.7766) (17.7944, 7.05) (17.9689, 7.4321) (18.372, 7.5505) (18.7254, 7.3234) (18.8056, 7.05) (18.5573, 6.5391) (18.7597, 6.2631) (18.7597, 5.9969) (18.6032, 5.7815) (18.35, 5.6992) (18.2169, 5.7203), closed, covered)
  P6_DCN_L2_h3 = polyline(z=0mm, xy in mm: (17.5189, 4.6703) (17.3035, 4.8268) (17.2423, 5.2131) (17.3988, 5.4285) (17.7851, 5.4897) (18.0005, 5.3332) (18.0828, 5.08) (18.0005, 4.8268) (17.652, 4.6492) (17.5189, 4.6703), closed, covered)
  P6_DCN_L2_h4 = polyline(z=0mm, xy in mm: (11.7899, 2.04) (11.5148, 2.3575) (11.5148, 2.6425) (11.6689, 2.8821) (11.928, 3.0005) (12.2101, 2.96) (12.4276, 2.7997) (12.828, 3.0005) (13.1101, 2.96) (13.3276, 2.7997) (13.728, 3.0005) (14.0101, 2.96) (14.2276, 2.7997) (14.628, 3.0005) (14.9101, 2.96) (15.1276, 2.7997) (15.528, 3.0005) (15.8101, 2.96) (16.0276, 2.7997) (16.428, 3.0005) (16.7101, 2.96) (16.9276, 2.7997) (17.328, 3.0005) (17.6101, 2.96) (17.8276, 2.7997) (18.0899, 2.96) (18.372, 3.0005) (18.7254, 2.7734) (18.8056, 2.5) (18.7254, 2.2266) (18.372, 1.9995) (18.0899, 2.04) (17.8724, 2.2003) (17.472, 1.9995) (17.1899, 2.04) (16.9724, 2.2003) (16.572, 1.9995) (16.2899, 2.04) (16.0724, 2.2003) (15.672, 1.9995) (15.3899, 2.04) (15.1724, 2.2003) (14.772, 1.9995) (14.4899, 2.04) (14.2724, 2.2003) (13.872, 1.9995) (13.5899, 2.04) (13.3724, 2.2003) (12.972, 1.9995) (12.6899, 2.04) (12.4724, 2.2003) (12.2101, 2.04) (11.928, 1.9995) (11.7899, 2.04), closed, covered)
  P6_DCN_L2_h5 = polyline(z=0mm, xy in mm: (-7.3601, -5.96) (-7.6352, -5.6425) (-7.6352, -5.3575) (-7.3601, -5.04) (-6.9399, -5.04) (-6.6648, -5.3575) (-6.6648, -5.6425) (-6.9399, -5.96) (-7.222, -6.0005) (-7.3601, -5.96), closed, covered)
  P6_DCN_L2_h6 = polyline(z=0mm, xy in mm: (8.1399, -5.96) (7.8648, -5.6425) (7.8648, -5.3575) (8.1399, -5.04) (8.5601, -5.04) (8.7754, -5.2266) (8.9188, -5.5012) (8.6811, -5.8821) (8.278, -6.0005) (8.1399, -5.96), closed, covered)
  P6_DCN_L2_h7 = polyline(z=0mm, xy in mm: (-37.7102, 11.9425) (-37.4351, 12.26) (-37.0149, 12.26) (-36.7398, 11.9425) (-36.7398, 11.6575) (-37.0149, 11.34) (-37.297, 11.2995) (-37.6504, 11.5266) (-37.7163, 11.9) (-37.7102, 11.9425), closed, covered)
  P6_DCN_L2_h8 = polyline(z=0mm, xy in mm: (-10.7602, 11.9425) (-10.4851, 12.26) (-10.0649, 12.26) (-9.7898, 11.9425) (-9.7898, 11.6575) (-10.0649, 11.34) (-10.347, 11.2995) (-10.7004, 11.5266) (-10.7663, 11.9) (-10.7602, 11.9425), closed, covered)
  P6_DCN_L2_h9 = polyline(z=0mm, xy in mm: (10.7663, 11.9) (10.7004, 11.5266) (10.347, 11.2995) (10.0649, 11.34) (9.7898, 11.6575) (9.8496, 12.0734) (10.203, 12.3005) (10.6061, 12.1821) (10.7663, 11.9) (10.7663, 11.9), closed, covered)
  P6_DCN_L2_h10 = polyline(z=0mm, xy in mm: (36.7398, 11.9425) (37.0149, 12.26) (37.4351, 12.26) (37.7102, 11.9425) (37.7102, 11.6575) (37.4351, 11.34) (37.153, 11.2995) (36.7996, 11.5266) (36.7337, 11.9) (36.7398, 11.9425), closed, covered)
  P6_DCN_L2_h11 = polyline(z=0mm, xy in mm: (-29.5597, 10.5631) (-29.4032, 10.7785) (-29.0169, 10.8397) (-28.8015, 10.6832) (-28.7403, 10.2969) (-28.8968, 10.0815) (-29.15, 9.9992) (-29.4032, 10.0815) (-29.5808, 10.43) (-29.5597, 10.5631), closed, covered)
  P6_DCN_L2_h12 = polyline(z=0mm, xy in mm: (-30.2577, 9.5131) (-30.1012, 9.7285) (-29.7149, 9.7897) (-29.4995, 9.6332) (-29.4383, 9.2469) (-29.5948, 9.0315) (-29.848, 8.9492) (-30.1012, 9.0315) (-30.2788, 9.38) (-30.2577, 9.5131), closed, covered)
  P6_DCN_L2_h13 = polyline(z=0mm, xy in mm: (-18.0617, 9.1531) (-17.9052, 9.3685) (-17.5189, 9.4297) (-17.3035, 9.2732) (-17.2423, 8.8869) (-17.3988, 8.6715) (-17.652, 8.5892) (-17.9052, 8.6715) (-18.0828, 9.02) (-18.0617, 9.1531), closed, covered)
  P6_DCN_L2_h14 = polyline(z=0mm, xy in mm: (29.4383, 9.1531) (29.5948, 9.3685) (29.9811, 9.4297) (30.1965, 9.2732) (30.2577, 8.8869) (30.1012, 8.6715) (29.848, 8.5892) (29.5948, 8.6715) (29.4172, 9.02) (29.4383, 9.1531), closed, covered)
  P6_DCN_L2_h15 = polyline(z=0mm, xy in mm: (-29.6852, 7.1925) (-29.5311, 7.4321) (-29.272, 7.5505) (-28.9899, 7.51) (-28.7148, 7.1925) (-28.7148, 6.9075) (-28.9427, 6.5391) (-28.7403, 6.2631) (-28.7403, 5.9969) (-29.0169, 5.7203) (-29.2831, 5.7203) (-29.4985, 5.8768) (-29.5808, 6.13) (-29.4067, 6.5718) (-29.6254, 6.7766) (-29.7056, 7.05) (-29.6852, 7.1925), closed, covered)
  P6_DCN_L2_h16 = polyline(z=0mm, xy in mm: (-18.7852, 7.1925) (-18.5608, 7.4998) (-18.7597, 7.8369) (-18.6985, 8.2232) (-18.35, 8.4008) (-18.0968, 8.3185) (-17.9192, 7.97) (-18.1029, 7.5886) (-17.8148, 7.1925) (-17.8746, 6.7766) (-18.0899, 6.59) (-18.5101, 6.59) (-18.7254, 6.7766) (-18.8056, 7.05) (-18.7852, 7.1925), closed, covered)
  P6_DCN_L2_h17 = polyline(z=0mm, xy in mm: (28.7148, 7.1925) (28.9392, 7.4998) (28.7403, 7.8369) (28.8015, 8.2232) (29.15, 8.4008) (29.4032, 8.3185) (29.5808, 7.97) (29.3971, 7.5886) (29.6852, 7.1925) (29.6254, 6.7766) (29.4101, 6.59) (28.9899, 6.59) (28.7746, 6.7766) (28.6944, 7.05) (28.7148, 7.1925), closed, covered)
  P6_DCN_L2_h18 = polyline(z=0mm, xy in mm: (-30.2577, 5.2131) (-30.1012, 5.4285) (-29.7149, 5.4897) (-29.4995, 5.3332) (-29.4383, 4.9469) (-29.5948, 4.7315) (-29.848, 4.6492) (-30.1012, 4.7315) (-30.2788, 5.08) (-30.2577, 5.2131), closed, covered)
  P6_DCN_L2_h19 = polyline(z=0mm, xy in mm: (-18.0617, 4.8531) (-17.9052, 5.0685) (-17.5189, 5.1297) (-17.3035, 4.9732) (-17.2423, 4.5869) (-17.3988, 4.3715) (-17.652, 4.2892) (-17.9052, 4.3715) (-18.0828, 4.72) (-18.0617, 4.8531), closed, covered)
  P6_DCN_L2_h20 = polyline(z=0mm, xy in mm: (29.4383, 4.8531) (29.5948, 5.0685) (29.9811, 5.1297) (30.1965, 4.9732) (30.2577, 4.5869) (30.1012, 4.3715) (29.848, 4.2892) (29.5948, 4.3715) (29.4172, 4.72) (29.4383, 4.8531), closed, covered)
  P6_DCN_L2_h21 = polyline(z=0mm, xy in mm: (-18.7597, 3.8031) (-18.6032, 4.0185) (-18.2169, 4.0797) (-18.0015, 3.9232) (-17.9403, 3.5369) (-18.0968, 3.3215) (-18.35, 3.2392) (-18.6032, 3.3215) (-18.7808, 3.67) (-18.7597, 3.8031), closed, covered)
  P6_DCN_L2_h22 = polyline(z=0mm, xy in mm: (28.7403, 3.8031) (28.8968, 4.0185) (29.2831, 4.0797) (29.4985, 3.9232) (29.5597, 3.5369) (29.4032, 3.3215) (29.15, 3.2392) (28.8968, 3.3215) (28.7192, 3.67) (28.7403, 3.8031), closed, covered)
  P6_DCN_L2_h23 = polyline(z=0mm, xy in mm: (-35.9852, 2.6425) (-35.8311, 2.8821) (-35.572, 3.0005) (-35.2899, 2.96) (-35.0724, 2.7997) (-34.672, 3.0005) (-34.3899, 2.96) (-34.1724, 2.7997) (-33.772, 3.0005) (-33.4899, 2.96) (-33.2724, 2.7997) (-32.872, 3.0005) (-32.5899, 2.96) (-32.3724, 2.7997) (-31.972, 3.0005) (-31.6899, 2.96) (-31.4724, 2.7997) (-31.072, 3.0005) (-30.7899, 2.96) (-30.5724, 2.7997) (-30.172, 3.0005) (-29.8899, 2.96) (-29.6724, 2.7997) (-29.4101, 2.96) (-29.128, 3.0005) (-28.7746, 2.7734) (-28.6944, 2.5) (-28.7746, 2.2266) (-29.128, 1.9995) (-29.4101, 2.04) (-29.6276, 2.2003) (-30.028, 1.9995) (-30.3101, 2.04) (-30.5276, 2.2003) (-30.928, 1.9995) (-31.2101, 2.04) (-31.4276, 2.2003) (-31.828, 1.9995) (-32.1101, 2.04) (-32.3276, 2.2003) (-32.728, 1.9995) (-33.0101, 2.04) (-33.2276, 2.2003) (-33.628, 1.9995) (-33.9101, 2.04) (-34.1276, 2.2003) (-34.528, 1.9995) (-34.8101, 2.04) (-35.0276, 2.2003) (-35.2899, 2.04) (-35.572, 1.9995) (-35.9254, 2.2266) (-36.0056, 2.5) (-35.9852, 2.6425), closed, covered)
  P6_DCN_L2_h24 = polyline(z=0mm, xy in mm: (-18.7852, 2.6425) (-18.6311, 2.8821) (-18.372, 3.0005) (-18.0899, 2.96) (-17.8724, 2.7997) (-17.472, 3.0005) (-17.1899, 2.96) (-16.9724, 2.7997) (-16.572, 3.0005) (-16.2899, 2.96) (-16.0724, 2.7997) (-15.672, 3.0005) (-15.3899, 2.96) (-15.1724, 2.7997) (-14.772, 3.0005) (-14.4899, 2.96) (-14.2724, 2.7997) (-13.872, 3.0005) (-13.5899, 2.96) (-13.3724, 2.7997) (-12.972, 3.0005) (-12.6899, 2.96) (-12.4724, 2.7997) (-12.2101, 2.96) (-11.928, 3.0005) (-11.5746, 2.7734) (-11.4944, 2.5) (-11.5746, 2.2266) (-11.928, 1.9995) (-12.2101, 2.04) (-12.4276, 2.2003) (-12.828, 1.9995) (-13.1101, 2.04) (-13.3276, 2.2003) (-13.728, 1.9995) (-14.0101, 2.04) (-14.2276, 2.2003) (-14.628, 1.9995) (-14.9101, 2.04) (-15.1276, 2.2003) (-15.528, 1.9995) (-15.8101, 2.04) (-16.0276, 2.2003) (-16.428, 1.9995) (-16.7101, 2.04) (-16.9276, 2.2003) (-17.328, 1.9995) (-17.6101, 2.04) (-17.8276, 2.2003) (-18.0899, 2.04) (-18.372, 1.9995) (-18.7254, 2.2266) (-18.8056, 2.5) (-18.7852, 2.6425), closed, covered)
  P6_DCN_L2_h25 = polyline(z=0mm, xy in mm: (28.7148, 2.6425) (28.8689, 2.8821) (29.128, 3.0005) (29.4101, 2.96) (29.6276, 2.7997) (30.028, 3.0005) (30.3101, 2.96) (30.5276, 2.7997) (30.928, 3.0005) (31.2101, 2.96) (31.4276, 2.7997) (31.828, 3.0005) (32.1101, 2.96) (32.3276, 2.7997) (32.728, 3.0005) (33.0101, 2.96) (33.2276, 2.7997) (33.628, 3.0005) (33.9101, 2.96) (34.1276, 2.7997) (34.528, 3.0005) (34.8101, 2.96) (35.0276, 2.7997) (35.2899, 2.96) (35.572, 3.0005) (35.9254, 2.7734) (36.0056, 2.5) (35.9254, 2.2266) (35.572, 1.9995) (35.2899, 2.04) (35.0724, 2.2003) (34.672, 1.9995) (34.3899, 2.04) (34.1724, 2.2003) (33.772, 1.9995) (33.4899, 2.04) (33.2724, 2.2003) (32.872, 1.9995) (32.5899, 2.04) (32.3724, 2.2003) (31.972, 1.9995) (31.6899, 2.04) (31.4724, 2.2003) (31.072, 1.9995) (30.7899, 2.04) (30.5724, 2.2003) (30.172, 1.9995) (29.8899, 2.04) (29.6724, 2.2003) (29.4101, 2.04) (29.128, 1.9995) (28.7746, 2.2266) (28.6944, 2.5) (28.7148, 2.6425), closed, covered)
  P6_DCN_L2_h26 = polyline(z=0mm, xy in mm: (-37.3294, -5.4959) (-37.1119, -5.1179) (-36.7088, -4.9995) (-36.4496, -5.1179) (-36.212, -5.5012) (-36.4496, -5.8821) (-36.8527, -6.0005) (-37.1119, -5.8821) (-37.3496, -5.4988) (-37.3294, -5.4959), closed, covered)
  P6_DCN_L2_h27 = polyline(z=0mm, xy in mm: (-34.9602, -5.4959) (-34.7427, -5.1179) (-34.3396, -4.9995) (-34.0804, -5.1179) (-33.8427, -5.5012) (-34.0804, -5.8821) (-34.4835, -6.0005) (-34.7427, -5.8821) (-34.9804, -5.4988) (-34.9602, -5.4959), closed, covered)
  P6_DCN_L2_h28 = polyline(z=0mm, xy in mm: (-33.7756, -5.4959) (-33.558, -5.1179) (-33.155, -4.9995) (-32.8958, -5.1179) (-32.6581, -5.5012) (-32.8958, -5.8821) (-33.2989, -6.0005) (-33.558, -5.8821) (-33.7957, -5.4988) (-33.7756, -5.4959), closed, covered)
  P6_DCN_L2_h29 = polyline(z=0mm, xy in mm: (-31.4063, -5.4959) (-31.1888, -5.1179) (-30.7857, -4.9995) (-30.5266, -5.1179) (-30.2889, -5.5012) (-30.5266, -5.8821) (-30.9297, -6.0005) (-31.1888, -5.8821) (-31.4265, -5.4988) (-31.4063, -5.4959), closed, covered)
  P6_DCN_L2_h30 = polyline(z=0mm, xy in mm: (-29.0371, -5.4959) (-28.8196, -5.1179) (-28.4165, -4.9995) (-28.1573, -5.1179) (-27.9196, -5.5012) (-28.1573, -5.8821) (-28.5604, -6.0005) (-28.8196, -5.8821) (-29.0573, -5.4988) (-29.0371, -5.4959), closed, covered)
  P6_DCN_L2_h31 = polyline(z=0mm, xy in mm: (-27.8525, -5.4959) (-27.635, -5.1179) (-27.2319, -4.9995) (-26.9727, -5.1179) (-26.735, -5.5012) (-26.9727, -5.8821) (-27.3758, -6.0005) (-27.635, -5.8821) (-27.8727, -5.4988) (-27.8525, -5.4959), closed, covered)
  P6_DCN_L2_h32 = polyline(z=0mm, xy in mm: (-25.4832, -5.4959) (-25.2657, -5.1179) (-24.8627, -4.9995) (-24.6035, -5.1179) (-24.3658, -5.5012) (-24.6035, -5.8821) (-25.0066, -6.0005) (-25.2657, -5.8821) (-25.5034, -5.4988) (-25.4832, -5.4959), closed, covered)
  P6_DCN_L2_h33 = polyline(z=0mm, xy in mm: (-24.2986, -5.4959) (-24.0811, -5.1179) (-23.678, -4.9995) (-23.4189, -5.1179) (-23.1812, -5.5012) (-23.4189, -5.8821) (-23.822, -6.0005) (-24.0811, -5.8821) (-24.3188, -5.4988) (-24.2986, -5.4959), closed, covered)
  P6_DCN_L2_h34 = polyline(z=0mm, xy in mm: (-21.9294, -5.4959) (-21.7119, -5.1179) (-21.3088, -4.9995) (-21.0496, -5.1179) (-20.812, -5.5012) (-21.0496, -5.8821) (-21.4527, -6.0005) (-21.7119, -5.8821) (-21.9496, -5.4988) (-21.9294, -5.4959), closed, covered)
  P6_DCN_L2_h35 = polyline(z=0mm, xy in mm: (-19.5602, -5.4959) (-19.3427, -5.1179) (-18.9396, -4.9995) (-18.6804, -5.1179) (-18.4427, -5.5012) (-18.6804, -5.8821) (-19.0835, -6.0005) (-19.3427, -5.8821) (-19.5804, -5.4988) (-19.5602, -5.4959), closed, covered)
  P6_DCN_L2_h36 = polyline(z=0mm, xy in mm: (-18.3756, -5.4959) (-18.1581, -5.1179) (-17.755, -4.9995) (-17.4958, -5.1179) (-17.2581, -5.5012) (-17.4958, -5.8821) (-17.8989, -6.0005) (-18.1581, -5.8821) (-18.3957, -5.4988) (-18.3756, -5.4959), closed, covered)
  P6_DCN_L2_h37 = polyline(z=0mm, xy in mm: (-16.0063, -5.4959) (-15.7888, -5.1179) (-15.3857, -4.9995) (-15.1266, -5.1179) (-14.8889, -5.5012) (-15.1266, -5.8821) (-15.5297, -6.0005) (-15.7888, -5.8821) (-16.0265, -5.4988) (-16.0063, -5.4959), closed, covered)
  P6_DCN_L2_h38 = polyline(z=0mm, xy in mm: (-13.6371, -5.4959) (-13.4196, -5.1179) (-13.0165, -4.9995) (-12.7573, -5.1179) (-12.5196, -5.5012) (-12.7573, -5.8821) (-13.1604, -6.0005) (-13.4196, -5.8821) (-13.6573, -5.4988) (-13.6371, -5.4959), closed, covered)
  P6_DCN_L2_h39 = polyline(z=0mm, xy in mm: (-12.4525, -5.4959) (-12.235, -5.1179) (-11.8319, -4.9995) (-11.5727, -5.1179) (-11.335, -5.5012) (-11.5727, -5.8821) (-11.9758, -6.0005) (-12.235, -5.8821) (-12.4727, -5.4988) (-12.4525, -5.4959), closed, covered)
  P6_DCN_L2_h40 = polyline(z=0mm, xy in mm: (-10.0832, -5.4959) (-9.8657, -5.1179) (-9.4627, -4.9995) (-9.2035, -5.1179) (-8.9658, -5.5012) (-9.2035, -5.8821) (-9.6066, -6.0005) (-9.8657, -5.8821) (-10.1034, -5.4988) (-10.0832, -5.4959), closed, covered)
  P6_DCN_L2_h41 = polyline(z=0mm, xy in mm: (8.986, -5.4959) (9.2035, -5.1179) (9.6066, -4.9995) (9.8657, -5.1179) (10.1034, -5.5012) (9.8657, -5.8821) (9.4626, -6.0005) (9.2035, -5.8821) (8.9658, -5.4988) (8.986, -5.4959), closed, covered)
  P6_DCN_L2_h42 = polyline(z=0mm, xy in mm: (10.1706, -5.4959) (10.3881, -5.1179) (10.7912, -4.9995) (11.0504, -5.1179) (11.288, -5.5012) (11.0504, -5.8821) (10.6473, -6.0005) (10.3881, -5.8821) (10.1504, -5.4988) (10.1706, -5.4959), closed, covered)
  P6_DCN_L2_h43 = polyline(z=0mm, xy in mm: (12.5398, -5.4959) (12.7573, -5.1179) (13.1604, -4.9995) (13.4196, -5.1179) (13.6573, -5.5012) (13.4196, -5.8821) (13.0165, -6.0005) (12.7573, -5.8821) (12.5196, -5.4988) (12.5398, -5.4959), closed, covered)
  P6_DCN_L2_h44 = polyline(z=0mm, xy in mm: (13.7244, -5.4959) (13.9419, -5.1179) (14.345, -4.9995) (14.6042, -5.1179) (14.8419, -5.5012) (14.6042, -5.8821) (14.2011, -6.0005) (13.9419, -5.8821) (13.7043, -5.4988) (13.7244, -5.4959), closed, covered)
  P6_DCN_L2_h45 = polyline(z=0mm, xy in mm: (16.0937, -5.4959) (16.3112, -5.1179) (16.7143, -4.9995) (16.9734, -5.1179) (17.2111, -5.5012) (16.9734, -5.8821) (16.5703, -6.0005) (16.3112, -5.8821) (16.0735, -5.4988) (16.0937, -5.4959), closed, covered)
  P6_DCN_L2_h46 = polyline(z=0mm, xy in mm: (18.4629, -5.4959) (18.6804, -5.1179) (19.0835, -4.9995) (19.3427, -5.1179) (19.5804, -5.5012) (19.3427, -5.8821) (18.9396, -6.0005) (18.6804, -5.8821) (18.4427, -5.4988) (18.4629, -5.4959), closed, covered)
  P6_DCN_L2_h47 = polyline(z=0mm, xy in mm: (19.6475, -5.4959) (19.865, -5.1179) (20.2681, -4.9995) (20.5273, -5.1179) (20.765, -5.5012) (20.5273, -5.8821) (20.1242, -6.0005) (19.865, -5.8821) (19.6273, -5.4988) (19.6475, -5.4959), closed, covered)
  P6_DCN_L2_h48 = polyline(z=0mm, xy in mm: (22.0168, -5.4959) (22.2343, -5.1179) (22.6373, -4.9995) (22.8965, -5.1179) (23.1342, -5.5012) (22.8965, -5.8821) (22.4934, -6.0005) (22.2343, -5.8821) (21.9966, -5.4988) (22.0168, -5.4959), closed, covered)
  P6_DCN_L2_h49 = polyline(z=0mm, xy in mm: (24.386, -5.4959) (24.6035, -5.1179) (25.0066, -4.9995) (25.2657, -5.1179) (25.5034, -5.5012) (25.2657, -5.8821) (24.8627, -6.0005) (24.6035, -5.8821) (24.3658, -5.4988) (24.386, -5.4959), closed, covered)
  P6_DCN_L2_h50 = polyline(z=0mm, xy in mm: (25.5706, -5.4959) (25.7881, -5.1179) (26.1912, -4.9995) (26.4504, -5.1179) (26.688, -5.5012) (26.4504, -5.8821) (26.0473, -6.0005) (25.7881, -5.8821) (25.5504, -5.4988) (25.5706, -5.4959), closed, covered)
  P6_DCN_L2_h51 = polyline(z=0mm, xy in mm: (27.9398, -5.4959) (28.1573, -5.1179) (28.5604, -4.9995) (28.8196, -5.1179) (29.0573, -5.5012) (28.8196, -5.8821) (28.4165, -6.0005) (28.1573, -5.8821) (27.9196, -5.4988) (27.9398, -5.4959), closed, covered)
  P6_DCN_L2_h52 = polyline(z=0mm, xy in mm: (29.1244, -5.4959) (29.3419, -5.1179) (29.745, -4.9995) (30.0042, -5.1179) (30.2419, -5.5012) (30.0042, -5.8821) (29.6011, -6.0005) (29.3419, -5.8821) (29.1043, -5.4988) (29.1244, -5.4959), closed, covered)
  P6_DCN_L2_h53 = polyline(z=0mm, xy in mm: (31.4937, -5.4959) (31.7112, -5.1179) (32.1143, -4.9995) (32.3734, -5.1179) (32.6111, -5.5012) (32.3734, -5.8821) (31.9703, -6.0005) (31.7112, -5.8821) (31.4735, -5.4988) (31.4937, -5.4959), closed, covered)
  P6_DCN_L2_h54 = polyline(z=0mm, xy in mm: (33.8629, -5.4959) (34.0804, -5.1179) (34.4835, -4.9995) (34.7427, -5.1179) (34.9804, -5.5012) (34.7427, -5.8821) (34.3396, -6.0005) (34.0804, -5.8821) (33.8427, -5.4988) (33.8629, -5.4959), closed, covered)
  P6_DCN_L2_h55 = polyline(z=0mm, xy in mm: (35.0475, -5.4959) (35.265, -5.1179) (35.6681, -4.9995) (35.9273, -5.1179) (36.165, -5.5012) (35.9273, -5.8821) (35.5242, -6.0005) (35.265, -5.8821) (35.0273, -5.4988) (35.0475, -5.4959), closed, covered)
  P6_DCN_L2_h56 = polyline(z=0mm, xy in mm: (37.4168, -5.4959) (37.6343, -5.1179) (38.0373, -4.9995) (38.2965, -5.1179) (38.5342, -5.5012) (38.2965, -5.8821) (37.8934, -6.0005) (37.6343, -5.8821) (37.3966, -5.4988) (37.4168, -5.4959), closed, covered)
  P6_DCN_L2_h57 = polyline(z=0mm, xy in mm: (-38.514, -5.4959) (-38.2965, -5.1179) (-37.8934, -4.9995) (-37.6343, -5.1179) (-37.3966, -5.5012) (-37.6343, -5.8821) (-38.0373, -6.0005) (-38.2965, -5.8821) (-38.5342, -5.4988) (-38.514, -5.4959), closed, covered)
  P6_DCN_L2_h58 = polyline(z=0mm, xy in mm: (-36.1448, -5.4959) (-35.9273, -5.1179) (-35.5242, -4.9995) (-35.265, -5.1179) (-35.0273, -5.5012) (-35.265, -5.8821) (-35.6681, -6.0005) (-35.9273, -5.8821) (-36.165, -5.4988) (-36.1448, -5.4959), closed, covered)
  P6_DCN_L2_h59 = polyline(z=0mm, xy in mm: (-32.5909, -5.4959) (-32.3734, -5.1179) (-31.9703, -4.9995) (-31.7112, -5.1179) (-31.4735, -5.5012) (-31.7112, -5.8821) (-32.1143, -6.0005) (-32.3734, -5.8821) (-32.6111, -5.4988) (-32.5909, -5.4959), closed, covered)
  P6_DCN_L2_h60 = polyline(z=0mm, xy in mm: (-30.2217, -5.4959) (-30.0042, -5.1179) (-29.6011, -4.9995) (-29.3419, -5.1179) (-29.1043, -5.5012) (-29.3419, -5.8821) (-29.745, -6.0005) (-30.0042, -5.8821) (-30.2419, -5.4988) (-30.2217, -5.4959), closed, covered)
  P6_DCN_L2_h61 = polyline(z=0mm, xy in mm: (-26.6679, -5.4959) (-26.4504, -5.1179) (-26.0473, -4.9995) (-25.7881, -5.1179) (-25.5504, -5.5012) (-25.7881, -5.8821) (-26.1912, -6.0005) (-26.4504, -5.8821) (-26.688, -5.4988) (-26.6679, -5.4959), closed, covered)
  P6_DCN_L2_h62 = polyline(z=0mm, xy in mm: (-23.114, -5.4959) (-22.8965, -5.1179) (-22.4934, -4.9995) (-22.2343, -5.1179) (-21.9966, -5.5012) (-22.2343, -5.8821) (-22.6373, -6.0005) (-22.8965, -5.8821) (-23.1342, -5.4988) (-23.114, -5.4959), closed, covered)
  P6_DCN_L2_h63 = polyline(z=0mm, xy in mm: (-20.7448, -5.4959) (-20.5273, -5.1179) (-20.1242, -4.9995) (-19.865, -5.1179) (-19.6273, -5.5012) (-19.865, -5.8821) (-20.2681, -6.0005) (-20.5273, -5.8821) (-20.765, -5.4988) (-20.7448, -5.4959), closed, covered)
  P6_DCN_L2_h64 = polyline(z=0mm, xy in mm: (-17.1909, -5.4959) (-16.9734, -5.1179) (-16.5703, -4.9995) (-16.3112, -5.1179) (-16.0735, -5.5012) (-16.3112, -5.8821) (-16.7143, -6.0005) (-16.9734, -5.8821) (-17.2111, -5.4988) (-17.1909, -5.4959), closed, covered)
  P6_DCN_L2_h65 = polyline(z=0mm, xy in mm: (-14.8217, -5.4959) (-14.6042, -5.1179) (-14.2011, -4.9995) (-13.9419, -5.1179) (-13.7043, -5.5012) (-13.9419, -5.8821) (-14.345, -6.0005) (-14.6042, -5.8821) (-14.8419, -5.4988) (-14.8217, -5.4959), closed, covered)
  P6_DCN_L2_h66 = polyline(z=0mm, xy in mm: (-11.2679, -5.4959) (-11.0504, -5.1179) (-10.6473, -4.9995) (-10.3881, -5.1179) (-10.1504, -5.5012) (-10.3881, -5.8821) (-10.7912, -6.0005) (-11.0504, -5.8821) (-11.288, -5.4988) (-11.2679, -5.4959), closed, covered)
  P6_DCN_L2_h67 = polyline(z=0mm, xy in mm: (-8.8986, -5.4959) (-8.6811, -5.1179) (-8.422, -4.9995) (-8.0189, -5.1179) (-7.8381, -5.4948) (-8.0189, -5.8821) (-8.278, -6.0005) (-8.6811, -5.8821) (-8.9188, -5.4988) (-8.8986, -5.4959), closed, covered)
  P6_DCN_L2_h68 = polyline(z=0mm, xy in mm: (11.3552, -5.4959) (11.5727, -5.1179) (11.9758, -4.9995) (12.235, -5.1179) (12.4727, -5.5012) (12.235, -5.8821) (11.8319, -6.0005) (11.5727, -5.8821) (11.335, -5.4988) (11.3552, -5.4959), closed, covered)
  P6_DCN_L2_h69 = polyline(z=0mm, xy in mm: (14.9091, -5.4959) (15.1266, -5.1179) (15.5297, -4.9995) (15.7888, -5.1179) (16.0265, -5.5012) (15.7888, -5.8821) (15.3857, -6.0005) (15.1266, -5.8821) (14.8889, -5.4988) (14.9091, -5.4959), closed, covered)
  P6_DCN_L2_h70 = polyline(z=0mm, xy in mm: (17.2783, -5.4959) (17.4958, -5.1179) (17.8989, -4.9995) (18.1581, -5.1179) (18.3957, -5.5012) (18.1581, -5.8821) (17.755, -6.0005) (17.4958, -5.8821) (17.2581, -5.4988) (17.2783, -5.4959), closed, covered)
  P6_DCN_L2_h71 = polyline(z=0mm, xy in mm: (20.8321, -5.4959) (21.0496, -5.1179) (21.4527, -4.9995) (21.7119, -5.1179) (21.9496, -5.5012) (21.7119, -5.8821) (21.3088, -6.0005) (21.0496, -5.8821) (20.812, -5.4988) (20.8321, -5.4959), closed, covered)
  P6_DCN_L2_h72 = polyline(z=0mm, xy in mm: (23.2014, -5.4959) (23.4189, -5.1179) (23.822, -4.9995) (24.0811, -5.1179) (24.3188, -5.5012) (24.0811, -5.8821) (23.678, -6.0005) (23.4189, -5.8821) (23.1812, -5.4988) (23.2014, -5.4959), closed, covered)
  P6_DCN_L2_h73 = polyline(z=0mm, xy in mm: (26.7552, -5.4959) (26.9727, -5.1179) (27.3758, -4.9995) (27.635, -5.1179) (27.8727, -5.5012) (27.635, -5.8821) (27.2319, -6.0005) (26.9727, -5.8821) (26.735, -5.4988) (26.7552, -5.4959), closed, covered)
  P6_DCN_L2_h74 = polyline(z=0mm, xy in mm: (30.3091, -5.4959) (30.5266, -5.1179) (30.9297, -4.9995) (31.1888, -5.1179) (31.4265, -5.5012) (31.1888, -5.8821) (30.7857, -6.0005) (30.5266, -5.8821) (30.2889, -5.4988) (30.3091, -5.4959), closed, covered)
  P6_DCN_L2_h75 = polyline(z=0mm, xy in mm: (32.6783, -5.4959) (32.8958, -5.1179) (33.2989, -4.9995) (33.5581, -5.1179) (33.7957, -5.5012) (33.5581, -5.8821) (33.155, -6.0005) (32.8958, -5.8821) (32.6581, -5.4988) (32.6783, -5.4959), closed, covered)
  P6_DCN_L2_h76 = polyline(z=0mm, xy in mm: (36.2321, -5.4959) (36.4496, -5.1179) (36.8527, -4.9995) (37.1119, -5.1179) (37.3496, -5.5012) (37.1119, -5.8821) (36.7088, -6.0005) (36.4496, -5.8821) (36.212, -5.4988) (36.2321, -5.4959), closed, covered)
  P6_DCN_L2_h77 = polyline(z=0mm, xy in mm: (-2.852, -5.4747) (-2.6811, -5.1179) (-2.278, -4.9995) (-2.0189, -5.1179) (-1.8381, -5.4948) (-2.0189, -5.8821) (-2.278, -6.0005) (-2.6811, -5.8821) (-2.8619, -5.5052) (-2.852, -5.4747), closed, covered)
  P6_DCN_L2_h78 = polyline(z=0mm, xy in mm: (-6.452, -5.4747) (-6.2811, -5.1179) (-5.878, -4.9995) (-5.6189, -5.1179) (-5.4381, -5.4948) (-5.6189, -5.8821) (-5.878, -6.0005) (-6.2811, -5.8821) (-6.4619, -5.5052) (-6.452, -5.4747), closed, covered)
  P6_DCN_L2_h79 = polyline(z=0mm, xy in mm: (-5.252, -5.4747) (-5.0811, -5.1179) (-4.678, -4.9995) (-4.4189, -5.1179) (-4.2381, -5.4948) (-4.4189, -5.8821) (-4.678, -6.0005) (-5.0811, -5.8821) (-5.2619, -5.5052) (-5.252, -5.4747), closed, covered)
  P6_DCN_L2_h80 = polyline(z=0mm, xy in mm: (-4.052, -5.4747) (-3.8811, -5.1179) (-3.478, -4.9995) (-3.2189, -5.1179) (-3.0381, -5.4948) (-3.2189, -5.8821) (-3.478, -6.0005) (-3.8811, -5.8821) (-4.0619, -5.5052) (-4.052, -5.4747), closed, covered)
  P6_DCN_L2_h81 = polyline(z=0mm, xy in mm: (-1.652, -5.4747) (-1.4811, -5.1179) (-1.078, -4.9995) (-0.8189, -5.1179) (-0.6381, -5.4948) (-0.8189, -5.8821) (-1.078, -6.0005) (-1.4811, -5.8821) (-1.6619, -5.5052) (-1.652, -5.4747), closed, covered)
  P6_DCN_L2_h82 = polyline(z=0mm, xy in mm: (-0.452, -5.4747) (-0.2811, -5.1179) (0.122, -4.9995) (0.3811, -5.1179) (0.5619, -5.4948) (0.3811, -5.8821) (0.122, -6.0005) (-0.2811, -5.8821) (-0.4619, -5.5052) (-0.452, -5.4747), closed, covered)
  P6_DCN_L2_h83 = polyline(z=0mm, xy in mm: (0.748, -5.4747) (0.9189, -5.1179) (1.322, -4.9995) (1.5811, -5.1179) (1.7619, -5.4948) (1.5811, -5.8821) (1.322, -6.0005) (0.9189, -5.8821) (0.7381, -5.5052) (0.748, -5.4747), closed, covered)
  P6_DCN_L2_h84 = polyline(z=0mm, xy in mm: (1.948, -5.4747) (2.1189, -5.1179) (2.522, -4.9995) (2.7811, -5.1179) (2.9619, -5.4948) (2.7811, -5.8821) (2.522, -6.0005) (2.1189, -5.8821) (1.9381, -5.5052) (1.948, -5.4747), closed, covered)
  P6_DCN_L2_h85 = polyline(z=0mm, xy in mm: (3.148, -5.4747) (3.3189, -5.1179) (3.722, -4.9995) (3.9811, -5.1179) (4.1619, -5.4948) (3.9811, -5.8821) (3.722, -6.0005) (3.3189, -5.8821) (3.1381, -5.5052) (3.148, -5.4747), closed, covered)
  P6_DCN_L2_h86 = polyline(z=0mm, xy in mm: (4.348, -5.4747) (4.5189, -5.1179) (4.922, -4.9995) (5.1811, -5.1179) (5.3619, -5.4948) (5.1811, -5.8821) (4.922, -6.0005) (4.5189, -5.8821) (4.3381, -5.5052) (4.348, -5.4747), closed, covered)
  P6_DCN_L2_h87 = polyline(z=0mm, xy in mm: (5.548, -5.4747) (5.7189, -5.1179) (6.122, -4.9995) (6.4754, -5.2266) (6.5556, -5.5) (6.4754, -5.7734) (6.122, -6.0005) (5.7189, -5.8821) (5.5381, -5.5052) (5.548, -5.4747), closed, covered)
  P6_DCN_L2_h88 = polyline(z=0mm, xy in mm: (-34.9602, -12.6459) (-34.7427, -12.2679) (-34.3396, -12.1495) (-34.0804, -12.2679) (-33.8427, -12.6512) (-34.0804, -13.0321) (-34.4835, -13.1505) (-34.7427, -13.0321) (-34.9804, -12.6488) (-34.9602, -12.6459), closed, covered)
  P6_DCN_L2_h89 = polyline(z=0mm, xy in mm: (-33.7756, -12.6459) (-33.5581, -12.2679) (-33.155, -12.1495) (-32.8958, -12.2679) (-32.6581, -12.6512) (-32.8958, -13.0321) (-33.2989, -13.1505) (-33.558, -13.0321) (-33.7957, -12.6488) (-33.7756, -12.6459), closed, covered)
  P6_DCN_L2_h90 = polyline(z=0mm, xy in mm: (-31.4063, -12.6459) (-31.1888, -12.2679) (-30.7857, -12.1495) (-30.5266, -12.2679) (-30.2889, -12.6512) (-30.5266, -13.0321) (-30.9297, -13.1505) (-31.1888, -13.0321) (-31.4265, -12.6488) (-31.4063, -12.6459), closed, covered)
  P6_DCN_L2_h91 = polyline(z=0mm, xy in mm: (-29.0371, -12.6459) (-28.8196, -12.2679) (-28.4165, -12.1495) (-28.1573, -12.2679) (-27.9196, -12.6512) (-28.1573, -13.0321) (-28.5604, -13.1505) (-28.8196, -13.0321) (-29.0573, -12.6488) (-29.0371, -12.6459), closed, covered)
  P6_DCN_L2_h92 = polyline(z=0mm, xy in mm: (-27.8525, -12.6459) (-27.635, -12.2679) (-27.2319, -12.1495) (-26.9727, -12.2679) (-26.735, -12.6512) (-26.9727, -13.0321) (-27.3758, -13.1505) (-27.635, -13.0321) (-27.8727, -12.6488) (-27.8525, -12.6459), closed, covered)
  P6_DCN_L2_h93 = polyline(z=0mm, xy in mm: (-25.4832, -12.6459) (-25.2657, -12.2679) (-24.8627, -12.1495) (-24.6035, -12.2679) (-24.3658, -12.6512) (-24.6035, -13.0321) (-25.0066, -13.1505) (-25.2657, -13.0321) (-25.5034, -12.6488) (-25.4832, -12.6459), closed, covered)
  P6_DCN_L2_h94 = polyline(z=0mm, xy in mm: (-24.2986, -12.6459) (-24.0811, -12.2679) (-23.678, -12.1495) (-23.4189, -12.2679) (-23.1812, -12.6512) (-23.4189, -13.0321) (-23.822, -13.1505) (-24.0811, -13.0321) (-24.3188, -12.6488) (-24.2986, -12.6459), closed, covered)
  P6_DCN_L2_h95 = polyline(z=0mm, xy in mm: (-21.9294, -12.6459) (-21.7119, -12.2679) (-21.3088, -12.1495) (-21.0496, -12.2679) (-20.812, -12.6512) (-21.0496, -13.0321) (-21.4527, -13.1505) (-21.7119, -13.0321) (-21.9496, -12.6488) (-21.9294, -12.6459), closed, covered)
  P6_DCN_L2_h96 = polyline(z=0mm, xy in mm: (-19.5602, -12.6459) (-19.3427, -12.2679) (-18.9396, -12.1495) (-18.6804, -12.2679) (-18.4427, -12.6512) (-18.6804, -13.0321) (-19.0835, -13.1505) (-19.3427, -13.0321) (-19.5804, -12.6488) (-19.5602, -12.6459), closed, covered)
  P6_DCN_L2_h97 = polyline(z=0mm, xy in mm: (-18.3756, -12.6459) (-18.1581, -12.2679) (-17.755, -12.1495) (-17.4958, -12.2679) (-17.2581, -12.6512) (-17.4958, -13.0321) (-17.8989, -13.1505) (-18.1581, -13.0321) (-18.3957, -12.6488) (-18.3756, -12.6459), closed, covered)
  P6_DCN_L2_h98 = polyline(z=0mm, xy in mm: (-16.0063, -12.6459) (-15.7888, -12.2679) (-15.3857, -12.1495) (-15.1266, -12.2679) (-14.8889, -12.6512) (-15.1266, -13.0321) (-15.5297, -13.1505) (-15.7888, -13.0321) (-16.0265, -12.6488) (-16.0063, -12.6459), closed, covered)
  P6_DCN_L2_h99 = polyline(z=0mm, xy in mm: (-13.6371, -12.6459) (-13.4196, -12.2679) (-13.0165, -12.1495) (-12.7573, -12.2679) (-12.5196, -12.6512) (-12.7573, -13.0321) (-13.1604, -13.1505) (-13.4196, -13.0321) (-13.6573, -12.6488) (-13.6371, -12.6459), closed, covered)
  P6_DCN_L2_h100 = polyline(z=0mm, xy in mm: (-12.4525, -12.6459) (-12.235, -12.2679) (-11.8319, -12.1495) (-11.5727, -12.2679) (-11.335, -12.6512) (-11.5727, -13.0321) (-11.9758, -13.1505) (-12.235, -13.0321) (-12.4727, -12.6488) (-12.4525, -12.6459), closed, covered)
  P6_DCN_L2_h101 = polyline(z=0mm, xy in mm: (-10.0832, -12.6459) (-9.8657, -12.2679) (-9.4627, -12.1495) (-9.2035, -12.2679) (-8.9658, -12.6512) (-9.2035, -13.0321) (-9.6066, -13.1505) (-9.8657, -13.0321) (-10.1034, -12.6488) (-10.0832, -12.6459), closed, covered)
  P6_DCN_L2_h102 = polyline(z=0mm, xy in mm: (8.986, -12.6459) (9.2035, -12.2679) (9.6066, -12.1495) (9.8657, -12.2679) (10.1034, -12.6512) (9.8657, -13.0321) (9.4626, -13.1505) (9.2035, -13.0321) (8.9658, -12.6488) (8.986, -12.6459), closed, covered)
  P6_DCN_L2_h103 = polyline(z=0mm, xy in mm: (10.1706, -12.6459) (10.3881, -12.2679) (10.7912, -12.1495) (11.0504, -12.2679) (11.288, -12.6512) (11.0504, -13.0321) (10.6473, -13.1505) (10.3881, -13.0321) (10.1504, -12.6488) (10.1706, -12.6459), closed, covered)
  P6_DCN_L2_h104 = polyline(z=0mm, xy in mm: (12.5398, -12.6459) (12.7573, -12.2679) (13.1604, -12.1495) (13.4196, -12.2679) (13.6573, -12.6512) (13.4196, -13.0321) (13.0165, -13.1505) (12.7573, -13.0321) (12.5196, -12.6488) (12.5398, -12.6459), closed, covered)
  P6_DCN_L2_h105 = polyline(z=0mm, xy in mm: (13.7244, -12.6459) (13.9419, -12.2679) (14.345, -12.1495) (14.6042, -12.2679) (14.8419, -12.6512) (14.6042, -13.0321) (14.2011, -13.1505) (13.9419, -13.0321) (13.7043, -12.6488) (13.7244, -12.6459), closed, covered)
  P6_DCN_L2_h106 = polyline(z=0mm, xy in mm: (16.0937, -12.6459) (16.3112, -12.2679) (16.7143, -12.1495) (16.9734, -12.2679) (17.2111, -12.6512) (16.9734, -13.0321) (16.5703, -13.1505) (16.3112, -13.0321) (16.0735, -12.6488) (16.0937, -12.6459), closed, covered)
  P6_DCN_L2_h107 = polyline(z=0mm, xy in mm: (18.4629, -12.6459) (18.6804, -12.2679) (19.0835, -12.1495) (19.3427, -12.2679) (19.5804, -12.6512) (19.3427, -13.0321) (18.9396, -13.1505) (18.6804, -13.0321) (18.4427, -12.6488) (18.4629, -12.6459), closed, covered)
  P6_DCN_L2_h108 = polyline(z=0mm, xy in mm: (19.6475, -12.6459) (19.865, -12.2679) (20.2681, -12.1495) (20.5273, -12.2679) (20.765, -12.6512) (20.5273, -13.0321) (20.1242, -13.1505) (19.865, -13.0321) (19.6273, -12.6488) (19.6475, -12.6459), closed, covered)
  P6_DCN_L2_h109 = polyline(z=0mm, xy in mm: (22.0168, -12.6459) (22.2343, -12.2679) (22.6373, -12.1495) (22.8965, -12.2679) (23.1342, -12.6512) (22.8965, -13.0321) (22.4934, -13.1505) (22.2343, -13.0321) (21.9966, -12.6488) (22.0168, -12.6459), closed, covered)
  P6_DCN_L2_h110 = polyline(z=0mm, xy in mm: (24.386, -12.6459) (24.6035, -12.2679) (25.0066, -12.1495) (25.2657, -12.2679) (25.5034, -12.6512) (25.2657, -13.0321) (24.8627, -13.1505) (24.6035, -13.0321) (24.3658, -12.6488) (24.386, -12.6459), closed, covered)
  P6_DCN_L2_h111 = polyline(z=0mm, xy in mm: (25.5706, -12.6459) (25.7881, -12.2679) (26.1912, -12.1495) (26.4504, -12.2679) (26.688, -12.6512) (26.4504, -13.0321) (26.0473, -13.1505) (25.7881, -13.0321) (25.5504, -12.6488) (25.5706, -12.6459), closed, covered)
  P6_DCN_L2_h112 = polyline(z=0mm, xy in mm: (27.9398, -12.6459) (28.1573, -12.2679) (28.5604, -12.1495) (28.8196, -12.2679) (29.0573, -12.6512) (28.8196, -13.0321) (28.4165, -13.1505) (28.1573, -13.0321) (27.9196, -12.6488) (27.9398, -12.6459), closed, covered)
  P6_DCN_L2_h113 = polyline(z=0mm, xy in mm: (29.1244, -12.6459) (29.3419, -12.2679) (29.745, -12.1495) (30.0042, -12.2679) (30.2419, -12.6512) (30.0042, -13.0321) (29.6011, -13.1505) (29.3419, -13.0321) (29.1043, -12.6488) (29.1244, -12.6459), closed, covered)
  P6_DCN_L2_h114 = polyline(z=0mm, xy in mm: (31.4937, -12.6459) (31.7112, -12.2679) (32.1143, -12.1495) (32.3734, -12.2679) (32.6111, -12.6512) (32.3734, -13.0321) (31.9703, -13.1505) (31.7112, -13.0321) (31.4735, -12.6488) (31.4937, -12.6459), closed, covered)
  P6_DCN_L2_h115 = polyline(z=0mm, xy in mm: (33.8629, -12.6459) (34.0804, -12.2679) (34.4835, -12.1495) (34.7427, -12.2679) (34.9804, -12.6512) (34.7427, -13.0321) (34.3396, -13.1505) (34.0804, -13.0321) (33.8427, -12.6488) (33.8629, -12.6459), closed, covered)
  P6_DCN_L2_h116 = polyline(z=0mm, xy in mm: (-32.5909, -12.6459) (-32.3734, -12.2679) (-31.9703, -12.1495) (-31.7112, -12.2679) (-31.4735, -12.6512) (-31.7112, -13.0321) (-32.1143, -13.1505) (-32.3734, -13.0321) (-32.6111, -12.6488) (-32.5909, -12.6459), closed, covered)
  P6_DCN_L2_h117 = polyline(z=0mm, xy in mm: (-30.2217, -12.6459) (-30.0042, -12.2679) (-29.6011, -12.1495) (-29.3419, -12.2679) (-29.1043, -12.6512) (-29.3419, -13.0321) (-29.745, -13.1505) (-30.0042, -13.0321) (-30.2419, -12.6488) (-30.2217, -12.6459), closed, covered)
  P6_DCN_L2_h118 = polyline(z=0mm, xy in mm: (-26.6679, -12.6459) (-26.4504, -12.2679) (-26.0473, -12.1495) (-25.7881, -12.2679) (-25.5504, -12.6512) (-25.7881, -13.0321) (-26.1912, -13.1505) (-26.4504, -13.0321) (-26.688, -12.6488) (-26.6679, -12.6459), closed, covered)
  P6_DCN_L2_h119 = polyline(z=0mm, xy in mm: (-23.114, -12.6459) (-22.8965, -12.2679) (-22.4934, -12.1495) (-22.2343, -12.2679) (-21.9966, -12.6512) (-22.2343, -13.0321) (-22.6373, -13.1505) (-22.8965, -13.0321) (-23.1342, -12.6488) (-23.114, -12.6459), closed, covered)
  P6_DCN_L2_h120 = polyline(z=0mm, xy in mm: (-20.7448, -12.6459) (-20.5273, -12.2679) (-20.1242, -12.1495) (-19.865, -12.2679) (-19.6273, -12.6512) (-19.865, -13.0321) (-20.2681, -13.1505) (-20.5273, -13.0321) (-20.765, -12.6488) (-20.7448, -12.6459), closed, covered)
  P6_DCN_L2_h121 = polyline(z=0mm, xy in mm: (-17.1909, -12.6459) (-16.9734, -12.2679) (-16.5703, -12.1495) (-16.3112, -12.2679) (-16.0735, -12.6512) (-16.3112, -13.0321) (-16.7143, -13.1505) (-16.9734, -13.0321) (-17.2111, -12.6488) (-17.1909, -12.6459), closed, covered)
  P6_DCN_L2_h122 = polyline(z=0mm, xy in mm: (-14.8217, -12.6459) (-14.6042, -12.2679) (-14.2011, -12.1495) (-13.9419, -12.2679) (-13.7043, -12.6512) (-13.9419, -13.0321) (-14.345, -13.1505) (-14.6042, -13.0321) (-14.8419, -12.6488) (-14.8217, -12.6459), closed, covered)
  P6_DCN_L2_h123 = polyline(z=0mm, xy in mm: (-11.2679, -12.6459) (-11.0504, -12.2679) (-10.6473, -12.1495) (-10.3881, -12.2679) (-10.1504, -12.6512) (-10.3881, -13.0321) (-10.7912, -13.1505) (-11.0504, -13.0321) (-11.288, -12.6488) (-11.2679, -12.6459), closed, covered)
  P6_DCN_L2_h124 = polyline(z=0mm, xy in mm: (-8.8986, -12.6459) (-8.6811, -12.2679) (-8.422, -12.1495) (-8.0189, -12.2679) (-7.8381, -12.6448) (-8.0189, -13.0321) (-8.278, -13.1505) (-8.6811, -13.0321) (-8.9188, -12.6488) (-8.8986, -12.6459), closed, covered)
  P6_DCN_L2_h125 = polyline(z=0mm, xy in mm: (11.3552, -12.6459) (11.5727, -12.2679) (11.9758, -12.1495) (12.235, -12.2679) (12.4727, -12.6512) (12.235, -13.0321) (11.8319, -13.1505) (11.5727, -13.0321) (11.335, -12.6488) (11.3552, -12.6459), closed, covered)
  P6_DCN_L2_h126 = polyline(z=0mm, xy in mm: (14.9091, -12.6459) (15.1266, -12.2679) (15.5297, -12.1495) (15.7888, -12.2679) (16.0265, -12.6512) (15.7888, -13.0321) (15.3857, -13.1505) (15.1266, -13.0321) (14.8889, -12.6488) (14.9091, -12.6459), closed, covered)
  P6_DCN_L2_h127 = polyline(z=0mm, xy in mm: (17.2783, -12.6459) (17.4958, -12.2679) (17.8989, -12.1495) (18.1581, -12.2679) (18.3957, -12.6512) (18.1581, -13.0321) (17.755, -13.1505) (17.4958, -13.0321) (17.2581, -12.6488) (17.2783, -12.6459), closed, covered)
  P6_DCN_L2_h128 = polyline(z=0mm, xy in mm: (20.8321, -12.6459) (21.0496, -12.2679) (21.4527, -12.1495) (21.7119, -12.2679) (21.9496, -12.6512) (21.7119, -13.0321) (21.3088, -13.1505) (21.0496, -13.0321) (20.812, -12.6488) (20.8321, -12.6459), closed, covered)
  P6_DCN_L2_h129 = polyline(z=0mm, xy in mm: (23.2014, -12.6459) (23.4189, -12.2679) (23.822, -12.1495) (24.0811, -12.2679) (24.3188, -12.6512) (24.0811, -13.0321) (23.678, -13.1505) (23.4189, -13.0321) (23.1812, -12.6488) (23.2014, -12.6459), closed, covered)
  P6_DCN_L2_h130 = polyline(z=0mm, xy in mm: (26.7552, -12.6459) (26.9727, -12.2679) (27.3758, -12.1495) (27.635, -12.2679) (27.8727, -12.6512) (27.635, -13.0321) (27.2319, -13.1505) (26.9727, -13.0321) (26.735, -12.6488) (26.7552, -12.6459), closed, covered)
  P6_DCN_L2_h131 = polyline(z=0mm, xy in mm: (30.3091, -12.6459) (30.5266, -12.2679) (30.9297, -12.1495) (31.1888, -12.2679) (31.4265, -12.6512) (31.1888, -13.0321) (30.7857, -13.1505) (30.5266, -13.0321) (30.2889, -12.6488) (30.3091, -12.6459), closed, covered)
  P6_DCN_L2_h132 = polyline(z=0mm, xy in mm: (32.6783, -12.6459) (32.8958, -12.2679) (33.2989, -12.1495) (33.5581, -12.2679) (33.7957, -12.6512) (33.5581, -13.0321) (33.155, -13.1505) (32.8958, -13.0321) (32.6581, -12.6488) (32.6783, -12.6459), closed, covered)
  P6_DCN_L2_h133 = polyline(z=0mm, xy in mm: (7.8648, -12.5075) (8.1399, -12.19) (8.422, -12.1495) (8.6811, -12.2679) (8.9188, -12.6512) (8.6811, -13.0321) (8.278, -13.1505) (7.9246, -12.9234) (7.8444, -12.65) (7.8648, -12.5075), closed, covered)
  P6_DCN_L2_h134 = polyline(z=0mm, xy in mm: (-2.852, -12.6247) (-2.6811, -12.2679) (-2.278, -12.1495) (-2.0189, -12.2679) (-1.8381, -12.6448) (-2.0189, -13.0321) (-2.278, -13.1505) (-2.6811, -13.0321) (-2.8619, -12.6552) (-2.852, -12.6247), closed, covered)
  P6_DCN_L2_h135 = polyline(z=0mm, xy in mm: (-7.652, -12.6247) (-7.4811, -12.2679) (-7.078, -12.1495) (-6.8189, -12.2679) (-6.6381, -12.6448) (-6.8189, -13.0321) (-7.078, -13.1505) (-7.4811, -13.0321) (-7.6619, -12.6552) (-7.652, -12.6247), closed, covered)
  P6_DCN_L2_h136 = polyline(z=0mm, xy in mm: (-6.452, -12.6247) (-6.2811, -12.2679) (-5.878, -12.1495) (-5.6189, -12.2679) (-5.4381, -12.6448) (-5.6189, -13.0321) (-5.878, -13.1505) (-6.2811, -13.0321) (-6.4619, -12.6552) (-6.452, -12.6247), closed, covered)
  P6_DCN_L2_h137 = polyline(z=0mm, xy in mm: (-5.252, -12.6247) (-5.0811, -12.2679) (-4.678, -12.1495) (-4.4189, -12.2679) (-4.2381, -12.6448) (-4.4189, -13.0321) (-4.678, -13.1505) (-5.0811, -13.0321) (-5.2619, -12.6552) (-5.252, -12.6247), closed, covered)
  P6_DCN_L2_h138 = polyline(z=0mm, xy in mm: (-4.052, -12.6247) (-3.8811, -12.2679) (-3.478, -12.1495) (-3.2189, -12.2679) (-3.0381, -12.6448) (-3.2189, -13.0321) (-3.478, -13.1505) (-3.8811, -13.0321) (-4.0619, -12.6552) (-4.052, -12.6247), closed, covered)
  P6_DCN_L2_h139 = polyline(z=0mm, xy in mm: (-1.652, -12.6247) (-1.4811, -12.2679) (-1.078, -12.1495) (-0.8189, -12.2679) (-0.6381, -12.6448) (-0.8189, -13.0321) (-1.078, -13.1505) (-1.4811, -13.0321) (-1.6619, -12.6552) (-1.652, -12.6247), closed, covered)
  P6_DCN_L2_h140 = polyline(z=0mm, xy in mm: (-0.452, -12.6247) (-0.2811, -12.2679) (0.122, -12.1495) (0.3811, -12.2679) (0.5619, -12.6448) (0.3811, -13.0321) (0.122, -13.1505) (-0.2811, -13.0321) (-0.4619, -12.6552) (-0.452, -12.6247), closed, covered)
  P6_DCN_L2_h141 = polyline(z=0mm, xy in mm: (0.748, -12.6247) (0.9189, -12.2679) (1.322, -12.1495) (1.5811, -12.2679) (1.7619, -12.6448) (1.5811, -13.0321) (1.322, -13.1505) (0.9189, -13.0321) (0.7381, -12.6552) (0.748, -12.6247), closed, covered)
  P6_DCN_L2_h142 = polyline(z=0mm, xy in mm: (1.948, -12.6247) (2.1189, -12.2679) (2.522, -12.1495) (2.7811, -12.2679) (2.9619, -12.6448) (2.7811, -13.0321) (2.522, -13.1505) (2.1189, -13.0321) (1.9381, -12.6552) (1.948, -12.6247), closed, covered)
  P6_DCN_L2_h143 = polyline(z=0mm, xy in mm: (3.148, -12.6247) (3.3189, -12.2679) (3.722, -12.1495) (3.9811, -12.2679) (4.1619, -12.6448) (3.9811, -13.0321) (3.722, -13.1505) (3.3189, -13.0321) (3.1381, -12.6552) (3.148, -12.6247), closed, covered)
  P6_DCN_L2_h144 = polyline(z=0mm, xy in mm: (4.348, -12.6247) (4.5189, -12.2679) (4.922, -12.1495) (5.1811, -12.2679) (5.3619, -12.6448) (5.1811, -13.0321) (4.922, -13.1505) (4.5189, -13.0321) (4.3381, -12.6552) (4.348, -12.6247), closed, covered)
  P6_DCN_L2_h145 = polyline(z=0mm, xy in mm: (5.548, -12.6247) (5.7189, -12.2679) (6.122, -12.1495) (6.4754, -12.3766) (6.5556, -12.65) (6.4754, -12.9234) (6.122, -13.1505) (5.7189, -13.0321) (5.5381, -12.6552) (5.548, -12.6247), closed, covered)
  P6_DCN_L2_h146 = polyline(z=0mm, xy in mm: (-10.7204, -15.5959) (-10.4268, -14.8479) (-9.8378, -14.3013) (-9.3368, -14.1047) (-8.5332, -14.1047) (-8.0322, -14.3013) (-7.4432, -14.8479) (-7.1496, -15.5959) (-7.1496, -16.1341) (-7.4432, -16.8821) (-7.8093, -17.2766) (-8.5332, -17.6253) (-9.0699, -17.6655) (-9.8378, -17.4287) (-10.2586, -17.0931) (-10.6603, -16.3972) (-10.7405, -15.865) (-10.7204, -15.5959), closed, covered)
  P6_DCN_L2_h147 = polyline(z=0mm, xy in mm: (-4.8504, -15.5959) (-4.5568, -14.8479) (-3.9678, -14.3013) (-3.4668, -14.1047) (-2.6632, -14.1047) (-2.1622, -14.3013) (-1.5732, -14.8479) (-1.2796, -15.5959) (-1.2796, -16.1341) (-1.5732, -16.8821) (-1.9393, -17.2766) (-2.6632, -17.6253) (-3.1999, -17.6655) (-3.9678, -17.4287) (-4.3886, -17.0931) (-4.7903, -16.3972) (-4.8705, -15.865) (-4.8504, -15.5959), closed, covered)
  P6_DCN_L2.subtract(P6_DCN_L2_h0..P6_DCN_L2_h147)
  P6_DCN_L2.sweep_along_vector((0mm, 0mm, 0.07mm))
  P7_DCN_L4 = polyline(z=-1.44mm, xy in mm: (-28.4908, -1.1811) (-28.45, 0.851) (-28.5184, 0.9452) (-37.951, 0.95) (-38.0452, 0.8816) (-38.05, -1.101) (-37.9816, -1.1952) (-28.549, -1.2) (-28.4908, -1.1811), closed, covered)
  P7_DCN_L4.sweep_along_vector((0mm, 0mm, 0.07mm))
  P8_DCN_L4 = polyline(z=-1.44mm, xy in mm: (-9.4908, -1.1811) (-9.45, 0.851) (-9.5184, 0.9452) (-18.951, 0.95) (-19.0452, 0.8816) (-19.05, -1.101) (-18.9816, -1.1952) (-9.549, -1.2) (-9.4908, -1.1811), closed, covered)
  P8_DCN_L4.sweep_along_vector((0mm, 0mm, 0.07mm))
  P9_DCN_L4 = polyline(z=-1.44mm, xy in mm: (19.0092, -1.1811) (19.05, 0.851) (18.9816, 0.9452) (9.549, 0.95) (9.4548, 0.8816) (9.45, -1.101) (9.5184, -1.1952) (18.951, -1.2) (19.0092, -1.1811), closed, covered)
  P9_DCN_L4.sweep_along_vector((0mm, 0mm, 0.07mm))
  P10_DCN_L4 = polyline(z=-1.44mm, xy in mm: (38.0092, -1.1811) (38.05, 0.851) (37.9816, 0.9452) (28.549, 0.95) (28.4548, 0.8816) (28.45, -1.101) (28.5184, -1.1952) (37.951, -1.2) (38.0092, -1.1811), closed, covered)
  P10_DCN_L4.sweep_along_vector((0mm, 0mm, 0.07mm))
  P11_DCN_L4 = polyline(z=-1.44mm, xy in mm: (35.7092, -23.3811) (35.75, -16.699) (35.6816, -16.6048) (-1.3532, -16.6) (-1.5445, -16.8589) (-1.5445, -20.7411) (-1.3397, -21.2028) (-1.2595, -21.735) (-1.3397, -22.2672) (-1.5445, -22.7289) (-1.5526, -23.0183) (-1.75, -23.2621) (-1.6678, -23.3996) (35.651, -23.4) (35.7092, -23.3811), closed, covered)
  P11_DCN_L4.sweep_along_vector((0mm, 0mm, 0.07mm))
  P12_DCP_L1 [copper] = polyline(z=0.17mm, xy in mm: (-28.7908, 1.5189) (-28.75, 4.501) (-28.8184, 4.5952) (-30.1057, 4.5811) (-30.1495, 3.1377) (-30.2785, 2.9494) (-30.4106, 2.8995) (-31.3854, 2.8995) (-31.5996, 3.0315) (-31.6495, 4.501) (-31.7179, 4.5952) (-32.2005, 4.6) (-32.2947, 4.5316) (-32.2995, 3.1388) (-32.3736, 2.9736) (-32.5389, 2.8995) (-33.1886, 2.9149) (-33.3351, 3.0614) (-33.3505, 4.501) (-33.4189, 4.5952) (-33.9005, 4.6) (-33.9947, 4.5316) (-33.9995, 3.1388) (-34.0736, 2.9736) (-34.2389, 2.8995) (-34.8886, 2.9149) (-35.0351, 3.0614) (-35.0505, 4.501) (-35.1189, 4.5952) (-37.651, 4.6) (-37.7452, 4.5316) (-37.75, 1.599) (-37.6816, 1.5048) (-28.849, 1.5) (-28.7908, 1.5189), closed, covered)
  P12_DCP_L1.sweep_along_vector((0mm, 0mm, 0.07mm))
  P13_DCP_L1 = polyline(z=0.17mm, xy in mm: (-9.7908, 1.5189) (-9.75, 4.501) (-9.8184, 4.5952) (-12.4087, 4.5811) (-12.4495, 3.1388) (-12.5236, 2.9736) (-12.6889, 2.8995) (-13.3386, 2.9149) (-13.4851, 3.0614) (-13.5005, 4.501) (-13.5995, 4.6) (-14.0505, 4.6) (-14.1447, 4.5316) (-14.1495, 3.1388) (-14.3114, 2.9149) (-14.9612, 2.8995) (-15.1851, 3.0614) (-15.2005, 4.501) (-15.2995, 4.6) (-15.7515, 4.6) (-15.8457, 4.5316) (-15.9029, 4.3191) (-15.8535, 3.1377) (-16.0887, 2.9025) (-17.1153, 2.9025) (-17.3036, 3.0315) (-17.3724, 3.2787) (-17.4525, 3.3195) (-18.0769, 3.3195) (-18.35, 3.2392) (-18.651, 3.3195) (-18.7452, 3.2511) (-18.75, 1.599) (-18.6816, 1.5048) (-9.849, 1.5) (-9.7908, 1.5189), closed, covered)
  P13_DCP_L1.sweep_along_vector((0mm, 0mm, 0.07mm))
  P14_DCP_L1 = polyline(z=0.17mm, xy in mm: (18.7092, 1.5189) (18.75, 4.501) (18.6816, 4.5952) (17.3943, 4.5811) (17.3505, 3.1377) (17.2215, 2.9494) (17.0894, 2.8995) (16.1146, 2.8995) (15.9004, 3.0315) (15.8505, 4.501) (15.7821, 4.5952) (15.2995, 4.6) (15.2053, 4.5316) (15.2005, 3.1388) (15.1264, 2.9736) (14.9611, 2.8995) (14.3114, 2.9149) (14.1649, 3.0614) (14.1495, 4.501) (14.0811, 4.5952) (13.5995, 4.6) (13.5053, 4.5316) (13.5005, 3.1388) (13.4264, 2.9736) (13.2611, 2.8995) (12.6114, 2.9149) (12.4649, 3.0614) (12.4495, 4.501) (12.3811, 4.5952) (9.849, 4.6) (9.7548, 4.5316) (9.75, 1.599) (9.8184, 1.5048) (18.651, 1.5) (18.7092, 1.5189), closed, covered)
  P14_DCP_L1.sweep_along_vector((0mm, 0mm, 0.07mm))
  P15_DCP_L1 = polyline(z=0.17mm, xy in mm: (37.7092, 1.5189) (37.75, 4.501) (37.6816, 4.5952) (35.0913, 4.5811) (35.0505, 3.1388) (34.9764, 2.9736) (34.8111, 2.8995) (34.1614, 2.9149) (34.0149, 3.0614) (33.9995, 4.501) (33.9005, 4.6) (33.4495, 4.6) (33.3553, 4.5316) (33.3505, 3.1388) (33.1886, 2.9149) (32.5388, 2.8995) (32.3149, 3.0614) (32.2995, 4.501) (32.2005, 4.6) (31.7485, 4.6) (31.6543, 4.5316) (31.5971, 4.3191) (31.6465, 3.1377) (31.4113, 2.9025) (30.3847, 2.9025) (30.1964, 3.0315) (30.1276, 3.2787) (30.0475, 3.3195) (29.4231, 3.3195) (29.15, 3.2392) (28.849, 3.3195) (28.7548, 3.2511) (28.75, 1.599) (28.8184, 1.5048) (37.651, 1.5) (37.7092, 1.5189), closed, covered)
  P15_DCP_L1.sweep_along_vector((0mm, 0mm, 0.07mm))
  P16_DCP_L1 = polyline(z=0.17mm, xy in mm: (-7.75, -7.9972) (39.651, -8) (39.75, -7.901) (39.75, -7.25) (42.3, -7.25) (42.3, -6.95) (39.75, -6.95) (39.75, -4.899) (39.651, -4.8) (-39.651, -4.8) (-39.75, -4.899) (-39.75, -7.901) (-39.651, -8) (-7.75, -8) (-7.75, -7.9972), closed, covered)
  P16_DCP_L1.sweep_along_vector((0mm, 0mm, 0.07mm))
  P17_DCP_L1 = polyline(z=0.17mm, xy in mm: (35.75, -16) (39.7092, -15.9811) (39.75, -12.099) (39.651, -12) (-39.651, -12) (-39.75, -12.099) (-39.7311, -15.9592) (-35.75, -16) (-35.75, -23.301) (-35.651, -23.4) (1.9899, -23.4) (2.0841, -23.2704) (1.5732, -22.7521) (1.3397, -22.2672) (1.2595, -21.735) (1.3397, -21.2028) (1.5732, -20.7179) (1.9393, -20.3234) (2.4054, -20.0543) (2.9301, -19.9345) (3.4668, -19.9747) (3.9678, -20.1713) (4.4839, -20.6264) (4.7903, -21.2028) (4.8705, -21.735) (4.7903, -22.2672) (4.5568, -22.7521) (4.0469, -23.2676) (4.1371, -23.4) (7.9181, -23.3811) (7.9541, -23.2704) (7.4432, -22.7521) (7.2097, -22.2672) (7.1295, -21.735) (7.2097, -21.2028) (7.4432, -20.7179) (7.8093, -20.3234) (8.2754, -20.0543) (8.8001, -19.9345) (9.3368, -19.9747) (9.8378, -20.1713) (10.3539, -20.6264) (10.6603, -21.2028) (10.7405, -21.735) (10.6603, -22.2672) (10.4268, -22.7521) (9.9169, -23.2676) (10.0071, -23.4) (35.651, -23.4) (35.75, -23.301) (35.75, -16) (35.75, -16), closed, covered)
  P17_DCP_L1_h0 = polyline(z=0.17mm, xy in mm: (1.2696, -16) (1.3397, -15.3328) (1.7414, -14.6369) (2.1622, -14.3013) (2.9301, -14.0645) (3.4668, -14.1047) (4.1907, -14.4534) (4.5568, -14.8479) (4.8504, -15.5959) (4.7903, -16.3972) (4.3886, -17.0931) (3.9678, -17.4287) (3.1999, -17.6655) (2.6632, -17.6253) (1.9393, -17.2766) (1.4383, -16.6484) (1.2696, -16) (1.2696, -16), closed, covered)
  P17_DCP_L1_h1 = polyline(z=0.17mm, xy in mm: (7.1295, -15.865) (7.2097, -15.3328) (7.6114, -14.6369) (8.0322, -14.3013) (8.8001, -14.0645) (9.5946, -14.1843) (10.2586, -14.6369) (10.6603, -15.3328) (10.7405, -15.865) (10.6603, -16.3972) (10.2586, -17.0931) (9.8378, -17.4287) (9.0699, -17.6655) (8.5332, -17.6253) (7.8093, -17.2766) (7.3083, -16.6484) (7.1396, -16) (7.1295, -15.865), closed, covered)
  P17_DCP_L1.subtract(P17_DCP_L1_h0, P17_DCP_L1_h1)
  P17_DCP_L1.sweep_along_vector((0mm, 0mm, 0.07mm))
  P18_DCP_L3 = polyline(z=-1.27mm, xy in mm: (35.75, -13.4) (39.651, -13.4) (39.7452, -13.3316) (39.7311, -11.0291) (39.6204, -10.9931) (39.3601, -11.21) (39.078, -11.2505) (38.8189, -11.1321) (38.5812, -10.7488) (38.8189, -10.3679) (39.078, -10.2495) (39.3601, -10.29) (39.6286, -10.5092) (39.75, -10.4127) (39.75, -0.8373) (39.6204, -0.7431) (39.3601, -0.96) (39.078, -1.0005) (38.8189, -0.8821) (38.5812, -0.4988) (38.8189, -0.1179) (39.078, 0.0005) (39.3601, -0.04) (39.6286, -0.2592) (39.75, -0.1627) (39.75, 4.501) (39.6816, 4.5952) (30.3251, 4.6) (30.1012, 4.3715) (29.848, 4.2892) (29.5948, 4.3715) (29.3709, 4.6) (24.1975, 4.6) (23.822, 4.3995) (23.5399, 4.44) (23.3025, 4.6) (7.3293, 4.6) (7.2351, 4.4704) (7.4852, 4.1425) (7.4852, 3.8575) (7.3311, 3.6179) (7.072, 3.4995) (6.7899, 3.54) (6.5148, 3.8575) (6.5148, 4.1425) (6.763, 4.4651) (6.6707, 4.6) (-17.1749, 4.6) (-17.3988, 4.3715) (-17.652, 4.2892) (-17.9052, 4.3715) (-18.1291, 4.6) (-23.3025, 4.6) (-23.678, 4.3995) (-23.9601, 4.44) (-24.1975, 4.6) (-39.651, 4.6) (-39.7452, 4.5316) (-39.75, -0.1627) (-39.6204, -0.2569) (-39.3601, -0.04) (-39.078, 0.0005) (-38.8189, -0.1179) (-38.5812, -0.5012) (-38.8189, -0.8821) (-39.078, -1.0005) (-39.3601, -0.96) (-39.6286, -0.7408) (-39.75, -0.8373) (-39.75, -10.4127) (-39.6204, -10.5069) (-39.3601, -10.29) (-39.078, -10.2495) (-38.8189, -10.3679) (-38.5812, -10.7512) (-38.8189, -11.1321) (-39.078, -11.2505) (-39.3601, -11.21) (-39.6286, -10.9908) (-39.7358, -11.0362) (-39.75, -13.301) (-39.651, -13.4) (-35.75, -13.4) (-35.75, -23.301) (-35.6816, -23.3952) (1.9899, -23.4) (2.0841, -23.2704) (1.5732, -22.7521) (1.3397, -22.2672) (1.2595, -21.735) (1.3397, -21.2028) (1.7414, -20.5069) (2.1622, -20.1713) (2.6632, -19.9747) (3.1999, -19.9345) (3.7246, -20.0543) (4.1907, -20.3234) (4.5568, -20.7179) (4.7903, -21.2028) (4.8705, -21.735) (4.7903, -22.2672) (4.5568, -22.7521) (4.0469, -23.2676) (4.0795, -23.3793) (7.8599, -23.4) (7.9541, -23.2704) (7.4432, -22.7521) (7.2097, -22.2672) (7.1295, -21.735) (7.2097, -21.2028) (7.6114, -20.5069) (8.0322, -20.1713) (8.5332, -19.9747) (9.0699, -19.9345) (9.5946, -20.0543) (10.0607, -20.3234) (10.4268, -20.7179) (10.6603, -21.2028) (10.7405, -21.735) (10.6603, -22.2672) (10.4268, -22.7521) (9.9169, -23.2676) (10.0071, -23.4) (35.651, -23.4) (35.75, -23.301) (35.75, -13.4) (35.75, -13.4), closed, covered)
  P18_DCP_L3_h0 = polyline(z=-1.27mm, xy in mm: (29.0169, 3.2603) (28.8015, 3.4168) (28.7403, 3.8031) (28.8968, 4.0185) (29.2831, 4.0797) (29.4985, 3.9232) (29.5808, 3.67) (29.4985, 3.4168) (29.15, 3.2392) (29.0169, 3.2603), closed, covered)
  P18_DCP_L3_h1 = polyline(z=-1.27mm, xy in mm: (5.7899, 1.86) (5.5148, 2.1775) (5.5148, 2.4625) (5.7899, 2.78) (6.2101, 2.78) (6.4852, 2.4625) (6.4852, 2.1775) (6.2101, 1.86) (5.928, 1.8195) (5.7899, 1.86), closed, covered)
  P18_DCP_L3_h2 = polyline(z=-1.27mm, xy in mm: (-7.3601, -0.96) (-7.6352, -0.6425) (-7.6352, -0.3575) (-7.3601, -0.04) (-6.9399, -0.04) (-6.6648, -0.3575) (-6.6648, -0.6425) (-6.9399, -0.96) (-7.222, -1.0005) (-7.3601, -0.96), closed, covered)
  P18_DCP_L3_h3 = polyline(z=-1.27mm, xy in mm: (8.1399, -0.96) (7.8648, -0.6425) (7.8648, -0.3575) (8.1399, -0.04) (8.5601, -0.04) (8.7754, -0.2266) (8.9188, -0.5012) (8.6811, -0.8821) (8.278, -1.0005) (8.1399, -0.96), closed, covered)
  P18_DCP_L3_h4 = polyline(z=-1.27mm, xy in mm: (-7.3601, -11.21) (-7.6352, -10.8925) (-7.6352, -10.6075) (-7.3601, -10.29) (-6.9399, -10.29) (-6.6648, -10.6075) (-6.6648, -10.8925) (-6.9399, -11.21) (-7.222, -11.2505) (-7.3601, -11.21), closed, covered)
  P18_DCP_L3_h5 = polyline(z=-1.27mm, xy in mm: (8.1399, -11.21) (7.8648, -10.8925) (7.8648, -10.6075) (8.1399, -10.29) (8.5601, -10.29) (8.7754, -10.4766) (8.9188, -10.7512) (8.6811, -11.1321) (8.278, -11.2505) (8.1399, -11.21), closed, covered)
  P18_DCP_L3_h6 = polyline(z=-1.27mm, xy in mm: (-18.7597, 3.8031) (-18.6032, 4.0185) (-18.2169, 4.0797) (-18.0015, 3.9232) (-17.9403, 3.5369) (-18.0968, 3.3215) (-18.35, 3.2392) (-18.6032, 3.3215) (-18.7808, 3.67) (-18.7597, 3.8031), closed, covered)
  P18_DCP_L3_h7 = polyline(z=-1.27mm, xy in mm: (-37.3294, -0.4959) (-37.1119, -0.1179) (-36.7088, 0.0005) (-36.4496, -0.1179) (-36.212, -0.5012) (-36.4496, -0.8821) (-36.8527, -1.0005) (-37.1119, -0.8821) (-37.3496, -0.4988) (-37.3294, -0.4959), closed, covered)
  P18_DCP_L3_h8 = polyline(z=-1.27mm, xy in mm: (-34.9602, -0.4959) (-34.7427, -0.1179) (-34.3396, 0.0005) (-34.0804, -0.1179) (-33.8427, -0.5012) (-34.0804, -0.8821) (-34.4835, -1.0005) (-34.7427, -0.8821) (-34.9804, -0.4988) (-34.9602, -0.4959), closed, covered)
  P18_DCP_L3_h9 = polyline(z=-1.27mm, xy in mm: (-33.7756, -0.4959) (-33.558, -0.1179) (-33.155, 0.0005) (-32.8958, -0.1179) (-32.6581, -0.5012) (-32.8958, -0.8821) (-33.2989, -1.0005) (-33.558, -0.8821) (-33.7957, -0.4988) (-33.7756, -0.4959), closed, covered)
  P18_DCP_L3_h10 = polyline(z=-1.27mm, xy in mm: (-31.4063, -0.4959) (-31.1888, -0.1179) (-30.7857, 0.0005) (-30.5266, -0.1179) (-30.2889, -0.5012) (-30.5266, -0.8821) (-30.9297, -1.0005) (-31.1888, -0.8821) (-31.4265, -0.4988) (-31.4063, -0.4959), closed, covered)
  P18_DCP_L3_h11 = polyline(z=-1.27mm, xy in mm: (-29.0371, -0.4959) (-28.8196, -0.1179) (-28.4165, 0.0005) (-28.1573, -0.1179) (-27.9196, -0.5012) (-28.1573, -0.8821) (-28.5604, -1.0005) (-28.8196, -0.8821) (-29.0573, -0.4988) (-29.0371, -0.4959), closed, covered)
  P18_DCP_L3_h12 = polyline(z=-1.27mm, xy in mm: (-27.8525, -0.4959) (-27.635, -0.1179) (-27.2319, 0.0005) (-26.9727, -0.1179) (-26.735, -0.5012) (-26.9727, -0.8821) (-27.3758, -1.0005) (-27.635, -0.8821) (-27.8727, -0.4988) (-27.8525, -0.4959), closed, covered)
  P18_DCP_L3_h13 = polyline(z=-1.27mm, xy in mm: (-25.4832, -0.4959) (-25.2657, -0.1179) (-24.8627, 0.0005) (-24.6035, -0.1179) (-24.3658, -0.5012) (-24.6035, -0.8821) (-25.0066, -1.0005) (-25.2657, -0.8821) (-25.5034, -0.4988) (-25.4832, -0.4959), closed, covered)
  P18_DCP_L3_h14 = polyline(z=-1.27mm, xy in mm: (-24.2986, -0.4959) (-24.0811, -0.1179) (-23.678, 0.0005) (-23.4189, -0.1179) (-23.1812, -0.5012) (-23.4189, -0.8821) (-23.822, -1.0005) (-24.0811, -0.8821) (-24.3188, -0.4988) (-24.2986, -0.4959), closed, covered)
  P18_DCP_L3_h15 = polyline(z=-1.27mm, xy in mm: (-21.9294, -0.4959) (-21.7119, -0.1179) (-21.3088, 0.0005) (-21.0496, -0.1179) (-20.812, -0.5012) (-21.0496, -0.8821) (-21.4527, -1.0005) (-21.7119, -0.8821) (-21.9496, -0.4988) (-21.9294, -0.4959), closed, covered)
  P18_DCP_L3_h16 = polyline(z=-1.27mm, xy in mm: (-19.5602, -0.4959) (-19.3427, -0.1179) (-18.9396, 0.0005) (-18.6804, -0.1179) (-18.4427, -0.5012) (-18.6804, -0.8821) (-19.0835, -1.0005) (-19.3427, -0.8821) (-19.5804, -0.4988) (-19.5602, -0.4959), closed, covered)
  P18_DCP_L3_h17 = polyline(z=-1.27mm, xy in mm: (-18.3756, -0.4959) (-18.1581, -0.1179) (-17.755, 0.0005) (-17.4958, -0.1179) (-17.2581, -0.5012) (-17.4958, -0.8821) (-17.8989, -1.0005) (-18.1581, -0.8821) (-18.3957, -0.4988) (-18.3756, -0.4959), closed, covered)
  P18_DCP_L3_h18 = polyline(z=-1.27mm, xy in mm: (-16.0063, -0.4959) (-15.7888, -0.1179) (-15.3857, 0.0005) (-15.1266, -0.1179) (-14.8889, -0.5012) (-15.1266, -0.8821) (-15.5297, -1.0005) (-15.7888, -0.8821) (-16.0265, -0.4988) (-16.0063, -0.4959), closed, covered)
  P18_DCP_L3_h19 = polyline(z=-1.27mm, xy in mm: (-13.6371, -0.4959) (-13.4196, -0.1179) (-13.0165, 0.0005) (-12.7573, -0.1179) (-12.5196, -0.5012) (-12.7573, -0.8821) (-13.1604, -1.0005) (-13.4196, -0.8821) (-13.6573, -0.4988) (-13.6371, -0.4959), closed, covered)
  P18_DCP_L3_h20 = polyline(z=-1.27mm, xy in mm: (-12.4525, -0.4959) (-12.235, -0.1179) (-11.8319, 0.0005) (-11.5727, -0.1179) (-11.335, -0.5012) (-11.5727, -0.8821) (-11.9758, -1.0005) (-12.235, -0.8821) (-12.4727, -0.4988) (-12.4525, -0.4959), closed, covered)
  P18_DCP_L3_h21 = polyline(z=-1.27mm, xy in mm: (-10.0832, -0.4959) (-9.8657, -0.1179) (-9.4627, 0.0005) (-9.2035, -0.1179) (-8.9658, -0.5012) (-9.2035, -0.8821) (-9.6066, -1.0005) (-9.8657, -0.8821) (-10.1034, -0.4988) (-10.0832, -0.4959), closed, covered)
  P18_DCP_L3_h22 = polyline(z=-1.27mm, xy in mm: (8.986, -0.4959) (9.2035, -0.1179) (9.6066, 0.0005) (9.8657, -0.1179) (10.1034, -0.5012) (9.8657, -0.8821) (9.4626, -1.0005) (9.2035, -0.8821) (8.9658, -0.4988) (8.986, -0.4959), closed, covered)
  P18_DCP_L3_h23 = polyline(z=-1.27mm, xy in mm: (10.1706, -0.4959) (10.3881, -0.1179) (10.7912, 0.0005) (11.0504, -0.1179) (11.288, -0.5012) (11.0504, -0.8821) (10.6473, -1.0005) (10.3881, -0.8821) (10.1504, -0.4988) (10.1706, -0.4959), closed, covered)
  P18_DCP_L3_h24 = polyline(z=-1.27mm, xy in mm: (12.5398, -0.4959) (12.7573, -0.1179) (13.1604, 0.0005) (13.4196, -0.1179) (13.6573, -0.5012) (13.4196, -0.8821) (13.0165, -1.0005) (12.7573, -0.8821) (12.5196, -0.4988) (12.5398, -0.4959), closed, covered)
  P18_DCP_L3_h25 = polyline(z=-1.27mm, xy in mm: (13.7244, -0.4959) (13.9419, -0.1179) (14.345, 0.0005) (14.6042, -0.1179) (14.8419, -0.5012) (14.6042, -0.8821) (14.2011, -1.0005) (13.9419, -0.8821) (13.7043, -0.4988) (13.7244, -0.4959), closed, covered)
  P18_DCP_L3_h26 = polyline(z=-1.27mm, xy in mm: (16.0937, -0.4959) (16.3112, -0.1179) (16.7143, 0.0005) (16.9734, -0.1179) (17.2111, -0.5012) (16.9734, -0.8821) (16.5703, -1.0005) (16.3112, -0.8821) (16.0735, -0.4988) (16.0937, -0.4959), closed, covered)
  P18_DCP_L3_h27 = polyline(z=-1.27mm, xy in mm: (18.4629, -0.4959) (18.6804, -0.1179) (19.0835, 0.0005) (19.3427, -0.1179) (19.5804, -0.5012) (19.3427, -0.8821) (18.9396, -1.0005) (18.6804, -0.8821) (18.4427, -0.4988) (18.4629, -0.4959), closed, covered)
  P18_DCP_L3_h28 = polyline(z=-1.27mm, xy in mm: (19.6475, -0.4959) (19.865, -0.1179) (20.2681, 0.0005) (20.5273, -0.1179) (20.765, -0.5012) (20.5273, -0.8821) (20.1242, -1.0005) (19.865, -0.8821) (19.6273, -0.4988) (19.6475, -0.4959), closed, covered)
  P18_DCP_L3_h29 = polyline(z=-1.27mm, xy in mm: (22.0168, -0.4959) (22.2343, -0.1179) (22.6373, 0.0005) (22.8965, -0.1179) (23.1342, -0.5012) (22.8965, -0.8821) (22.4934, -1.0005) (22.2343, -0.8821) (21.9966, -0.4988) (22.0168, -0.4959), closed, covered)
  P18_DCP_L3_h30 = polyline(z=-1.27mm, xy in mm: (24.386, -0.4959) (24.6035, -0.1179) (25.0066, 0.0005) (25.2657, -0.1179) (25.5034, -0.5012) (25.2657, -0.8821) (24.8627, -1.0005) (24.6035, -0.8821) (24.3658, -0.4988) (24.386, -0.4959), closed, covered)
  P18_DCP_L3_h31 = polyline(z=-1.27mm, xy in mm: (25.5706, -0.4959) (25.7881, -0.1179) (26.1912, 0.0005) (26.4504, -0.1179) (26.688, -0.5012) (26.4504, -0.8821) (26.0473, -1.0005) (25.7881, -0.8821) (25.5504, -0.4988) (25.5706, -0.4959), closed, covered)
  P18_DCP_L3_h32 = polyline(z=-1.27mm, xy in mm: (27.9398, -0.4959) (28.1573, -0.1179) (28.5604, 0.0005) (28.8196, -0.1179) (29.0573, -0.5012) (28.8196, -0.8821) (28.4165, -1.0005) (28.1573, -0.8821) (27.9196, -0.4988) (27.9398, -0.4959), closed, covered)
  P18_DCP_L3_h33 = polyline(z=-1.27mm, xy in mm: (29.1244, -0.4959) (29.3419, -0.1179) (29.745, 0.0005) (30.0042, -0.1179) (30.2419, -0.5012) (30.0042, -0.8821) (29.6011, -1.0005) (29.3419, -0.8821) (29.1043, -0.4988) (29.1244, -0.4959), closed, covered)
  P18_DCP_L3_h34 = polyline(z=-1.27mm, xy in mm: (31.4937, -0.4959) (31.7112, -0.1179) (32.1143, 0.0005) (32.3734, -0.1179) (32.6111, -0.5012) (32.3734, -0.8821) (31.9703, -1.0005) (31.7112, -0.8821) (31.4735, -0.4988) (31.4937, -0.4959), closed, covered)
  P18_DCP_L3_h35 = polyline(z=-1.27mm, xy in mm: (33.8629, -0.4959) (34.0804, -0.1179) (34.4835, 0.0005) (34.7427, -0.1179) (34.9804, -0.5012) (34.7427, -0.8821) (34.3396, -1.0005) (34.0804, -0.8821) (33.8427, -0.4988) (33.8629, -0.4959), closed, covered)
  P18_DCP_L3_h36 = polyline(z=-1.27mm, xy in mm: (35.0475, -0.4959) (35.265, -0.1179) (35.6681, 0.0005) (35.9273, -0.1179) (36.165, -0.5012) (35.9273, -0.8821) (35.5242, -1.0005) (35.265, -0.8821) (35.0273, -0.4988) (35.0475, -0.4959), closed, covered)
  P18_DCP_L3_h37 = polyline(z=-1.27mm, xy in mm: (37.4168, -0.4959) (37.6343, -0.1179) (38.0373, 0.0005) (38.2965, -0.1179) (38.5342, -0.5012) (38.2965, -0.8821) (37.8934, -1.0005) (37.6343, -0.8821) (37.3966, -0.4988) (37.4168, -0.4959), closed, covered)
  P18_DCP_L3_h38 = polyline(z=-1.27mm, xy in mm: (-38.514, -0.4959) (-38.2965, -0.1179) (-37.8934, 0.0005) (-37.6343, -0.1179) (-37.3966, -0.5012) (-37.6343, -0.8821) (-38.0373, -1.0005) (-38.2965, -0.8821) (-38.5342, -0.4988) (-38.514, -0.4959), closed, covered)
  P18_DCP_L3_h39 = polyline(z=-1.27mm, xy in mm: (-36.1448, -0.4959) (-35.9273, -0.1179) (-35.5242, 0.0005) (-35.265, -0.1179) (-35.0273, -0.5012) (-35.265, -0.8821) (-35.6681, -1.0005) (-35.9273, -0.8821) (-36.165, -0.4988) (-36.1448, -0.4959), closed, covered)
  P18_DCP_L3_h40 = polyline(z=-1.27mm, xy in mm: (-32.5909, -0.4959) (-32.3734, -0.1179) (-31.9703, 0.0005) (-31.7112, -0.1179) (-31.4735, -0.5012) (-31.7112, -0.8821) (-32.1143, -1.0005) (-32.3734, -0.8821) (-32.6111, -0.4988) (-32.5909, -0.4959), closed, covered)
  P18_DCP_L3_h41 = polyline(z=-1.27mm, xy in mm: (-30.2217, -0.4959) (-30.0042, -0.1179) (-29.6011, 0.0005) (-29.3419, -0.1179) (-29.1043, -0.5012) (-29.3419, -0.8821) (-29.745, -1.0005) (-30.0042, -0.8821) (-30.2419, -0.4988) (-30.2217, -0.4959), closed, covered)
  P18_DCP_L3_h42 = polyline(z=-1.27mm, xy in mm: (-26.6679, -0.4959) (-26.4504, -0.1179) (-26.0473, 0.0005) (-25.7881, -0.1179) (-25.5504, -0.5012) (-25.7881, -0.8821) (-26.1912, -1.0005) (-26.4504, -0.8821) (-26.688, -0.4988) (-26.6679, -0.4959), closed, covered)
  P18_DCP_L3_h43 = polyline(z=-1.27mm, xy in mm: (-23.114, -0.4959) (-22.8965, -0.1179) (-22.4934, 0.0005) (-22.2343, -0.1179) (-21.9966, -0.5012) (-22.2343, -0.8821) (-22.6373, -1.0005) (-22.8965, -0.8821) (-23.1342, -0.4988) (-23.114, -0.4959), closed, covered)
  P18_DCP_L3_h44 = polyline(z=-1.27mm, xy in mm: (-20.7448, -0.4959) (-20.5273, -0.1179) (-20.1242, 0.0005) (-19.865, -0.1179) (-19.6273, -0.5012) (-19.865, -0.8821) (-20.2681, -1.0005) (-20.5273, -0.8821) (-20.765, -0.4988) (-20.7448, -0.4959), closed, covered)
  P18_DCP_L3_h45 = polyline(z=-1.27mm, xy in mm: (-17.1909, -0.4959) (-16.9734, -0.1179) (-16.5703, 0.0005) (-16.3112, -0.1179) (-16.0735, -0.5012) (-16.3112, -0.8821) (-16.7143, -1.0005) (-16.9734, -0.8821) (-17.2111, -0.4988) (-17.1909, -0.4959), closed, covered)
  P18_DCP_L3_h46 = polyline(z=-1.27mm, xy in mm: (-14.8217, -0.4959) (-14.6042, -0.1179) (-14.2011, 0.0005) (-13.9419, -0.1179) (-13.7043, -0.5012) (-13.9419, -0.8821) (-14.345, -1.0005) (-14.6042, -0.8821) (-14.8419, -0.4988) (-14.8217, -0.4959), closed, covered)
  P18_DCP_L3_h47 = polyline(z=-1.27mm, xy in mm: (-11.2679, -0.4959) (-11.0504, -0.1179) (-10.6473, 0.0005) (-10.3881, -0.1179) (-10.1504, -0.5012) (-10.3881, -0.8821) (-10.7912, -1.0005) (-11.0504, -0.8821) (-11.288, -0.4988) (-11.2679, -0.4959), closed, covered)
  P18_DCP_L3_h48 = polyline(z=-1.27mm, xy in mm: (-8.8986, -0.4959) (-8.6811, -0.1179) (-8.422, 0.0005) (-8.0189, -0.1179) (-7.8381, -0.4948) (-8.0189, -0.8821) (-8.278, -1.0005) (-8.6811, -0.8821) (-8.9188, -0.4988) (-8.8986, -0.4959), closed, covered)
  P18_DCP_L3_h49 = polyline(z=-1.27mm, xy in mm: (11.3552, -0.4959) (11.5727, -0.1179) (11.9758, 0.0005) (12.235, -0.1179) (12.4727, -0.5012) (12.235, -0.8821) (11.8319, -1.0005) (11.5727, -0.8821) (11.335, -0.4988) (11.3552, -0.4959), closed, covered)
  P18_DCP_L3_h50 = polyline(z=-1.27mm, xy in mm: (14.9091, -0.4959) (15.1266, -0.1179) (15.5297, 0.0005) (15.7888, -0.1179) (16.0265, -0.5012) (15.7888, -0.8821) (15.3857, -1.0005) (15.1266, -0.8821) (14.8889, -0.4988) (14.9091, -0.4959), closed, covered)
  P18_DCP_L3_h51 = polyline(z=-1.27mm, xy in mm: (17.2783, -0.4959) (17.4958, -0.1179) (17.8989, 0.0005) (18.1581, -0.1179) (18.3957, -0.5012) (18.1581, -0.8821) (17.755, -1.0005) (17.4958, -0.8821) (17.2581, -0.4988) (17.2783, -0.4959), closed, covered)
  P18_DCP_L3_h52 = polyline(z=-1.27mm, xy in mm: (20.8321, -0.4959) (21.0496, -0.1179) (21.4527, 0.0005) (21.7119, -0.1179) (21.9496, -0.5012) (21.7119, -0.8821) (21.3088, -1.0005) (21.0496, -0.8821) (20.812, -0.4988) (20.8321, -0.4959), closed, covered)
  P18_DCP_L3_h53 = polyline(z=-1.27mm, xy in mm: (23.2014, -0.4959) (23.4189, -0.1179) (23.822, 0.0005) (24.0811, -0.1179) (24.3188, -0.5012) (24.0811, -0.8821) (23.678, -1.0005) (23.4189, -0.8821) (23.1812, -0.4988) (23.2014, -0.4959), closed, covered)
  P18_DCP_L3_h54 = polyline(z=-1.27mm, xy in mm: (26.7552, -0.4959) (26.9727, -0.1179) (27.3758, 0.0005) (27.635, -0.1179) (27.8727, -0.5012) (27.635, -0.8821) (27.2319, -1.0005) (26.9727, -0.8821) (26.735, -0.4988) (26.7552, -0.4959), closed, covered)
  P18_DCP_L3_h55 = polyline(z=-1.27mm, xy in mm: (30.3091, -0.4959) (30.5266, -0.1179) (30.9297, 0.0005) (31.1888, -0.1179) (31.4265, -0.5012) (31.1888, -0.8821) (30.7857, -1.0005) (30.5266, -0.8821) (30.2889, -0.4988) (30.3091, -0.4959), closed, covered)
  P18_DCP_L3_h56 = polyline(z=-1.27mm, xy in mm: (32.6783, -0.4959) (32.8958, -0.1179) (33.2989, 0.0005) (33.5581, -0.1179) (33.7957, -0.5012) (33.5581, -0.8821) (33.155, -1.0005) (32.8958, -0.8821) (32.6581, -0.4988) (32.6783, -0.4959), closed, covered)
  P18_DCP_L3_h57 = polyline(z=-1.27mm, xy in mm: (36.2321, -0.4959) (36.4496, -0.1179) (36.8527, 0.0005) (37.1119, -0.1179) (37.3496, -0.5012) (37.1119, -0.8821) (36.7088, -1.0005) (36.4496, -0.8821) (36.212, -0.4988) (36.2321, -0.4959), closed, covered)
  P18_DCP_L3_h58 = polyline(z=-1.27mm, xy in mm: (-2.852, -0.4747) (-2.6811, -0.1179) (-2.278, 0.0005) (-2.0189, -0.1179) (-1.8381, -0.4948) (-2.0189, -0.8821) (-2.278, -1.0005) (-2.6811, -0.8821) (-2.8619, -0.5052) (-2.852, -0.4747), closed, covered)
  P18_DCP_L3_h59 = polyline(z=-1.27mm, xy in mm: (-6.452, -0.4747) (-6.2811, -0.1179) (-5.878, 0.0005) (-5.6189, -0.1179) (-5.4381, -0.4948) (-5.6189, -0.8821) (-5.878, -1.0005) (-6.2811, -0.8821) (-6.4619, -0.5052) (-6.452, -0.4747), closed, covered)
  P18_DCP_L3_h60 = polyline(z=-1.27mm, xy in mm: (-5.252, -0.4747) (-5.0811, -0.1179) (-4.678, 0.0005) (-4.4189, -0.1179) (-4.2381, -0.4948) (-4.4189, -0.8821) (-4.678, -1.0005) (-5.0811, -0.8821) (-5.2619, -0.5052) (-5.252, -0.4747), closed, covered)
  P18_DCP_L3_h61 = polyline(z=-1.27mm, xy in mm: (-4.052, -0.4747) (-3.8811, -0.1179) (-3.478, 0.0005) (-3.2189, -0.1179) (-3.0381, -0.4948) (-3.2189, -0.8821) (-3.478, -1.0005) (-3.8811, -0.8821) (-4.0619, -0.5052) (-4.052, -0.4747), closed, covered)
  P18_DCP_L3_h62 = polyline(z=-1.27mm, xy in mm: (-1.652, -0.4747) (-1.4811, -0.1179) (-1.078, 0.0005) (-0.8189, -0.1179) (-0.6381, -0.4948) (-0.8189, -0.8821) (-1.078, -1.0005) (-1.4811, -0.8821) (-1.6619, -0.5052) (-1.652, -0.4747), closed, covered)
  P18_DCP_L3_h63 = polyline(z=-1.27mm, xy in mm: (-0.452, -0.4747) (-0.2811, -0.1179) (0.122, 0.0005) (0.3811, -0.1179) (0.5619, -0.4948) (0.3811, -0.8821) (0.122, -1.0005) (-0.2811, -0.8821) (-0.4619, -0.5052) (-0.452, -0.4747), closed, covered)
  P18_DCP_L3_h64 = polyline(z=-1.27mm, xy in mm: (0.748, -0.4747) (0.9189, -0.1179) (1.322, 0.0005) (1.5811, -0.1179) (1.7619, -0.4948) (1.5811, -0.8821) (1.322, -1.0005) (0.9189, -0.8821) (0.7381, -0.5052) (0.748, -0.4747), closed, covered)
  P18_DCP_L3_h65 = polyline(z=-1.27mm, xy in mm: (1.948, -0.4747) (2.1189, -0.1179) (2.522, 0.0005) (2.7811, -0.1179) (2.9619, -0.4948) (2.7811, -0.8821) (2.522, -1.0005) (2.1189, -0.8821) (1.9381, -0.5052) (1.948, -0.4747), closed, covered)
  P18_DCP_L3_h66 = polyline(z=-1.27mm, xy in mm: (3.148, -0.4747) (3.3189, -0.1179) (3.722, 0.0005) (3.9811, -0.1179) (4.1619, -0.4948) (3.9811, -0.8821) (3.722, -1.0005) (3.3189, -0.8821) (3.1381, -0.5052) (3.148, -0.4747), closed, covered)
  P18_DCP_L3_h67 = polyline(z=-1.27mm, xy in mm: (4.348, -0.4747) (4.5189, -0.1179) (4.922, 0.0005) (5.1811, -0.1179) (5.3619, -0.4948) (5.1811, -0.8821) (4.922, -1.0005) (4.5189, -0.8821) (4.3381, -0.5052) (4.348, -0.4747), closed, covered)
  P18_DCP_L3_h68 = polyline(z=-1.27mm, xy in mm: (5.548, -0.4747) (5.7189, -0.1179) (6.122, 0.0005) (6.4754, -0.2266) (6.5556, -0.5) (6.4754, -0.7734) (6.122, -1.0005) (5.7189, -0.8821) (5.5381, -0.5052) (5.548, -0.4747), closed, covered)
  P18_DCP_L3_h69 = polyline(z=-1.27mm, xy in mm: (-37.3294, -10.7459) (-37.1119, -10.3679) (-36.7088, -10.2495) (-36.4496, -10.3679) (-36.212, -10.7512) (-36.4496, -11.1321) (-36.8527, -11.2505) (-37.1119, -11.1321) (-37.3496, -10.7488) (-37.3294, -10.7459), closed, covered)
  P18_DCP_L3_h70 = polyline(z=-1.27mm, xy in mm: (-34.9602, -10.7459) (-34.7427, -10.3679) (-34.3396, -10.2495) (-34.0804, -10.3679) (-33.8427, -10.7512) (-34.0804, -11.1321) (-34.4835, -11.2505) (-34.7427, -11.1321) (-34.9804, -10.7488) (-34.9602, -10.7459), closed, covered)
  P18_DCP_L3_h71 = polyline(z=-1.27mm, xy in mm: (-33.7756, -10.7459) (-33.558, -10.3679) (-33.155, -10.2495) (-32.8958, -10.3679) (-32.6581, -10.7512) (-32.8958, -11.1321) (-33.2989, -11.2505) (-33.558, -11.1321) (-33.7957, -10.7488) (-33.7756, -10.7459), closed, covered)
  P18_DCP_L3_h72 = polyline(z=-1.27mm, xy in mm: (-31.4063, -10.7459) (-31.1888, -10.3679) (-30.7857, -10.2495) (-30.5266, -10.3679) (-30.2889, -10.7512) (-30.5266, -11.1321) (-30.9297, -11.2505) (-31.1888, -11.1321) (-31.4265, -10.7488) (-31.4063, -10.7459), closed, covered)
  P18_DCP_L3_h73 = polyline(z=-1.27mm, xy in mm: (-29.0371, -10.7459) (-28.8196, -10.3679) (-28.4165, -10.2495) (-28.1573, -10.3679) (-27.9196, -10.7512) (-28.1573, -11.1321) (-28.5604, -11.2505) (-28.8196, -11.1321) (-29.0573, -10.7488) (-29.0371, -10.7459), closed, covered)
  P18_DCP_L3_h74 = polyline(z=-1.27mm, xy in mm: (-27.8525, -10.7459) (-27.635, -10.3679) (-27.2319, -10.2495) (-26.9727, -10.3679) (-26.735, -10.7512) (-26.9727, -11.1321) (-27.3758, -11.2505) (-27.635, -11.1321) (-27.8727, -10.7488) (-27.8525, -10.7459), closed, covered)
  P18_DCP_L3_h75 = polyline(z=-1.27mm, xy in mm: (-25.4832, -10.7459) (-25.2657, -10.3679) (-24.8627, -10.2495) (-24.6035, -10.3679) (-24.3658, -10.7512) (-24.6035, -11.1321) (-25.0066, -11.2505) (-25.2657, -11.1321) (-25.5034, -10.7488) (-25.4832, -10.7459), closed, covered)
  P18_DCP_L3_h76 = polyline(z=-1.27mm, xy in mm: (-24.2986, -10.7459) (-24.0811, -10.3679) (-23.678, -10.2495) (-23.4189, -10.3679) (-23.1812, -10.7512) (-23.4189, -11.1321) (-23.822, -11.2505) (-24.0811, -11.1321) (-24.3188, -10.7488) (-24.2986, -10.7459), closed, covered)
  P18_DCP_L3_h77 = polyline(z=-1.27mm, xy in mm: (-21.9294, -10.7459) (-21.7119, -10.3679) (-21.3088, -10.2495) (-21.0496, -10.3679) (-20.812, -10.7512) (-21.0496, -11.1321) (-21.4527, -11.2505) (-21.7119, -11.1321) (-21.9496, -10.7488) (-21.9294, -10.7459), closed, covered)
  P18_DCP_L3_h78 = polyline(z=-1.27mm, xy in mm: (-19.5602, -10.7459) (-19.3427, -10.3679) (-18.9396, -10.2495) (-18.6804, -10.3679) (-18.4427, -10.7512) (-18.6804, -11.1321) (-19.0835, -11.2505) (-19.3427, -11.1321) (-19.5804, -10.7488) (-19.5602, -10.7459), closed, covered)
  P18_DCP_L3_h79 = polyline(z=-1.27mm, xy in mm: (-18.3756, -10.7459) (-18.1581, -10.3679) (-17.755, -10.2495) (-17.4958, -10.3679) (-17.2581, -10.7512) (-17.4958, -11.1321) (-17.8989, -11.2505) (-18.1581, -11.1321) (-18.3957, -10.7488) (-18.3756, -10.7459), closed, covered)
  P18_DCP_L3_h80 = polyline(z=-1.27mm, xy in mm: (-16.0063, -10.7459) (-15.7888, -10.3679) (-15.3857, -10.2495) (-15.1266, -10.3679) (-14.8889, -10.7512) (-15.1266, -11.1321) (-15.5297, -11.2505) (-15.7888, -11.1321) (-16.0265, -10.7488) (-16.0063, -10.7459), closed, covered)
  P18_DCP_L3_h81 = polyline(z=-1.27mm, xy in mm: (-13.6371, -10.7459) (-13.4196, -10.3679) (-13.0165, -10.2495) (-12.7573, -10.3679) (-12.5196, -10.7512) (-12.7573, -11.1321) (-13.1604, -11.2505) (-13.4196, -11.1321) (-13.6573, -10.7488) (-13.6371, -10.7459), closed, covered)
  P18_DCP_L3_h82 = polyline(z=-1.27mm, xy in mm: (-12.4525, -10.7459) (-12.235, -10.3679) (-11.8319, -10.2495) (-11.5727, -10.3679) (-11.335, -10.7512) (-11.5727, -11.1321) (-11.9758, -11.2505) (-12.235, -11.1321) (-12.4727, -10.7488) (-12.4525, -10.7459), closed, covered)
  P18_DCP_L3_h83 = polyline(z=-1.27mm, xy in mm: (-10.0832, -10.7459) (-9.8657, -10.3679) (-9.4627, -10.2495) (-9.2035, -10.3679) (-8.9658, -10.7512) (-9.2035, -11.1321) (-9.6066, -11.2505) (-9.8657, -11.1321) (-10.1034, -10.7488) (-10.0832, -10.7459), closed, covered)
  P18_DCP_L3_h84 = polyline(z=-1.27mm, xy in mm: (8.986, -10.7459) (9.2035, -10.3679) (9.6066, -10.2495) (9.8657, -10.3679) (10.1034, -10.7512) (9.8657, -11.1321) (9.4626, -11.2505) (9.2035, -11.1321) (8.9658, -10.7488) (8.986, -10.7459), closed, covered)
  P18_DCP_L3_h85 = polyline(z=-1.27mm, xy in mm: (10.1706, -10.7459) (10.3881, -10.3679) (10.7912, -10.2495) (11.0504, -10.3679) (11.288, -10.7512) (11.0504, -11.1321) (10.6473, -11.2505) (10.3881, -11.1321) (10.1504, -10.7488) (10.1706, -10.7459), closed, covered)
  P18_DCP_L3_h86 = polyline(z=-1.27mm, xy in mm: (12.5398, -10.7459) (12.7573, -10.3679) (13.1604, -10.2495) (13.4196, -10.3679) (13.6573, -10.7512) (13.4196, -11.1321) (13.0165, -11.2505) (12.7573, -11.1321) (12.5196, -10.7488) (12.5398, -10.7459), closed, covered)
  P18_DCP_L3_h87 = polyline(z=-1.27mm, xy in mm: (13.7244, -10.7459) (13.9419, -10.3679) (14.345, -10.2495) (14.6042, -10.3679) (14.8419, -10.7512) (14.6042, -11.1321) (14.2011, -11.2505) (13.9419, -11.1321) (13.7043, -10.7488) (13.7244, -10.7459), closed, covered)
  P18_DCP_L3_h88 = polyline(z=-1.27mm, xy in mm: (16.0937, -10.7459) (16.3112, -10.3679) (16.7143, -10.2495) (16.9734, -10.3679) (17.2111, -10.7512) (16.9734, -11.1321) (16.5703, -11.2505) (16.3112, -11.1321) (16.0735, -10.7488) (16.0937, -10.7459), closed, covered)
  P18_DCP_L3_h89 = polyline(z=-1.27mm, xy in mm: (18.4629, -10.7459) (18.6804, -10.3679) (19.0835, -10.2495) (19.3427, -10.3679) (19.5804, -10.7512) (19.3427, -11.1321) (18.9396, -11.2505) (18.6804, -11.1321) (18.4427, -10.7488) (18.4629, -10.7459), closed, covered)
  P18_DCP_L3_h90 = polyline(z=-1.27mm, xy in mm: (19.6475, -10.7459) (19.865, -10.3679) (20.2681, -10.2495) (20.5273, -10.3679) (20.765, -10.7512) (20.5273, -11.1321) (20.1242, -11.2505) (19.865, -11.1321) (19.6273, -10.7488) (19.6475, -10.7459), closed, covered)
  P18_DCP_L3_h91 = polyline(z=-1.27mm, xy in mm: (22.0168, -10.7459) (22.2343, -10.3679) (22.6373, -10.2495) (22.8965, -10.3679) (23.1342, -10.7512) (22.8965, -11.1321) (22.4934, -11.2505) (22.2343, -11.1321) (21.9966, -10.7488) (22.0168, -10.7459), closed, covered)
  P18_DCP_L3_h92 = polyline(z=-1.27mm, xy in mm: (24.386, -10.7459) (24.6035, -10.3679) (25.0066, -10.2495) (25.2657, -10.3679) (25.5034, -10.7512) (25.2657, -11.1321) (24.8627, -11.2505) (24.6035, -11.1321) (24.3658, -10.7488) (24.386, -10.7459), closed, covered)
  P18_DCP_L3_h93 = polyline(z=-1.27mm, xy in mm: (25.5706, -10.7459) (25.7881, -10.3679) (26.1912, -10.2495) (26.4504, -10.3679) (26.688, -10.7512) (26.4504, -11.1321) (26.0473, -11.2505) (25.7881, -11.1321) (25.5504, -10.7488) (25.5706, -10.7459), closed, covered)
  P18_DCP_L3_h94 = polyline(z=-1.27mm, xy in mm: (27.9398, -10.7459) (28.1573, -10.3679) (28.5604, -10.2495) (28.8196, -10.3679) (29.0573, -10.7512) (28.8196, -11.1321) (28.4165, -11.2505) (28.1573, -11.1321) (27.9196, -10.7488) (27.9398, -10.7459), closed, covered)
  P18_DCP_L3_h95 = polyline(z=-1.27mm, xy in mm: (29.1244, -10.7459) (29.3419, -10.3679) (29.745, -10.2495) (30.0042, -10.3679) (30.2419, -10.7512) (30.0042, -11.1321) (29.6011, -11.2505) (29.3419, -11.1321) (29.1043, -10.7488) (29.1244, -10.7459), closed, covered)
  P18_DCP_L3_h96 = polyline(z=-1.27mm, xy in mm: (31.4937, -10.7459) (31.7112, -10.3679) (32.1143, -10.2495) (32.3734, -10.3679) (32.6111, -10.7512) (32.3734, -11.1321) (31.9703, -11.2505) (31.7112, -11.1321) (31.4735, -10.7488) (31.4937, -10.7459), closed, covered)
  P18_DCP_L3_h97 = polyline(z=-1.27mm, xy in mm: (33.8629, -10.7459) (34.0804, -10.3679) (34.4835, -10.2495) (34.7427, -10.3679) (34.9804, -10.7512) (34.7427, -11.1321) (34.3396, -11.2505) (34.0804, -11.1321) (33.8427, -10.7488) (33.8629, -10.7459), closed, covered)
  P18_DCP_L3_h98 = polyline(z=-1.27mm, xy in mm: (35.0475, -10.7459) (35.265, -10.3679) (35.6681, -10.2495) (35.9273, -10.3679) (36.165, -10.7512) (35.9273, -11.1321) (35.5242, -11.2505) (35.265, -11.1321) (35.0273, -10.7488) (35.0475, -10.7459), closed, covered)
  P18_DCP_L3_h99 = polyline(z=-1.27mm, xy in mm: (37.4168, -10.7459) (37.6343, -10.3679) (38.0373, -10.2495) (38.2965, -10.3679) (38.5342, -10.7512) (38.2965, -11.1321) (37.8934, -11.2505) (37.6343, -11.1321) (37.3966, -10.7488) (37.4168, -10.7459), closed, covered)
  P18_DCP_L3_h100 = polyline(z=-1.27mm, xy in mm: (-38.514, -10.7459) (-38.2965, -10.3679) (-37.8934, -10.2495) (-37.6343, -10.3679) (-37.3966, -10.7512) (-37.6343, -11.1321) (-38.0373, -11.2505) (-38.2965, -11.1321) (-38.5342, -10.7488) (-38.514, -10.7459), closed, covered)
  P18_DCP_L3_h101 = polyline(z=-1.27mm, xy in mm: (-36.1448, -10.7459) (-35.9273, -10.3679) (-35.5242, -10.2495) (-35.265, -10.3679) (-35.0273, -10.7512) (-35.265, -11.1321) (-35.6681, -11.2505) (-35.9273, -11.1321) (-36.165, -10.7488) (-36.1448, -10.7459), closed, covered)
  P18_DCP_L3_h102 = polyline(z=-1.27mm, xy in mm: (-32.5909, -10.7459) (-32.3734, -10.3679) (-31.9703, -10.2495) (-31.7112, -10.3679) (-31.4735, -10.7512) (-31.7112, -11.1321) (-32.1143, -11.2505) (-32.3734, -11.1321) (-32.6111, -10.7488) (-32.5909, -10.7459), closed, covered)
  P18_DCP_L3_h103 = polyline(z=-1.27mm, xy in mm: (-30.2217, -10.7459) (-30.0042, -10.3679) (-29.6011, -10.2495) (-29.3419, -10.3679) (-29.1043, -10.7512) (-29.3419, -11.1321) (-29.745, -11.2505) (-30.0042, -11.1321) (-30.2419, -10.7488) (-30.2217, -10.7459), closed, covered)
  P18_DCP_L3_h104 = polyline(z=-1.27mm, xy in mm: (-26.6679, -10.7459) (-26.4504, -10.3679) (-26.0473, -10.2495) (-25.7881, -10.3679) (-25.5504, -10.7512) (-25.7881, -11.1321) (-26.1912, -11.2505) (-26.4504, -11.1321) (-26.688, -10.7488) (-26.6679, -10.7459), closed, covered)
  P18_DCP_L3_h105 = polyline(z=-1.27mm, xy in mm: (-23.114, -10.7459) (-22.8965, -10.3679) (-22.4934, -10.2495) (-22.2343, -10.3679) (-21.9966, -10.7512) (-22.2343, -11.1321) (-22.6373, -11.2505) (-22.8965, -11.1321) (-23.1342, -10.7488) (-23.114, -10.7459), closed, covered)
  P18_DCP_L3_h106 = polyline(z=-1.27mm, xy in mm: (-20.7448, -10.7459) (-20.5273, -10.3679) (-20.1242, -10.2495) (-19.865, -10.3679) (-19.6273, -10.7512) (-19.865, -11.1321) (-20.2681, -11.2505) (-20.5273, -11.1321) (-20.765, -10.7488) (-20.7448, -10.7459), closed, covered)
  P18_DCP_L3_h107 = polyline(z=-1.27mm, xy in mm: (-17.1909, -10.7459) (-16.9734, -10.3679) (-16.5703, -10.2495) (-16.3112, -10.3679) (-16.0735, -10.7512) (-16.3112, -11.1321) (-16.7143, -11.2505) (-16.9734, -11.1321) (-17.2111, -10.7488) (-17.1909, -10.7459), closed, covered)
  P18_DCP_L3_h108 = polyline(z=-1.27mm, xy in mm: (-14.8217, -10.7459) (-14.6042, -10.3679) (-14.2011, -10.2495) (-13.9419, -10.3679) (-13.7043, -10.7512) (-13.9419, -11.1321) (-14.345, -11.2505) (-14.6042, -11.1321) (-14.8419, -10.7488) (-14.8217, -10.7459), closed, covered)
  P18_DCP_L3_h109 = polyline(z=-1.27mm, xy in mm: (-11.2679, -10.7459) (-11.0504, -10.3679) (-10.6473, -10.2495) (-10.3881, -10.3679) (-10.1504, -10.7512) (-10.3881, -11.1321) (-10.7912, -11.2505) (-11.0504, -11.1321) (-11.288, -10.7488) (-11.2679, -10.7459), closed, covered)
  P18_DCP_L3_h110 = polyline(z=-1.27mm, xy in mm: (-8.8986, -10.7459) (-8.6811, -10.3679) (-8.422, -10.2495) (-8.0189, -10.3679) (-7.8381, -10.7448) (-8.0189, -11.1321) (-8.278, -11.2505) (-8.6811, -11.1321) (-8.9188, -10.7488) (-8.8986, -10.7459), closed, covered)
  P18_DCP_L3_h111 = polyline(z=-1.27mm, xy in mm: (11.3552, -10.7459) (11.5727, -10.3679) (11.9758, -10.2495) (12.235, -10.3679) (12.4727, -10.7512) (12.235, -11.1321) (11.8319, -11.2505) (11.5727, -11.1321) (11.335, -10.7488) (11.3552, -10.7459), closed, covered)
  P18_DCP_L3_h112 = polyline(z=-1.27mm, xy in mm: (14.9091, -10.7459) (15.1266, -10.3679) (15.5297, -10.2495) (15.7888, -10.3679) (16.0265, -10.7512) (15.7888, -11.1321) (15.3857, -11.2505) (15.1266, -11.1321) (14.8889, -10.7488) (14.9091, -10.7459), closed, covered)
  P18_DCP_L3_h113 = polyline(z=-1.27mm, xy in mm: (17.2783, -10.7459) (17.4958, -10.3679) (17.8989, -10.2495) (18.1581, -10.3679) (18.3957, -10.7512) (18.1581, -11.1321) (17.755, -11.2505) (17.4958, -11.1321) (17.2581, -10.7488) (17.2783, -10.7459), closed, covered)
  P18_DCP_L3_h114 = polyline(z=-1.27mm, xy in mm: (20.8321, -10.7459) (21.0496, -10.3679) (21.4527, -10.2495) (21.7119, -10.3679) (21.9496, -10.7512) (21.7119, -11.1321) (21.3088, -11.2505) (21.0496, -11.1321) (20.812, -10.7488) (20.8321, -10.7459), closed, covered)
  P18_DCP_L3_h115 = polyline(z=-1.27mm, xy in mm: (23.2014, -10.7459) (23.4189, -10.3679) (23.822, -10.2495) (24.0811, -10.3679) (24.3188, -10.7512) (24.0811, -11.1321) (23.678, -11.2505) (23.4189, -11.1321) (23.1812, -10.7488) (23.2014, -10.7459), closed, covered)
  P18_DCP_L3_h116 = polyline(z=-1.27mm, xy in mm: (26.7552, -10.7459) (26.9727, -10.3679) (27.3758, -10.2495) (27.635, -10.3679) (27.8727, -10.7512) (27.635, -11.1321) (27.2319, -11.2505) (26.9727, -11.1321) (26.735, -10.7488) (26.7552, -10.7459), closed, covered)
  P18_DCP_L3_h117 = polyline(z=-1.27mm, xy in mm: (30.3091, -10.7459) (30.5266, -10.3679) (30.9297, -10.2495) (31.1888, -10.3679) (31.4265, -10.7512) (31.1888, -11.1321) (30.7857, -11.2505) (30.5266, -11.1321) (30.2889, -10.7488) (30.3091, -10.7459), closed, covered)
  P18_DCP_L3_h118 = polyline(z=-1.27mm, xy in mm: (32.6783, -10.7459) (32.8958, -10.3679) (33.2989, -10.2495) (33.5581, -10.3679) (33.7957, -10.7512) (33.5581, -11.1321) (33.155, -11.2505) (32.8958, -11.1321) (32.6581, -10.7488) (32.6783, -10.7459), closed, covered)
  P18_DCP_L3_h119 = polyline(z=-1.27mm, xy in mm: (36.2321, -10.7459) (36.4496, -10.3679) (36.8527, -10.2495) (37.1119, -10.3679) (37.3496, -10.7512) (37.1119, -11.1321) (36.7088, -11.2505) (36.4496, -11.1321) (36.212, -10.7488) (36.2321, -10.7459), closed, covered)
  P18_DCP_L3_h120 = polyline(z=-1.27mm, xy in mm: (-2.852, -10.7247) (-2.6811, -10.3679) (-2.278, -10.2495) (-2.0189, -10.3679) (-1.8381, -10.7448) (-2.0189, -11.1321) (-2.278, -11.2505) (-2.6811, -11.1321) (-2.8619, -10.7552) (-2.852, -10.7247), closed, covered)
  P18_DCP_L3_h121 = polyline(z=-1.27mm, xy in mm: (-6.452, -10.7247) (-6.2811, -10.3679) (-5.878, -10.2495) (-5.6189, -10.3679) (-5.4381, -10.7448) (-5.6189, -11.1321) (-5.878, -11.2505) (-6.2811, -11.1321) (-6.4619, -10.7552) (-6.452, -10.7247), closed, covered)
  P18_DCP_L3_h122 = polyline(z=-1.27mm, xy in mm: (-5.252, -10.7247) (-5.0811, -10.3679) (-4.678, -10.2495) (-4.4189, -10.3679) (-4.2381, -10.7448) (-4.4189, -11.1321) (-4.678, -11.2505) (-5.0811, -11.1321) (-5.2619, -10.7552) (-5.252, -10.7247), closed, covered)
  P18_DCP_L3_h123 = polyline(z=-1.27mm, xy in mm: (-4.052, -10.7247) (-3.8811, -10.3679) (-3.478, -10.2495) (-3.2189, -10.3679) (-3.0381, -10.7448) (-3.2189, -11.1321) (-3.478, -11.2505) (-3.8811, -11.1321) (-4.0619, -10.7552) (-4.052, -10.7247), closed, covered)
  P18_DCP_L3_h124 = polyline(z=-1.27mm, xy in mm: (-1.652, -10.7247) (-1.4811, -10.3679) (-1.078, -10.2495) (-0.8189, -10.3679) (-0.6381, -10.7448) (-0.8189, -11.1321) (-1.078, -11.2505) (-1.4811, -11.1321) (-1.6619, -10.7552) (-1.652, -10.7247), closed, covered)
  P18_DCP_L3_h125 = polyline(z=-1.27mm, xy in mm: (-0.452, -10.7247) (-0.2811, -10.3679) (0.122, -10.2495) (0.3811, -10.3679) (0.5619, -10.7448) (0.3811, -11.1321) (0.122, -11.2505) (-0.2811, -11.1321) (-0.4619, -10.7552) (-0.452, -10.7247), closed, covered)
  P18_DCP_L3_h126 = polyline(z=-1.27mm, xy in mm: (0.748, -10.7247) (0.9189, -10.3679) (1.322, -10.2495) (1.5811, -10.3679) (1.7619, -10.7448) (1.5811, -11.1321) (1.322, -11.2505) (0.9189, -11.1321) (0.7381, -10.7552) (0.748, -10.7247), closed, covered)
  P18_DCP_L3_h127 = polyline(z=-1.27mm, xy in mm: (1.948, -10.7247) (2.1189, -10.3679) (2.522, -10.2495) (2.7811, -10.3679) (2.9619, -10.7448) (2.7811, -11.1321) (2.522, -11.2505) (2.1189, -11.1321) (1.9381, -10.7552) (1.948, -10.7247), closed, covered)
  P18_DCP_L3_h128 = polyline(z=-1.27mm, xy in mm: (3.148, -10.7247) (3.3189, -10.3679) (3.722, -10.2495) (3.9811, -10.3679) (4.1619, -10.7448) (3.9811, -11.1321) (3.722, -11.2505) (3.3189, -11.1321) (3.1381, -10.7552) (3.148, -10.7247), closed, covered)
  P18_DCP_L3_h129 = polyline(z=-1.27mm, xy in mm: (4.348, -10.7247) (4.5189, -10.3679) (4.922, -10.2495) (5.1811, -10.3679) (5.3619, -10.7448) (5.1811, -11.1321) (4.922, -11.2505) (4.5189, -11.1321) (4.3381, -10.7552) (4.348, -10.7247), closed, covered)
  P18_DCP_L3_h130 = polyline(z=-1.27mm, xy in mm: (5.548, -10.7247) (5.7189, -10.3679) (6.122, -10.2495) (6.4754, -10.4766) (6.5556, -10.75) (6.4754, -11.0234) (6.122, -11.2505) (5.7189, -11.1321) (5.5381, -10.7552) (5.548, -10.7247), closed, covered)
  P18_DCP_L3_h131 = polyline(z=-1.27mm, xy in mm: (1.2796, -15.5959) (1.5732, -14.8479) (2.1622, -14.3013) (2.6632, -14.1047) (3.4668, -14.1047) (3.9678, -14.3013) (4.5568, -14.8479) (4.8504, -15.5959) (4.8504, -16.1341) (4.5568, -16.8821) (4.1907, -17.2766) (3.4668, -17.6253) (2.9301, -17.6655) (2.1622, -17.4287) (1.7414, -17.0931) (1.3397, -16.3972) (1.2595, -15.865) (1.2796, -15.5959), closed, covered)
  P18_DCP_L3_h132 = polyline(z=-1.27mm, xy in mm: (7.1496, -15.5959) (7.4432, -14.8479) (8.0322, -14.3013) (8.5332, -14.1047) (9.3368, -14.1047) (9.8378, -14.3013) (10.4268, -14.8479) (10.7204, -15.5959) (10.7204, -16.1341) (10.4268, -16.8821) (10.0607, -17.2766) (9.3368, -17.6253) (8.8001, -17.6655) (8.0322, -17.4287) (7.6114, -17.0931) (7.2097, -16.3972) (7.1295, -15.865) (7.1496, -15.5959), closed, covered)
  P18_DCP_L3.subtract(P18_DCP_L3_h0..P18_DCP_L3_h132)
  P18_DCP_L3.sweep_along_vector((0mm, 0mm, 0.07mm))
  P19_DCP_L4 = polyline(z=-1.44mm, xy in mm: (-28.4908, 1.4689) (-28.45, 3.201) (-28.5184, 3.2952) (-37.951, 3.3) (-38.0452, 3.2316) (-38.05, 1.549) (-37.9816, 1.4548) (-28.549, 1.45) (-28.4908, 1.4689), closed, covered)
  P19_DCP_L4.sweep_along_vector((0mm, 0mm, 0.07mm))
  P20_DCP_L4 = polyline(z=-1.44mm, xy in mm: (-11.4759, 1.4689) (-11.44, 1.5796) (-11.5755, 1.8657) (-11.5755, 2.5243) (-11.4138, 2.9018) (-11.5077, 2.9695) (-12.1597, 2.9724) (-12.5805, 3.3) (-13.1745, 3.3) (-13.4657, 3.1495) (-13.8632, 3.1559) (-14.1055, 3.3) (-14.4857, 3.1495) (-14.8832, 3.1559) (-15.1255, 3.3) (-18.1152, 3.3) (-18.35, 3.2392) (-18.951, 3.3) (-19.0452, 3.2316) (-19.05, 1.549) (-18.9816, 1.4548) (-11.5341, 1.45) (-11.4759, 1.4689), closed, covered)
  P20_DCP_L4.sweep_along_vector((0mm, 0mm, 0.07mm))
  P21_DCP_L4 = polyline(z=-1.44mm, xy in mm: (19.0092, 1.4689) (19.05, 3.201) (18.9816, 3.2952) (9.549, 3.3) (9.4548, 3.2316) (9.45, 1.549) (9.5184, 1.4548) (18.951, 1.45) (19.0092, 1.4689), closed, covered)
  P21_DCP_L4.sweep_along_vector((0mm, 0mm, 0.07mm))
  P22_DCP_L4 = polyline(z=-1.44mm, xy in mm: (36.0241, 1.4689) (36.06, 1.5796) (35.9245, 1.8657) (35.9245, 2.5243) (36.0862, 2.9018) (35.9923, 2.9695) (35.3403, 2.9724) (34.9195, 3.3) (34.3255, 3.3) (34.0343, 3.1495) (33.6368, 3.1559) (33.3945, 3.3) (33.0143, 3.1495) (32.6168, 3.1559) (32.3745, 3.3) (29.3848, 3.3) (29.15, 3.2392) (28.549, 3.3) (28.4548, 3.2316) (28.45, 1.549) (28.5184, 1.4548) (35.9659, 1.45) (36.0241, 1.4689), closed, covered)
  P22_DCP_L4.sweep_along_vector((0mm, 0mm, 0.07mm))
  P23_DCP_L4 = polyline(z=-1.44mm, xy in mm: (-1.7908, -23.0311) (-1.7689, -14.5908) (-10.2092, -14.5689) (-10.2311, -23.0092) (-1.849, -23.05) (-1.7908, -23.0311), closed, covered)
  P23_DCP_L4.sweep_along_vector((0mm, 0mm, 0.07mm))
  P24_LSRC1_L1 [copper] = polyline(z=0.17mm, xy in mm: (-36.3943, 9.5189) (-36.3505, 10.9623) (-36.1153, 11.1975) (-35.1146, 11.2005) (-34.9004, 11.0685) (-34.8505, 9.599) (-34.7515, 9.5) (-34.2995, 9.5) (-34.2053, 9.5684) (-34.2005, 10.9612) (-34.1264, 11.1264) (-33.9611, 11.2005) (-33.3114, 11.1851) (-33.1495, 10.9611) (-33.1306, 9.5408) (-32.5995, 9.5) (-32.5005, 9.599) (-32.5005, 10.9612) (-32.4264, 11.1264) (-32.2611, 11.2005) (-30.4106, 11.2005) (-30.1964, 11.0685) (-30.0781, 10.7853) (-29.4231, 10.7805) (-29.15, 10.8608) (-28.7908, 10.7994) (-28.75, 11.2) (-28.65, 11.299) (-28.6689, 12.3592) (-43.6092, 12.3811) (-43.65, 11.299) (-43.5816, 11.2048) (-37.75, 11.2) (-37.7311, 9.5408) (-36.4525, 9.5) (-36.3943, 9.5189), closed, covered)
  P24_LSRC1_L1.sweep_along_vector((0mm, 0mm, 0.07mm))
  P25_LSRC1_L4 = polyline(z=-1.44mm, xy in mm: (-37.025, 13.225) (-37.025, 16.575) (-37.425, 16.575) (-37.425, 11.6) (-37.025, 11.6) (-37.025, 13.225), closed, covered)
  P25_LSRC1_L4.sweep_along_vector((0mm, 0mm, 0.07mm))
  P26_LSRC2_L1 [copper] = polyline(z=0.17mm, xy in mm: (-17.3943, 9.5189) (-17.3505, 10.9623) (-17.1153, 11.1975) (-15.2389, 11.2005) (-15.0736, 11.1264) (-14.9995, 10.9611) (-14.9995, 9.599) (-14.9005, 9.5) (-14.4495, 9.5) (-14.3553, 9.5684) (-14.3505, 10.9612) (-14.1886, 11.1851) (-13.5389, 11.2005) (-13.3736, 11.1264) (-13.2995, 10.9611) (-13.2806, 9.5408) (-12.7485, 9.5) (-12.6495, 9.599) (-12.5996, 11.0685) (-12.3854, 11.2005) (-11.3847, 11.1975) (-11.1495, 10.9623) (-11.1276, 9.5408) (-9.849, 9.5) (-9.75, 9.599) (-9.75, 11.2) (-3.949, 11.2) (-3.85, 11.299) (-3.85, 12.301) (-3.949, 12.4) (-18.751, 12.4) (-18.85, 12.301) (-18.85, 11.299) (-18.75, 11.2) (-18.7311, 9.5408) (-17.4525, 9.5) (-17.3943, 9.5189), closed, covered)
  P26_LSRC2_L1.sweep_along_vector((0mm, 0mm, 0.07mm))
  P27_LSRC2_L4 = polyline(z=-1.44mm, xy in mm: (-10.075, 13.225) (-10.075, 16.575) (-10.475, 16.575) (-10.475, 11.6) (-10.075, 11.6) (-10.075, 13.225), closed, covered)
  P27_LSRC2_L4.sweep_along_vector((0mm, 0mm, 0.07mm))
  P28_LSRC3_L1 [copper] = polyline(z=0.17mm, xy in mm: (11.1057, 9.5189) (11.1495, 10.9623) (11.3847, 11.1975) (12.3854, 11.2005) (12.5996, 11.0685) (12.6495, 9.599) (12.7485, 9.5) (13.2005, 9.5) (13.2947, 9.5684) (13.2995, 10.9612) (13.3736, 11.1264) (13.5389, 11.2005) (14.1886, 11.1851) (14.3505, 10.9611) (14.3694, 9.5408) (14.9005, 9.5) (14.9995, 9.599) (14.9995, 10.9612) (15.0736, 11.1264) (15.2389, 11.2005) (17.0894, 11.2005) (17.3036, 11.0685) (17.4219, 10.7853) (18.0769, 10.7805) (18.35, 10.8608) (18.7092, 10.7994) (18.75, 11.2) (18.85, 11.299) (18.8311, 12.3592) (3.8908, 12.3811) (3.85, 11.299) (3.9184, 11.2048) (9.75, 11.2) (9.7689, 9.5408) (11.0475, 9.5) (11.1057, 9.5189), closed, covered)
  P28_LSRC3_L1.sweep_along_vector((0mm, 0mm, 0.07mm))
  P29_LSRC3_L4 = polyline(z=-1.44mm, xy in mm: (10.475, 13.225) (10.475, 16.575) (10.075, 16.575) (10.075, 11.6) (10.475, 11.6) (10.475, 13.225), closed, covered)
  P29_LSRC3_L4.sweep_along_vector((0mm, 0mm, 0.07mm))
  P30_LSRC4_L1 [copper] = polyline(z=0.17mm, xy in mm: (30.1057, 9.5189) (30.1495, 10.9623) (30.3847, 11.1975) (32.2611, 11.2005) (32.4264, 11.1264) (32.5005, 10.9611) (32.5005, 9.599) (32.5995, 9.5) (33.0505, 9.5) (33.1447, 9.5684) (33.1495, 10.9612) (33.3114, 11.1851) (33.9611, 11.2005) (34.1264, 11.1264) (34.2005, 10.9611) (34.2194, 9.5408) (34.7515, 9.5) (34.8505, 9.599) (34.9004, 11.0685) (35.1146, 11.2005) (36.1153, 11.1975) (36.3505, 10.9623) (36.3724, 9.5408) (37.651, 9.5) (37.75, 9.599) (37.75, 11.2) (43.551, 11.2) (43.65, 11.299) (43.65, 12.301) (43.551, 12.4) (28.749, 12.4) (28.65, 12.301) (28.65, 11.299) (28.75, 11.2) (28.7689, 9.5408) (30.0475, 9.5) (30.1057, 9.5189), closed, covered)
  P30_LSRC4_L1.sweep_along_vector((0mm, 0mm, 0.07mm))
  P31_LSRC4_L4 = polyline(z=-1.44mm, xy in mm: (37.425, 13.225) (37.425, 16.575) (37.025, 16.575) (37.025, 11.6) (37.425, 11.6) (37.425, 13.225), closed, covered)
  P31_LSRC4_L4.sweep_along_vector((0mm, 0mm, 0.07mm))
  P32_AC_L1 [copper] = polyline(z=0.17mm, xy in mm: (43.9092, 39.3189) (43.95, 52.3968) (43.8204, 52.4909) (43.2937, 51.9012) (42.6011, 51.6143) (41.8539, 51.6731) (41.2148, 52.0648) (40.8231, 52.7039) (40.7643, 53.4511) (41.0512, 54.1437) (41.6382, 54.6631) (41.5545, 54.7997) (-41.5468, 54.8) (-41.6409, 54.6704) (-41.0512, 54.1437) (-40.7643, 53.4511) (-40.8231, 52.7039) (-41.2148, 52.0648) (-41.8539, 51.6731) (-42.6011, 51.6143) (-43.2937, 51.9012) (-43.8131, 52.4882) (-43.9497, 52.4045) (-43.95, 39.399) (-43.8816, 39.3048) (-43.65, 39.3) (-43.65, 20.899) (-43.551, 20.8) (-38.0593, 20.8) (-37.9652, 20.8684) (-37.9889, 22.8282) (-37.8782, 22.9389) (-37.349, 22.9505) (-37.25, 23.0495) (-37.2689, 23.418) (-37.5365, 23.5623) (-37.8277, 23.8535) (-38.0056, 24.44) (-37.8277, 25.0265) (-37.25, 25.5182) (-37.25, 39.3) (-10.25, 39.3) (-10.25, 25.5895) (-10.1816, 25.4953) (-9.6218, 25.4789) (-9.4995, 25.3097) (-9.5111, 23.5118) (-9.6218, 23.4011) (-10.151, 23.3895) (-10.25, 23.2905) (-10.2311, 22.922) (-9.8036, 22.6464) (-9.5147, 22.1059) (-9.5748, 21.496) (-9.8036, 21.1536) (-10.0733, 20.9422) (-9.9842, 20.8) (-3.949, 20.8) (-3.8548, 20.8684) (-3.85, 39.3) (3.85, 39.3) (3.85, 20.899) (3.949, 20.8) (9.4407, 20.8) (9.5348, 20.8684) (9.5111, 22.8282) (9.6218, 22.9389) (10.151, 22.9505) (10.25, 23.0495) (10.2311, 23.418) (9.9635, 23.5623) (9.6723, 23.8535) (9.4944, 24.44) (9.6723, 25.0265) (10.25, 25.5182) (10.25, 39.3) (37.25, 39.3) (37.25, 25.5895) (37.3184, 25.4953) (37.8782, 25.4789) (38.0005, 25.3097) (37.9889, 23.5118) (37.8782, 23.4011) (37.349, 23.3895) (37.25, 23.2905) (37.2689, 22.922) (37.5365, 22.7777) (37.8277, 22.4865) (38.0056, 21.9) (37.8277, 21.3136) (37.4183, 20.8816) (37.5158, 20.8) (43.551, 20.8) (43.65, 20.899) (43.65, 39.3) (43.851, 39.3) (43.9092, 39.3189), closed, covered)
  P32_AC_L1.sweep_along_vector((0mm, 0mm, 0.07mm))
  P33_AC_L1 = polyline(z=0.17mm, xy in mm: (-36.3943, 5.2189) (-36.3505, 6.6623) (-36.1153, 6.8975) (-35.1146, 6.9005) (-34.9004, 6.7685) (-34.8505, 5.299) (-34.7515, 5.2) (-34.2995, 5.2) (-34.2053, 5.2684) (-34.2005, 6.6612) (-34.0386, 6.8851) (-33.3889, 6.9005) (-33.1649, 6.7386) (-33.1495, 5.299) (-33.0505, 5.2) (-32.5995, 5.2) (-32.5053, 5.2684) (-32.5005, 6.6612) (-32.3386, 6.8851) (-30.4106, 6.9005) (-30.1964, 6.7685) (-30.0781, 6.4853) (-29.4231, 6.4805) (-29.15, 6.5608) (-28.7908, 6.4994) (-28.7689, 8.8592) (-30.1057, 8.8811) (-30.1964, 7.3315) (-30.4106, 7.1995) (-31.3854, 7.1995) (-31.5175, 7.2494) (-31.6465, 7.4377) (-31.6684, 8.8592) (-32.2587, 8.8811) (-32.3149, 7.3614) (-32.4614, 7.2149) (-33.1112, 7.1995) (-33.2764, 7.2736) (-33.3505, 7.4389) (-33.3694, 8.8592) (-33.9005, 8.9) (-33.9995, 8.801) (-34.0149, 7.3614) (-34.1614, 7.2149) (-34.8112, 7.1995) (-34.9764, 7.2736) (-35.0505, 7.4389) (-35.0505, 8.801) (-35.1189, 8.8952) (-37.7092, 8.8811) (-37.7311, 5.2408) (-36.4525, 5.2) (-36.3943, 5.2189), closed, covered)
  P33_AC_L1.sweep_along_vector((0mm, 0mm, 0.07mm))
  P34_AC_L1 = polyline(z=0.17mm, xy in mm: (-17.3943, 5.2189) (-17.3505, 6.6623) (-17.2215, 6.8506) (-17.0894, 6.9005) (-15.2389, 6.9005) (-15.0736, 6.8264) (-14.9995, 6.6611) (-14.9995, 5.299) (-14.9005, 5.2) (-14.4495, 5.2) (-14.3553, 5.2684) (-14.3505, 6.6612) (-14.1886, 6.8851) (-13.5389, 6.9005) (-13.3736, 6.8264) (-13.2995, 6.6611) (-13.2806, 5.2408) (-12.7485, 5.2) (-12.6495, 5.299) (-12.5996, 6.7685) (-12.3854, 6.9005) (-11.3847, 6.8975) (-11.1495, 6.6623) (-11.1276, 5.2408) (-9.7908, 5.2189) (-9.7689, 8.8592) (-12.4087, 8.8811) (-12.4495, 7.4388) (-12.5236, 7.2736) (-12.6889, 7.1995) (-13.3386, 7.2149) (-13.4851, 7.3614) (-13.5005, 8.801) (-13.5995, 8.9) (-14.0505, 8.9) (-14.1447, 8.8316) (-14.1495, 7.4388) (-14.3114, 7.2149) (-14.9612, 7.1995) (-15.1851, 7.3614) (-15.2005, 8.801) (-15.2995, 8.9) (-15.7515, 8.9) (-15.8457, 8.8316) (-15.9029, 8.6191) (-15.8535, 7.4377) (-16.0887, 7.2025) (-17.1153, 7.2025) (-17.3036, 7.3315) (-17.3724, 7.5787) (-17.4525, 7.6195) (-18.0769, 7.6195) (-18.35, 7.5392) (-18.7092, 7.6006) (-18.7311, 5.2408) (-17.4525, 5.2) (-17.3943, 5.2189), closed, covered)
  P34_AC_L1.sweep_along_vector((0mm, 0mm, 0.07mm))
  P35_AC_L1 = polyline(z=0.17mm, xy in mm: (11.1057, 5.2189) (11.1495, 6.6623) (11.3847, 6.8975) (12.3854, 6.9005) (12.5996, 6.7685) (12.6495, 5.299) (12.7485, 5.2) (13.2005, 5.2) (13.2947, 5.2684) (13.2995, 6.6612) (13.4614, 6.8851) (14.1111, 6.9005) (14.3351, 6.7386) (14.3505, 5.299) (14.4495, 5.2) (14.9005, 5.2) (14.9947, 5.2684) (14.9995, 6.6612) (15.1614, 6.8851) (17.0894, 6.9005) (17.3036, 6.7685) (17.4219, 6.4853) (18.0769, 6.4805) (18.35, 6.5608) (18.7092, 6.4994) (18.7311, 8.8592) (17.3943, 8.8811) (17.3036, 7.3315) (17.0894, 7.1995) (16.1146, 7.1995) (15.9825, 7.2494) (15.8535, 7.4377) (15.8316, 8.8592) (15.2413, 8.8811) (15.1851, 7.3614) (15.0386, 7.2149) (14.3888, 7.1995) (14.2236, 7.2736) (14.1495, 7.4389) (14.1306, 8.8592) (13.5995, 8.9) (13.5005, 8.801) (13.4851, 7.3614) (13.3386, 7.2149) (12.6888, 7.1995) (12.5236, 7.2736) (12.4495, 7.4389) (12.4495, 8.801) (12.3811, 8.8952) (9.7908, 8.8811) (9.7689, 5.2408) (11.0475, 5.2) (11.1057, 5.2189), closed, covered)
  P35_AC_L1.sweep_along_vector((0mm, 0mm, 0.07mm))
  P36_AC_L1 = polyline(z=0.17mm, xy in mm: (30.1057, 5.2189) (30.1495, 6.6623) (30.2785, 6.8506) (30.4106, 6.9005) (32.2611, 6.9005) (32.4264, 6.8264) (32.5005, 6.6611) (32.5005, 5.299) (32.5995, 5.2) (33.0505, 5.2) (33.1447, 5.2684) (33.1495, 6.6612) (33.3114, 6.8851) (33.9611, 6.9005) (34.1264, 6.8264) (34.2005, 6.6611) (34.2194, 5.2408) (34.7515, 5.2) (34.8505, 5.299) (34.9004, 6.7685) (35.1146, 6.9005) (36.1153, 6.8975) (36.3505, 6.6623) (36.3724, 5.2408) (37.7092, 5.2189) (37.7311, 8.8592) (35.0913, 8.8811) (35.0505, 7.4388) (34.9764, 7.2736) (34.8111, 7.1995) (34.1614, 7.2149) (34.0149, 7.3614) (33.9995, 8.801) (33.9005, 8.9) (33.4495, 8.9) (33.3553, 8.8316) (33.3505, 7.4388) (33.1886, 7.2149) (32.5388, 7.1995) (32.3149, 7.3614) (32.2995, 8.801) (32.2005, 8.9) (31.7485, 8.9) (31.6543, 8.8316) (31.5971, 8.6191) (31.6465, 7.4377) (31.4113, 7.2025) (30.3847, 7.2025) (30.1964, 7.3315) (30.1276, 7.5787) (30.0475, 7.6195) (29.4231, 7.6195) (29.15, 7.5392) (28.7908, 7.6006) (28.7689, 5.2408) (30.0475, 5.2) (30.1057, 5.2189), closed, covered)
  P36_AC_L1.sweep_along_vector((0mm, 0mm, 0.07mm))
  P37_AC_L2 = polyline(z=0mm, xy in mm: (43.9092, 39.3189) (43.95, 52.3968) (43.8204, 52.4909) (43.2937, 51.9012) (42.6011, 51.6143) (41.8539, 51.6731) (41.2148, 52.0648) (40.8231, 52.7039) (40.7643, 53.4511) (41.0512, 54.1437) (41.6382, 54.6631) (41.5545, 54.7997) (-41.5468, 54.8) (-41.6409, 54.6704) (-41.0512, 54.1437) (-40.7643, 53.4511) (-40.8231, 52.7039) (-41.2148, 52.0648) (-41.8539, 51.6731) (-42.6011, 51.6143) (-43.2937, 51.9012) (-43.8131, 52.4882) (-43.9497, 52.4045) (-43.95, 39.399) (-43.8816, 39.3048) (-43.65, 39.3) (-43.65, 20.9045) (-43.551, 20.8055) (-38.063, 20.8055) (-37.9688, 20.8739) (-37.9889, 22.8282) (-37.8782, 22.9389) (-37.349, 22.9505) (-37.25, 23.0495) (-37.2689, 23.418) (-37.5365, 23.5623) (-37.8277, 23.8535) (-38.0056, 24.44) (-37.8277, 25.0265) (-37.25, 25.5182) (-37.25, 39.3) (-10.25, 39.3) (-10.25, 25.5895) (-10.1816, 25.4953) (-9.6218, 25.4789) (-9.4995, 25.3097) (-9.5111, 23.5118) (-9.6218, 23.4011) (-10.151, 23.3895) (-10.25, 23.2905) (-10.2311, 22.922) (-9.8036, 22.6464) (-9.5147, 22.1059) (-9.5748, 21.496) (-9.8036, 21.1536) (-10.0733, 20.9422) (-9.9842, 20.8) (-3.949, 20.8055) (-3.8548, 20.8739) (-3.85, 39.3) (3.85, 39.3) (3.85, 22.5503) (3.9249, 22.4543) (6.185, 21.8739) (6.3178, 21.6909) (6.3255, 20.9045) (6.3939, 20.8103) (8.0044, 20.8) (9.4989, 20.8189) (9.5111, 22.8282) (9.6218, 22.9389) (10.151, 22.9505) (10.25, 23.0495) (10.2311, 23.418) (9.9635, 23.5623) (9.6723, 23.8535) (9.4944, 24.44) (9.6723, 25.0265) (10.25, 25.5182) (10.25, 39.3) (37.25, 39.3) (37.25, 25.5895) (37.3184, 25.4953) (37.8782, 25.4789) (38.0005, 25.3097) (37.9889, 23.5118) (37.8782, 23.4011) (37.349, 23.3895) (37.25, 23.2905) (37.2689, 22.922) (37.5365, 22.7777) (37.8277, 22.4865) (38.0056, 21.9) (37.8277, 21.3136) (37.4183, 20.8816) (37.5158, 20.8) (43.551, 20.8) (43.65, 20.899) (43.65, 39.3) (43.851, 39.3) (43.9092, 39.3189), closed, covered)
  P37_AC_L2.sweep_along_vector((0mm, 0mm, 0.07mm))
  P38_AC_L3 = polyline(z=-1.27mm, xy in mm: (43.9092, 39.3189) (43.95, 52.3968) (43.8204, 52.4909) (43.2937, 51.9012) (42.6011, 51.6143) (41.8539, 51.6731) (41.2148, 52.0648) (40.8231, 52.7039) (40.7643, 53.4511) (41.0512, 54.1437) (41.6382, 54.6631) (41.5545, 54.7997) (-41.605, 54.7811) (-41.605, 54.6209) (-41.0512, 54.1437) (-40.7643, 53.4511) (-40.8231, 52.7039) (-41.2148, 52.0648) (-41.8539, 51.6731) (-42.6011, 51.6143) (-43.2937, 51.9012) (-43.8131, 52.4882) (-43.9497, 52.4045) (-43.95, 39.399) (-43.8816, 39.3048) (-43.65, 39.3) (-43.6311, 20.1444) (-43.5204, 20.1084) (-43.078, 20.2505) (-42.6724, 19.992) (-42.3601, 20.21) (-42.078, 20.2505) (-41.6724, 19.992) (-41.3601, 20.21) (-41.078, 20.2505) (-40.6724, 19.992) (-40.3601, 20.21) (-40.078, 20.2505) (-39.6724, 19.992) (-39.3601, 20.21) (-39.078, 20.2505) (-38.6724, 19.992) (-38.3601, 20.21) (-38.078, 20.2505) (-37.6724, 19.992) (-37.3601, 20.21) (-37.078, 20.2505) (-36.6724, 19.992) (-36.3601, 20.21) (-36.078, 20.2505) (-35.6724, 19.992) (-35.3601, 20.21) (-35.078, 20.2505) (-34.6724, 19.992) (-34.3601, 20.21) (-34.078, 20.2505) (-33.6724, 19.992) (-33.3601, 20.21) (-33.078, 20.2505) (-32.6724, 19.992) (-32.3601, 20.21) (-32.078, 20.2505) (-31.6724, 19.992) (-31.3601, 20.21) (-31.078, 20.2505) (-30.6724, 19.992) (-30.3601, 20.21) (-30.078, 20.2505) (-29.8189, 20.1321) (-29.6648, 19.8925) (-29.6648, 19.6075) (-29.7803, 19.3835) (-29.6444, 19) (-29.7246, 18.7266) (-30.078, 18.4995) (-30.3601, 18.54) (-30.6276, 18.758) (-31.078, 18.4995) (-31.3601, 18.54) (-31.6276, 18.758) (-32.078, 18.4995) (-32.3601, 18.54) (-32.6276, 18.758) (-33.078, 18.4995) (-33.3601, 18.54) (-33.6276, 18.758) (-34.078, 18.4995) (-34.3601, 18.54) (-34.6276, 18.758) (-35.078, 18.4995) (-35.3601, 18.54) (-35.6276, 18.758) (-36.078, 18.4995) (-36.3601, 18.54) (-36.6276, 18.758) (-37.078, 18.4995) (-37.3601, 18.54) (-37.6276, 18.758) (-38.078, 18.4995) (-38.3601, 18.54) (-38.6276, 18.758) (-39.078, 18.4995) (-39.3601, 18.54) (-39.6276, 18.758) (-40.078, 18.4995) (-40.3601, 18.54) (-40.6276, 18.758) (-41.078, 18.4995) (-41.3601, 18.54) (-41.6276, 18.758) (-42.078, 18.4995) (-42.3601, 18.54) (-42.6276, 18.758) (-43.078, 18.4995) (-43.6021, 18.6322) (-43.65, 15.9526) (-43.5816, 15.8584) (-43.078, 16.0005) (-42.6115, 15.7472) (-42.3601, 15.96) (-42.078, 16.0005) (-41.6724, 15.742) (-41.3601, 15.96) (-41.078, 16.0005) (-40.6724, 15.742) (-40.3601, 15.96) (-40.078, 16.0005) (-39.6724, 15.742) (-39.3601, 15.96) (-39.078, 16.0005) (-38.8189, 15.8821) (-38.6648, 15.6425) (-38.7248, 15.0736) (-38.6115, 15.0472) (-38.3601, 15.26) (-38.078, 15.3005) (-37.7246, 15.0734) (-37.6444, 14.8) (-37.7246, 14.5266) (-38.078, 14.2995) (-38.3601, 14.34) (-38.6276, 14.558) (-38.7348, 14.5148) (-38.6444, 14.1) (-38.7587, 13.7585) (-38.6444, 13.4) (-38.7246, 13.1266) (-38.9399, 12.94) (-39.3601, 12.94) (-39.6276, 13.158) (-40.078, 12.8995) (-40.3601, 12.94) (-40.6276, 13.158) (-41.078, 12.8995) (-41.3601, 12.94) (-41.6276, 13.158) (-42.078, 12.8995) (-42.3601, 12.94) (-42.6276, 13.158) (-43.078, 12.8995) (-43.5425, 13.046) (-43.6422, 12.9859) (-43.6311, 5.2408) (-30.3251, 5.2) (-30.1012, 5.4285) (-29.848, 5.5108) (-29.5948, 5.4285) (-29.4159, 5.2108) (-29.1548, 5.2684) (-29.1689, 5.6728) (-29.4985, 5.8768) (-29.5808, 6.13) (-29.4985, 6.3832) (-29.1512, 6.6299) (-29.15, 9.9146) (-29.4985, 10.1768) (-29.5808, 10.43) (-29.4985, 10.6832) (-29.15, 10.9454) (-29.15, 21.7604) (-29.2556, 22.1) (-29.15, 22.4396) (-29.15, 33.301) (-29.249, 33.4) (-37.25, 33.4) (-37.25, 39.3) (-10.25, 39.3) (-10.25, 33.4) (-18.251, 33.4) (-18.3452, 33.3316) (-18.35, 22.4396) (-18.2444, 22.1) (-18.35, 21.7604) (-18.3311, 16.0375) (-17.8724, 15.742) (-17.422, 16.0005) (-17.1399, 15.96) (-16.8724, 15.742) (-16.422, 16.0005) (-16.0189, 15.8821) (-15.8444, 15.5) (-15.9587, 15.1585) (-15.8444, 14.8) (-15.9448, 14.3989) (-15.8115, 14.3472) (-15.422, 14.6005) (-15.0189, 14.4821) (-14.8648, 14.2425) (-14.8648, 13.9575) (-14.9587, 13.7585) (-14.8724, 13.642) (-14.422, 13.9005) (-14.1399, 13.86) (-13.8724, 13.642) (-13.422, 13.9005) (-13.1399, 13.86) (-12.8724, 13.642) (-12.5601, 13.86) (-12.278, 13.9005) (-11.9246, 13.6734) (-11.8444, 13.4) (-11.9246, 13.1266) (-12.278, 12.8995) (-12.5601, 12.94) (-12.8276, 13.158) (-13.278, 12.8995) (-13.5601, 12.94) (-13.8276, 13.158) (-14.278, 12.8995) (-14.5601, 12.94) (-14.8276, 13.158) (-15.278, 12.8995) (-15.5601, 12.94) (-15.8276, 13.158) (-16.278, 12.8995) (-16.5601, 12.94) (-16.8276, 13.158) (-17.1399, 12.94) (-17.422, 12.8995) (-17.8276, 13.158) (-18.3294, 12.8647) (-18.35, 8.4854) (-18.0015, 8.2232) (-17.9192, 7.97) (-18.0015, 7.7168) (-18.3488, 7.4701) (-18.35, 5.299) (-18.251, 5.2) (-3.949, 5.2) (-3.8548, 5.2684) (-3.8689, 13.0056) (-3.9796, 13.0416) (-4.422, 12.8995) (-4.8276, 13.158) (-5.1399, 12.94) (-5.422, 12.8995) (-5.8276, 13.158) (-6.1399, 12.94) (-6.422, 12.8995) (-6.8276, 13.158) (-7.1399, 12.94) (-7.422, 12.8995) (-7.8276, 13.158) (-8.1399, 12.94) (-8.5601, 12.94) (-8.7754, 13.1266) (-8.8556, 13.4) (-8.7413, 13.7415) (-8.8556, 14.1) (-8.7552, 14.5011) (-8.8885, 14.5528) (-9.1399, 14.34) (-9.422, 14.2995) (-9.7754, 14.5266) (-9.8556, 14.8) (-9.7754, 15.0734) (-9.422, 15.3005) (-9.1399, 15.26) (-8.8724, 15.042) (-8.7752, 15.0736) (-8.8352, 15.6425) (-8.6811, 15.8821) (-8.422, 16.0005) (-8.1399, 15.96) (-7.8724, 15.742) (-7.422, 16.0005) (-7.1399, 15.96) (-6.8724, 15.742) (-6.422, 16.0005) (-6.1399, 15.96) (-5.8724, 15.742) (-5.422, 16.0005) (-5.1399, 15.96) (-4.8724, 15.742) (-4.422, 16.0005) (-3.8979, 15.8678) (-3.8689, 18.6056) (-3.9796, 18.6416) (-4.422, 18.4995) (-4.8276, 18.758)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, closed, covered)
  P38_AC_L3_h0 = polyline(z=-1.27mm, xy in mm: (-30.7597, 31.0581) (-30.6032, 31.2735) (-30.2169, 31.3347) (-30.0015, 31.1782) (-29.9403, 30.7919) (-30.0968, 30.5765) (-30.35, 30.4942) (-30.6032, 30.5765) (-30.7808, 30.925) (-30.7597, 31.0581), closed, covered)
  P38_AC_L3_h1 = polyline(z=-1.27mm, xy in mm: (-17.5597, 31.0581) (-17.4032, 31.2735) (-17.0169, 31.3347) (-16.8015, 31.1782) (-16.7403, 30.7919) (-16.8968, 30.5765) (-17.15, 30.4942) (-17.4032, 30.5765) (-17.5808, 30.925) (-17.5597, 31.0581), closed, covered)
  P38_AC_L3_h2 = polyline(z=-1.27mm, xy in mm: (16.7403, 31.0581) (16.8968, 31.2735) (17.2831, 31.3347) (17.4985, 31.1782) (17.5597, 30.7919) (17.4032, 30.5765) (17.15, 30.4942) (16.8968, 30.5765) (16.7192, 30.925) (16.7403, 31.0581), closed, covered)
  P38_AC_L3_h3 = polyline(z=-1.27mm, xy in mm: (29.9403, 31.0581) (30.0968, 31.2735) (30.4831, 31.3347) (30.6985, 31.1782) (30.7597, 30.7919) (30.6032, 30.5765) (30.35, 30.4942) (30.0968, 30.5765) (29.9192, 30.925) (29.9403, 31.0581), closed, covered)
  P38_AC_L3_h4 = polyline(z=-1.27mm, xy in mm: (-34.9847, 30.4831) (-34.8282, 30.6985) (-34.4419, 30.7597) (-34.2265, 30.6032) (-34.1653, 30.2169) (-34.3218, 30.0015) (-34.575, 29.9192) (-34.8282, 30.0015) (-35.0058, 30.35) (-34.9847, 30.4831), closed, covered)
  P38_AC_L3_h5 = polyline(z=-1.27mm, xy in mm: (-13.1097, 30.4831) (-12.9532, 30.6985) (-12.5669, 30.7597) (-12.3515, 30.6032) (-12.2903, 30.2169) (-12.4468, 30.0015) (-12.7, 29.9192) (-12.9532, 30.0015) (-13.1308, 30.35) (-13.1097, 30.4831), closed, covered)
  P38_AC_L3_h6 = polyline(z=-1.27mm, xy in mm: (12.5153, 30.4831) (12.6718, 30.6985) (13.0581, 30.7597) (13.2735, 30.6032) (13.3347, 30.2169) (13.1782, 30.0015) (12.925, 29.9192) (12.6718, 30.0015) (12.4942, 30.35) (12.5153, 30.4831), closed, covered)
  P38_AC_L3_h7 = polyline(z=-1.27mm, xy in mm: (34.3903, 30.4831) (34.5468, 30.6985) (34.9331, 30.7597) (35.1485, 30.6032) (35.2097, 30.2169) (35.0532, 30.0015) (34.8, 29.9192) (34.5468, 30.0015) (34.3692, 30.35) (34.3903, 30.4831), closed, covered)
  P38_AC_L3_h8 = polyline(z=-1.27mm, xy in mm: (-34.1347, 26.2831) (-33.9782, 26.4985) (-33.5919, 26.5597) (-33.3765, 26.4032) (-33.3153, 26.0169) (-33.4718, 25.8015) (-33.725, 25.7192) (-34.0735, 25.8968) (-34.1558, 26.15) (-34.1347, 26.2831), closed, covered)
  P38_AC_L3_h9 = polyline(z=-1.27mm, xy in mm: (-14.1847, 26.2831) (-14.0282, 26.4985) (-13.6419, 26.5597) (-13.4265, 26.4032) (-13.3653, 26.0169) (-13.5218, 25.8015) (-13.775, 25.7192) (-14.0282, 25.8015) (-14.2058, 26.15) (-14.1847, 26.2831), closed, covered)
  P38_AC_L3_h10 = polyline(z=-1.27mm, xy in mm: (13.3653, 26.2831) (13.5218, 26.4985) (13.9081, 26.5597) (14.1235, 26.4032) (14.1847, 26.0169) (14.0282, 25.8015) (13.775, 25.7192) (13.5218, 25.8015) (13.3442, 26.15) (13.3653, 26.2831), closed, covered)
  P38_AC_L3_h11 = polyline(z=-1.27mm, xy in mm: (33.3153, 26.2831) (33.4718, 26.4985) (33.8581, 26.5597) (34.0735, 26.4032) (34.1347, 26.0169) (33.9782, 25.8015) (33.725, 25.7192) (33.4718, 25.8015) (33.2942, 26.15) (33.3153, 26.2831), closed, covered)
  P38_AC_L3_h12 = polyline(z=-1.27mm, xy in mm: (-11.6005, 25.3098) (-11.4198, 25.4905) (-9.6803, 25.4905) (-9.5554, 25.4346) (-9.4995, 25.3097) (-9.4995, 23.5703) (-9.5554, 23.4454) (-9.6802, 23.3895) (-11.4198, 23.3895) (-11.5445, 23.4454) (-11.6005, 23.5702) (-11.6005, 25.3097) (-11.6005, 25.3098), closed, covered)
  P38_AC_L3_h13 = polyline(z=-1.27mm, xy in mm: (35.8995, 25.3098) (36.0802, 25.4905) (37.8197, 25.4905) (37.9446, 25.4346) (38.0005, 25.3097) (38.0005, 23.5703) (37.9446, 23.4454) (37.8198, 23.3895) (36.0802, 23.3895) (35.9555, 23.4454) (35.8995, 23.5702) (35.8995, 25.3097) (35.8995, 25.3098), closed, covered)
  P38_AC_L3_h14 = polyline(z=-1.27mm, xy in mm: (-37.9853, 24.6459) (-37.8277, 25.0265) (-37.5365, 25.3177) (-37.1559, 25.4753) (-36.7441, 25.4753) (-36.3636, 25.3177) (-36.0723, 25.0264) (-35.9147, 24.6459) (-35.9147, 24.2341) (-36.0723, 23.8535) (-36.3635, 23.5623) (-36.95, 23.3844) (-37.354, 23.4648) (-37.6964, 23.6936) (-37.9252, 24.036) (-38.0056, 24.44) (-37.9853, 24.6459), closed, covered)
  P38_AC_L3_h15 = polyline(z=-1.27mm, xy in mm: (9.5147, 24.6459) (9.6723, 25.0265) (9.9635, 25.3177) (10.3441, 25.4753) (10.7559, 25.4753) (11.1364, 25.3177) (11.4277, 25.0264) (11.5853, 24.6459) (11.5853, 24.2341) (11.4277, 23.8535) (11.1365, 23.5623) (10.55, 23.3844) (10.146, 23.4648) (9.8036, 23.6936) (9.5748, 24.036) (9.4944, 24.44) (9.5147, 24.6459), closed, covered)
  P38_AC_L3_h16 = polyline(z=-1.27mm, xy in mm: (-38.0005, 22.7698) (-37.8198, 22.9505) (-36.0803, 22.9505) (-35.9554, 22.8946) (-35.8995, 22.7697) (-35.8995, 21.0303) (-35.9554, 20.9054) (-36.0802, 20.8495) (-37.8198, 20.8495) (-37.9445, 20.9054) (-38.0005, 21.0302) (-38.0005, 22.7697) (-38.0005, 22.7698), closed, covered)
  P38_AC_L3_h17 = polyline(z=-1.27mm, xy in mm: (9.4995, 22.7698) (9.6802, 22.9505) (11.4197, 22.9505) (11.5446, 22.8946) (11.6005, 22.7697) (11.6005, 21.0303) (11.5446, 20.9054) (11.4198, 20.8495) (9.6802, 20.8495) (9.5555, 20.9054) (9.4995, 21.0302) (9.4995, 22.7697) (9.4995, 22.7698), closed, covered)
  P38_AC_L3_h18 = polyline(z=-1.27mm, xy in mm: (-11.5853, 22.1059) (-11.4277, 22.4865) (-11.1365, 22.7777) (-10.7559, 22.9353) (-10.3441, 22.9353) (-9.9635, 22.7777) (-9.6723, 22.4865) (-9.5147, 22.1059) (-9.5147, 21.6941) (-9.6723, 21.3136) (-9.9635, 21.0223) (-10.55, 20.8444) (-10.954, 20.9248) (-11.2964, 21.1536) (-11.5252, 21.496) (-11.6056, 21.9) (-11.5853, 22.1059), closed, covered)
  P38_AC_L3_h19 = polyline(z=-1.27mm, xy in mm: (35.9147, 22.1059) (36.0723, 22.4865) (36.3635, 22.7777) (36.7441, 22.9353) (37.1559, 22.9353) (37.5365, 22.7777) (37.8277, 22.4865) (37.9853, 22.1059) (37.9853, 21.6941) (37.8277, 21.3136) (37.5365, 21.0223) (36.95, 20.8444) (36.546, 20.9248) (36.2036, 21.1536) (35.9748, 21.496) (35.8944, 21.9) (35.9147, 22.1059), closed, covered)
  P38_AC_L3_h20 = polyline(z=-1.27mm, xy in mm: (6.8648, 19.8925) (7.0189, 20.1321) (7.278, 20.2505) (7.5601, 20.21) (7.8276, 19.992) (8.278, 20.2505) (8.5601, 20.21) (8.8276, 19.992) (9.278, 20.2505) (9.5601, 20.21) (9.8276, 19.992) (10.278, 20.2505) (10.5601, 20.21) (10.8276, 19.992) (11.278, 20.2505) (11.5601, 20.21) (11.8276, 19.992) (12.278, 20.2505) (12.5601, 20.21) (12.8276, 19.992) (13.278, 20.2505) (13.5601, 20.21) (13.8276, 19.992) (14.278, 20.2505) (14.5601, 20.21) (14.8276, 19.992) (15.278, 20.2505) (15.5601, 20.21) (15.8276, 19.992) (16.278, 20.2505) (16.5601, 20.21) (16.8276, 19.992) (17.1399, 20.21) (17.422, 20.2505) (17.6811, 20.1321) (17.8352, 19.8925) (17.8352, 19.6075) (17.7197, 19.3835) (17.8556, 19) (17.7754, 18.7266) (17.422, 18.4995) (17.1399, 18.54) (16.8724, 18.758) (16.422, 18.4995) (16.1399, 18.54) (15.8724, 18.758) (15.422, 18.4995) (15.1399, 18.54) (14.8724, 18.758) (14.422, 18.4995) (14.1399, 18.54) (13.8724, 18.758) (13.422, 18.4995) (13.1399, 18.54) (12.8724, 18.758) (12.422, 18.4995) (12.1399, 18.54) (11.8724, 18.758) (11.422, 18.4995) (11.1399, 18.54) (10.8724, 18.758) (10.422, 18.4995) (10.1399, 18.54) (9.8724, 18.758) (9.422, 18.4995) (9.1399, 18.54) (8.8724, 18.758) (8.422, 18.4995) (8.1399, 18.54) (7.8724, 18.758) (7.5601, 18.54) (7.278, 18.4995) (7.0189, 18.6179) (6.8648, 18.8575) (6.8648, 19.1425) (6.9803, 19.3665) (6.8444, 19.75) (6.8648, 19.8925), closed, covered)
  P38_AC_L3_h21 = polyline(z=-1.27mm, xy in mm: (29.6648, 19.8925) (29.8189, 20.1321) (30.078, 20.2505) (30.3601, 20.21) (30.6276, 19.992) (31.078, 20.2505) (31.3601, 20.21) (31.6276, 19.992) (32.078, 20.2505) (32.3601, 20.21) (32.6276, 19.992) (33.078, 20.2505) (33.3601, 20.21) (33.6276, 19.992) (34.078, 20.2505) (34.3601, 20.21) (34.6276, 19.992) (35.078, 20.2505) (35.3601, 20.21) (35.6276, 19.992) (36.078, 20.2505) (36.3601, 20.21) (36.6276, 19.992) (37.078, 20.2505) (37.3601, 20.21) (37.6276, 19.992) (38.078, 20.2505) (38.3601, 20.21) (38.6276, 19.992) (39.078, 20.2505) (39.3601, 20.21) (39.6276, 19.992) (39.9399, 20.21) (40.222, 20.2505) (40.4811, 20.1321) (40.6352, 19.8925) (40.6352, 19.6075) (40.5197, 19.3835) (40.6556, 19) (40.5754, 18.7266) (40.222, 18.4995) (39.9399, 18.54) (39.6724, 18.758) (39.222, 18.4995) (38.9399, 18.54) (38.6724, 18.758) (38.222, 18.4995) (37.9399, 18.54) (37.6724, 18.758) (37.222, 18.4995) (36.9399, 18.54) (36.6724, 18.758) (36.222, 18.4995) (35.9399, 18.54) (35.6724, 18.758) (35.222, 18.4995) (34.9399, 18.54) (34.6724, 18.758) (34.222, 18.4995) (33.9399, 18.54) (33.6724, 18.758) (33.222, 18.4995) (32.9399, 18.54) (32.6724, 18.758) (32.222, 18.4995) (31.9399, 18.54) (31.6724, 18.758) (31.222, 18.4995) (30.9399, 18.54) (30.6724, 18.758) (30.3601, 18.54) (30.078, 18.4995) (29.8189, 18.6179) (29.6648, 18.8575) (29.6648, 19.1425) (29.7803, 19.3665) (29.6444, 19.75) (29.6648, 19.8925), closed, covered)
  P38_AC_L3_h22 = polyline(z=-1.27mm, xy in mm: (6.8648, 15.6425) (7.0189, 15.8821) (7.278, 16.0005) (7.5601, 15.96) (7.8276, 15.742) (8.1399, 15.96) (8.422, 16.0005) (8.6811, 15.8821) (8.8352, 15.6425) (8.7752, 15.0736) (8.8885, 15.0472) (9.1399, 15.26) (9.422, 15.3005) (9.7754, 15.0734) (9.8352, 14.6575) (9.5601, 14.34) (9.278, 14.2995) (8.8724, 14.558) (8.7652, 14.5148) (8.8556, 14.1) (8.7413, 13.7585) (8.8556, 13.4) (8.6811, 13.0179) (8.278, 12.8995) (7.8724, 13.158) (7.5601, 12.94) (7.278, 12.8995) (6.9246, 13.1266) (6.8444, 13.4) (6.9587, 13.7415) (6.8444, 14.1) (6.9587, 14.4415) (6.8444, 14.8) (6.9587, 15.1415) (6.8444, 15.5) (6.8648, 15.6425), closed, covered)
  P38_AC_L3_h23 = polyline(z=-1.27mm, xy in mm: (37.6648, 14.9425) (37.8189, 15.1821) (38.078, 15.3005) (38.3601, 15.26) (38.6276, 15.042) (38.7248, 15.0736) (38.6648, 15.6425) (38.9399, 15.96) (39.3601, 15.96) (39.6276, 15.742) (39.9399, 15.96) (40.3601, 15.96) (40.5754, 15.7734) (40.6556, 15.5) (40.5413, 15.1585) (40.6556, 14.8) (40.5413, 14.4585) (40.6556, 14.1) (40.5413, 13.7585) (40.6556, 13.4) (40.5754, 13.1266) (40.222, 12.8995) (39.9399, 12.94) (39.6724, 13.158) (39.3601, 12.94) (38.9399, 12.94) (38.7246, 13.1266) (38.6444, 13.4) (38.7587, 13.7415) (38.6444, 14.1) (38.7448, 14.5011) (38.6115, 14.5528) (38.3601, 14.34) (38.078, 14.2995) (37.7246, 14.5266) (37.6444, 14.8) (37.6648, 14.9425), closed, covered)
  P38_AC_L3_h24 = polyline(z=-1.27mm, xy in mm: (-35.6352, 13.5425) (-35.4811, 13.7821) (-35.222, 13.9005) (-34.9399, 13.86) (-34.6724, 13.642) (-34.222, 13.9005) (-33.9399, 13.86) (-33.6724, 13.642) (-33.3601, 13.86) (-33.078, 13.9005) (-32.6115, 13.6472) (-32.5413, 13.7415) (-32.6352, 13.9575) (-32.6352, 14.2425) (-32.4811, 14.4821) (-32.078, 14.6005) (-31.6724, 14.342) (-31.5652, 14.3852) (-31.6556, 14.8) (-31.5413, 15.1415) (-31.6556, 15.5) (-31.4811, 15.8821) (-31.078, 16.0005) (-30.6724, 15.742) (-30.3601, 15.96) (-30.078, 16.0005) (-29.8189, 15.8821) (-29.6648, 15.6425) (-29.6648, 15.3575) (-29.7587, 15.1585) (-29.6444, 14.8) (-29.7587, 14.4585) (-29.6444, 14.1) (-29.7587, 13.7585) (-29.6444, 13.4) (-29.7246, 13.1266) (-29.9399, 12.94) (-30.3601, 12.94) (-30.6276, 13.158) (-30.9399, 12.94) (-31.222, 12.8995) (-31.6276, 13.158) (-31.9399, 12.94) (-32.222, 12.8995) (-32.6276, 13.158) (-32.9399, 12.94) (-33.222, 12.8995) (-33.6276, 13.158) (-33.9399, 12.94) (-34.222, 12.8995) (-34.6276, 13.158) (-34.9399, 12.94) (-35.222, 12.8995) (-35.5754, 13.1266) (-35.6556, 13.4) (-35.6352, 13.5425), closed, covered)
  P38_AC_L3_h25 = polyline(z=-1.27mm, xy in mm: (11.8648, 13.5425) (12.0189, 13.7821) (12.278, 13.9005) (12.5601, 13.86) (12.8276, 13.642) (13.278, 13.9005) (13.5601, 13.86) (13.8276, 13.642) (14.1399, 13.86) (14.422, 13.9005) (14.8885, 13.6472) (14.9587, 13.7415) (14.8648, 13.9575) (14.8648, 14.2425) (15.0189, 14.4821) (15.422, 14.6005) (15.8276, 14.342) (15.9348, 14.3852) (15.8444, 14.8) (15.9587, 15.1415) (15.8444, 15.5) (16.0189, 15.8821) (16.422, 16.0005) (16.8276, 15.742) (17.1399, 15.96) (17.422, 16.0005) (17.6811, 15.8821) (17.8352, 15.6425) (17.8352, 15.3575) (17.7413, 15.1585) (17.8556, 14.8) (17.7413, 14.4585) (17.8556, 14.1) (17.7413, 13.7585) (17.8556, 13.4) (17.7754, 13.1266) (17.5601, 12.94) (17.1399, 12.94) (16.8724, 13.158) (16.5601, 12.94) (16.278, 12.8995) (15.8724, 13.158) (15.5601, 12.94) (15.278, 12.8995) (14.8724, 13.158) (14.5601, 12.94) (14.278, 12.8995) (13.8724, 13.158) (13.5601, 12.94) (13.278, 12.8995) (12.8724, 13.158) (12.5601, 12.94) (12.278, 12.8995) (11.9246, 13.1266) (11.8444, 13.4) (11.8648, 13.5425), closed, covered)
  P38_AC_L3_h26 = polyline(z=-1.27mm, xy in mm: (-37.7102, 11.9425) (-37.4351, 12.26) (-37.0149, 12.26) (-36.7398, 11.9425) (-36.7398, 11.6575) (-37.0149, 11.34) (-37.297, 11.2995) (-37.6504, 11.5266) (-37.7306, 11.8) (-37.7102, 11.9425), closed, covered)
  P38_AC_L3_h27 = polyline(z=-1.27mm, xy in mm: (-10.7602, 11.9425) (-10.4851, 12.26) (-10.0649, 12.26) (-9.7898, 11.9425) (-9.7898, 11.6575) (-10.0649, 11.34) (-10.347, 11.2995) (-10.7004, 11.5266) (-10.7806, 11.8) (-10.7602, 11.9425), closed, covered)
  P38_AC_L3_h28 = polyline(z=-1.27mm, xy in mm: (9.7898, 11.9425) (10.0649, 12.26) (10.4851, 12.26) (10.7602, 11.9425) (10.7602, 11.6575) (10.4851, 11.34) (10.203, 11.2995) (9.8496, 11.5266) (9.7694, 11.8) (9.7898, 11.9425), closed, covered)
  P38_AC_L3_h29 = polyline(z=-1.27mm, xy in mm: (36.7398, 11.9425) (37.0149, 12.26) (37.4351, 12.26) (37.7102, 11.9425) (37.7102, 11.6575) (37.4351, 11.34) (37.153, 11.2995) (36.7996, 11.5266) (36.7194, 11.8) (36.7398, 11.9425), closed, covered)
  P38_AC_L3_h30 = polyline(z=-1.27mm, xy in mm: (-30.2577, 9.5131) (-30.1012, 9.7285) (-29.7149, 9.7897) (-29.4995, 9.6332) (-29.4383, 9.2469) (-29.5948, 9.0315) (-29.848, 8.9492) (-30.1012, 9.0315) (-30.2788, 9.38) (-30.2577, 9.5131), closed, covered)
  P38_AC_L3_h31 = polyline(z=-1.27mm, xy in mm: (17.2423, 9.5131) (17.3988, 9.7285) (17.7851, 9.7897) (18.0005, 9.6332) (18.0617, 9.2469) (17.9052, 9.0315) (17.652, 8.9492) (17.3988, 9.0315) (17.2212, 9.38) (17.2423, 9.5131), closed, covered)
  P38_AC_L3_h32 = polyline(z=-1.27mm, xy in mm: (-18.0617, 9.1531) (-17.9052, 9.3685) (-17.5189, 9.4297) (-17.3035, 9.2732) (-17.2423, 8.8869) (-17.3988, 8.6715) (-17.652, 8.5892) (-17.9052, 8.6715) (-18.0828, 9.02) (-18.0617, 9.1531), closed, covered)
  P38_AC_L3_h33 = polyline(z=-1.27mm, xy in mm: (29.4383, 9.1531) (29.5948, 9.3685) (29.9811, 9.4297) (30.1965, 9.2732) (30.2577, 8.8869) (30.1012, 8.6715) (29.848, 8.5892) (29.5948, 8.6715) (29.4172, 9.02) (29.4383, 9.1531), closed, covered)
  P38_AC_L3.subtract(P38_AC_L3_h0..P38_AC_L3_h33)
  P38_AC_L3.sweep_along_vector((0mm, 0mm, 0.07mm))
  P39_AC_L4 = polyline(z=-1.44mm, xy in mm: (43.9092, 39.3189) (43.95, 52.3968) (43.8204, 52.4909) (43.2937, 51.9012) (42.6011, 51.6143) (41.8539, 51.6731) (41.2148, 52.0648) (40.8231, 52.7039) (40.7643, 53.4511) (41.0512, 54.1437) (41.6382, 54.6631) (41.5545, 54.7997) (-41.605, 54.7811) (-41.605, 54.6209) (-41.0512, 54.1437) (-40.7643, 53.4511) (-40.8231, 52.7039) (-41.2148, 52.0648) (-41.8539, 51.6731) (-42.6011, 51.6143) (-43.2937, 51.9012) (-43.8131, 52.4882) (-43.9497, 52.4045) (-43.95, 39.399) (-43.8816, 39.3048) (-43.65, 39.3) (-43.6311, 20.1444) (-43.5204, 20.1084) (-43.078, 20.2505) (-42.6724, 19.992) (-42.3601, 20.21) (-42.078, 20.2505) (-41.6724, 19.992) (-41.3601, 20.21) (-41.078, 20.2505) (-40.6724, 19.992) (-40.3601, 20.21) (-40.078, 20.2505) (-39.6724, 19.992) (-39.3601, 20.21) (-39.078, 20.2505) (-38.6724, 19.992) (-38.3601, 20.21) (-38.078, 20.2505) (-37.6724, 19.992) (-37.3601, 20.21) (-37.078, 20.2505) (-36.6724, 19.992) (-36.3601, 20.21) (-36.078, 20.2505) (-35.6724, 19.992) (-35.3601, 20.21) (-35.078, 20.2505) (-34.6724, 19.992) (-34.3601, 20.21) (-34.078, 20.2505) (-33.6724, 19.992) (-33.3601, 20.21) (-33.078, 20.2505) (-32.6724, 19.992) (-32.3601, 20.21) (-32.078, 20.2505) (-31.6724, 19.992) (-31.3601, 20.21) (-31.078, 20.2505) (-30.6724, 19.992) (-30.3601, 20.21) (-30.078, 20.2505) (-29.8189, 20.1321) (-29.6648, 19.8925) (-29.6648, 19.6075) (-29.7803, 19.3835) (-29.6444, 19) (-29.7246, 18.7266) (-30.078, 18.4995) (-30.3601, 18.54) (-30.6276, 18.758) (-31.078, 18.4995) (-31.3601, 18.54) (-31.6276, 18.758) (-32.078, 18.4995) (-32.3601, 18.54) (-32.6276, 18.758) (-33.078, 18.4995) (-33.3601, 18.54) (-33.6276, 18.758) (-34.078, 18.4995) (-34.3601, 18.54) (-34.6276, 18.758) (-35.078, 18.4995) (-35.3601, 18.54) (-35.6276, 18.758) (-36.078, 18.4995) (-36.3601, 18.54) (-36.6276, 18.758) (-37.078, 18.4995) (-37.3601, 18.54) (-37.6276, 18.758) (-38.078, 18.4995) (-38.3601, 18.54) (-38.6276, 18.758) (-39.078, 18.4995) (-39.3601, 18.54) (-39.6276, 18.758) (-40.078, 18.4995) (-40.3601, 18.54) (-40.6276, 18.758) (-41.078, 18.4995) (-41.3601, 18.54) (-41.6276, 18.758) (-42.078, 18.4995) (-42.3601, 18.54) (-42.6276, 18.758) (-43.078, 18.4995) (-43.6021, 18.6322) (-43.65, 15.9526) (-43.5816, 15.8584) (-43.078, 16.0005) (-42.6115, 15.7472) (-42.3601, 15.96) (-42.078, 16.0005) (-41.6724, 15.742) (-41.3601, 15.96) (-41.078, 16.0005) (-40.6724, 15.742) (-40.3601, 15.96) (-40.078, 16.0005) (-39.6724, 15.742) (-39.3601, 15.96) (-39.078, 16.0005) (-38.8189, 15.8821) (-38.6648, 15.6425) (-38.7248, 15.0736) (-38.6115, 15.0472) (-38.222, 15.3005) (-37.686, 15.1332) (-37.6255, 15.2244) (-37.6444, 15.6087) (-38.1597, 15.6524) (-38.4778, 15.8871) (-38.4778, 16.8629) (-38.1597, 17.0976) (-36.2903, 17.0976) (-36.0529, 16.9721) (-35.9274, 16.7347) (-35.9274, 16.0153) (-36.0867, 15.7294) (-36.0499, 15.619) (-35.3403, 15.5976) (-35.1029, 15.4721) (-34.9039, 15.2255) (-34.3627, 15.2255) (-34.0832, 15.4141) (-33.6368, 15.4141) (-33.3959, 15.1732) (-33.3895, 14.6757) (-33.4459, 14.5196) (-33.6368, 14.3859) (-34.0832, 14.3859) (-34.3627, 14.5745) (-34.9039, 14.5745) (-35.1029, 14.3278) (-35.3403, 14.2024) (-36.0505, 14.1806) (-36.0864, 14.0699) (-35.9245, 13.7543) (-35.9722, 12.9371) (-36.1621, 12.7472) (-36.7255, 12.6995) (-36.8197, 12.6311) (-36.7398, 11.6575) (-36.8939, 11.4179) (-37.153, 11.2995) (-37.4351, 11.34) (-37.7102, 11.6575) (-37.7102, 11.9425) (-37.6259, 12.1305) (-37.6444, 12.6587) (-38.2879, 12.7472) (-38.4778, 12.9371) (-38.5939, 13.2017) (-39.078, 12.8995) (-39.3601, 12.94) (-39.6276, 13.158) (-40.078, 12.8995) (-40.3601, 12.94) (-40.6276, 13.158) (-41.078, 12.8995) (-41.3601, 12.94) (-41.6276, 13.158) (-42.078, 12.8995) (-42.3601, 12.94) (-42.6276, 13.158) (-43.078, 12.8995) (-43.6021, 13.0322) (-43.6311, 4.6408) (-38.5663, 4.6189) (-38.5226, 5.0147) (-38.3971, 5.2522) (-38.1597, 5.3776) (-37.7245, 5.3805) (-37.6255, 5.4795) (-37.6444, 6.8387) (-38.2879, 6.9272) (-38.5226, 7.2453) (-38.4778, 8.0929) (-38.1293, 8.3305) (-36.1621, 8.2828) (-35.9245, 7.9343) (-35.9274, 7.2453) (-36.0862, 6.8982) (-35.9923, 6.8305) (-35.2121, 6.7828) (-34.9039, 6.4555) (-34.3627, 6.4555) (-34.0343, 6.6505) (-33.6368, 6.6441) (-33.3379, 6.4407) (-33.0143, 6.6505) (-32.6168, 6.6441) (-32.3373, 6.4555) (-29.4671, 6.4555) (-29.15, 6.5608) (-28.8968, 6.4785) (-28.7192, 6.13) (-28.8015, 5.8768) (-29.0169, 5.7203) (-29.4671, 5.8045) (-32.3373, 5.8045) (-32.6168, 5.6159) (-33.0143, 5.6095) (-33.3621, 5.8193) (-33.6368, 5.6159) (-34.0343, 5.6095) (-34.3627, 5.8045) (-34.9039, 5.8045) (-35.0988, 5.5633) (-35.0505, 5.4106) (-30.1651, 5.4055) (-29.848, 5.5108) (-29.5749, 5.4305) (-28.4995, 5.4305) (-28.4053, 5.4989) (-28.3754, 5.8927) (-28.2191, 6.0625) (-27.149, 6.1005) (-27.0548, 6.1689) (-27.0689, 7.9587) (-28.0793, 7.9959) (-28.2683, 8.0696) (-28.3945, 8.2628) (-28.4005, 8.9305) (-28.4689, 9.0247) (-29.5749, 9.0295) (-29.848, 8.9492) (-30.1651, 9.0545) (-39.0255, 9.0545) (-39.1197, 8.9861) (-39.1722, 8.4671) (-39.5207, 8.2295) (-41.3597, 8.2324) (-41.5971, 8.3578) (-41.7226, 8.5953) (-41.7226, 9.3147) (-41.5972, 9.5521) (-41.3597, 9.6776) (-40.9245, 9.6805) (-40.8255, 9.7795) (-40.8444, 11.1387) (-41.4879, 11.2272) (-41.7226, 11.5453) (-41.6778, 12.3929) (-41.3293, 12.6305) (-39.3621, 12.5828) (-39.1245, 12.2343) (-39.1274, 11.5453) (-39.2862, 11.1982) (-39.1923, 11.1305) (-38.4121, 11.0828) (-38.1039, 10.7555) (-34.3627, 10.7555) (-34.0343, 10.9505) (-33.6368, 10.9441) (-33.3379, 10.7407) (-33.0143, 10.9505) (-32.6168, 10.9441) (-32.3373, 10.7555) (-29.4671, 10.7555) (-29.15, 10.8608) (-28.8968, 10.7785) (-28.7403, 10.5631) (-28.7403, 10.2969) (-28.8968, 10.0815) (-29.15, 9.9992) (-29.4671, 10.1045) (-32.3373, 10.1045) (-32.6168, 9.9159) (-33.0143, 9.9095) (-33.3621, 10.1193) (-33.6368, 9.9159)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, closed, covered)
  P39_AC_L4_h0 = polyline(z=-1.44mm, xy in mm: (-35.3601, 12.94) (-35.5754, 13.1266) (-35.6556, 13.4) (-35.5754, 13.6734) (-35.3601, 13.86) (-34.9399, 13.86) (-34.6724, 13.642) (-34.3601, 13.86) (-34.078, 13.9005) (-33.6724, 13.642) (-33.3601, 13.86) (-33.078, 13.9005) (-32.6115, 13.6472) (-32.5413, 13.7415) (-32.6352, 13.9575) (-32.6352, 14.2425) (-32.4811, 14.4821) (-32.078, 14.6005) (-31.6724, 14.342) (-31.5752, 14.3736) (-31.6556, 14.8) (-31.5413, 15.1415) (-31.6556, 15.5) (-31.5754, 15.7734) (-31.3601, 15.96) (-30.9399, 15.96) (-30.6724, 15.742) (-30.3601, 15.96) (-30.078, 16.0005) (-29.7246, 15.7734) (-29.6444, 15.5) (-29.7587, 15.1585) (-29.6444, 14.8) (-29.7587, 14.4585) (-29.6444, 14.1) (-29.7587, 13.7585) (-29.6444, 13.4) (-29.7246, 13.1266) (-29.9399, 12.94) (-30.3601, 12.94) (-30.6276, 13.158) (-30.9399, 12.94) (-31.222, 12.8995) (-31.6276, 13.158) (-31.9399, 12.94) (-32.222, 12.8995) (-32.6276, 13.158) (-32.9399, 12.94) (-33.222, 12.8995) (-33.6276, 13.158) (-33.9399, 12.94) (-34.222, 12.8995) (-34.6276, 13.158) (-34.9399, 12.94) (-35.222, 12.8995) (-35.3601, 12.94), closed, covered)
  P39_AC_L4_h1 = polyline(z=-1.44mm, xy in mm: (12.1399, 12.94) (11.9246, 13.1266) (11.8444, 13.4) (11.9246, 13.6734) (12.1399, 13.86) (12.5601, 13.86) (12.8276, 13.642) (13.1399, 13.86) (13.422, 13.9005) (13.8276, 13.642) (14.1399, 13.86) (14.422, 13.9005) (14.8885, 13.6472) (14.9587, 13.7415) (14.8648, 13.9575) (14.8648, 14.2425) (15.0189, 14.4821) (15.422, 14.6005) (15.8276, 14.342) (15.9248, 14.3736) (15.8444, 14.8) (15.9587, 15.1415) (15.8444, 15.5) (15.9246, 15.7734) (16.1399, 15.96) (16.5601, 15.96) (16.8276, 15.742) (17.1399, 15.96) (17.422, 16.0005) (17.7754, 15.7734) (17.8556, 15.5) (17.7413, 15.1585) (17.8556, 14.8) (17.7413, 14.4585) (17.8556, 14.1) (17.7413, 13.7585) (17.8556, 13.4) (17.7754, 13.1266) (17.5601, 12.94) (17.1399, 12.94) (16.8724, 13.158) (16.5601, 12.94) (16.278, 12.8995) (15.8724, 13.158) (15.5601, 12.94) (15.278, 12.8995) (14.8724, 13.158) (14.5601, 12.94) (14.278, 12.8995) (13.8724, 13.158) (13.5601, 12.94) (13.278, 12.8995) (12.8724, 13.158) (12.5601, 12.94) (12.278, 12.8995) (12.1399, 12.94), closed, covered)
  P39_AC_L4_h2 = polyline(z=-1.44mm, xy in mm: (-30.7597, 31.0581) (-30.6032, 31.2735) (-30.2169, 31.3347) (-30.0015, 31.1782) (-29.9403, 30.7919) (-30.0968, 30.5765) (-30.35, 30.4942) (-30.6032, 30.5765) (-30.7808, 30.925) (-30.7597, 31.0581), closed, covered)
  P39_AC_L4_h3 = polyline(z=-1.44mm, xy in mm: (-17.5597, 31.0581) (-17.4032, 31.2735) (-17.0169, 31.3347) (-16.8015, 31.1782) (-16.7403, 30.7919) (-16.8968, 30.5765) (-17.15, 30.4942) (-17.4032, 30.5765) (-17.5808, 30.925) (-17.5597, 31.0581), closed, covered)
  P39_AC_L4_h4 = polyline(z=-1.44mm, xy in mm: (16.7403, 31.0581) (16.8968, 31.2735) (17.2831, 31.3347) (17.4985, 31.1782) (17.5597, 30.7919) (17.4032, 30.5765) (17.15, 30.4942) (16.8968, 30.5765) (16.7192, 30.925) (16.7403, 31.0581), closed, covered)
  P39_AC_L4_h5 = polyline(z=-1.44mm, xy in mm: (29.9403, 31.0581) (30.0968, 31.2735) (30.4831, 31.3347) (30.6985, 31.1782) (30.7597, 30.7919) (30.6032, 30.5765) (30.35, 30.4942) (30.0968, 30.5765) (29.9192, 30.925) (29.9403, 31.0581), closed, covered)
  P39_AC_L4_h6 = polyline(z=-1.44mm, xy in mm: (-34.9847, 30.4831) (-34.8282, 30.6985) (-34.4419, 30.7597) (-34.2265, 30.6032) (-34.1653, 30.2169) (-34.3218, 30.0015) (-34.575, 29.9192) (-34.8282, 30.0015) (-35.0058, 30.35) (-34.9847, 30.4831), closed, covered)
  P39_AC_L4_h7 = polyline(z=-1.44mm, xy in mm: (-13.1097, 30.4831) (-12.9532, 30.6985) (-12.5669, 30.7597) (-12.3515, 30.6032) (-12.2903, 30.2169) (-12.4468, 30.0015) (-12.7, 29.9192) (-12.9532, 30.0015) (-13.1308, 30.35) (-13.1097, 30.4831), closed, covered)
  P39_AC_L4_h8 = polyline(z=-1.44mm, xy in mm: (12.5153, 30.4831) (12.6718, 30.6985) (13.0581, 30.7597) (13.2735, 30.6032) (13.3347, 30.2169) (13.1782, 30.0015) (12.925, 29.9192) (12.6718, 30.0015) (12.4942, 30.35) (12.5153, 30.4831), closed, covered)
  P39_AC_L4_h9 = polyline(z=-1.44mm, xy in mm: (34.3903, 30.4831) (34.5468, 30.6985) (34.9331, 30.7597) (35.1485, 30.6032) (35.2097, 30.2169) (35.0532, 30.0015) (34.8, 29.9192) (34.5468, 30.0015) (34.3692, 30.35) (34.3903, 30.4831), closed, covered)
  P39_AC_L4_h10 = polyline(z=-1.44mm, xy in mm: (-34.1347, 26.2831) (-33.9782, 26.4985) (-33.5919, 26.5597) (-33.3765, 26.4032) (-33.3153, 26.0169) (-33.4718, 25.8015) (-33.725, 25.7192) (-34.0735, 25.8968) (-34.1558, 26.15) (-34.1347, 26.2831), closed, covered)
  P39_AC_L4_h11 = polyline(z=-1.44mm, xy in mm: (-14.1847, 26.2831) (-14.0282, 26.4985) (-13.6419, 26.5597) (-13.4265, 26.4032) (-13.3653, 26.0169) (-13.5218, 25.8015) (-13.775, 25.7192) (-14.0282, 25.8015) (-14.2058, 26.15) (-14.1847, 26.2831), closed, covered)
  P39_AC_L4_h12 = polyline(z=-1.44mm, xy in mm: (13.3653, 26.2831) (13.5218, 26.4985) (13.9081, 26.5597) (14.1235, 26.4032) (14.1847, 26.0169) (14.0282, 25.8015) (13.775, 25.7192) (13.5218, 25.8015) (13.3442, 26.15) (13.3653, 26.2831), closed, covered)
  P39_AC_L4_h13 = polyline(z=-1.44mm, xy in mm: (33.3153, 26.2831) (33.4718, 26.4985) (33.8581, 26.5597) (34.0735, 26.4032) (34.1347, 26.0169) (33.9782, 25.8015) (33.725, 25.7192) (33.4718, 25.8015) (33.2942, 26.15) (33.3153, 26.2831), closed, covered)
  P39_AC_L4_h14 = polyline(z=-1.44mm, xy in mm: (-11.6005, 25.3098) (-11.4198, 25.4905) (-9.6803, 25.4905) (-9.5554, 25.4346) (-9.4995, 25.3097) (-9.4995, 23.5703) (-9.5554, 23.4454) (-9.6802, 23.3895) (-11.4198, 23.3895) (-11.5445, 23.4454) (-11.6005, 23.5702) (-11.6005, 25.3097) (-11.6005, 25.3098), closed, covered)
  P39_AC_L4_h15 = polyline(z=-1.44mm, xy in mm: (35.8995, 25.3098) (36.0802, 25.4905) (37.8197, 25.4905) (37.9446, 25.4346) (38.0005, 25.3097) (38.0005, 23.5703) (37.9446, 23.4454) (37.8198, 23.3895) (36.0802, 23.3895) (35.9555, 23.4454) (35.8995, 23.5702) (35.8995, 25.3097) (35.8995, 25.3098), closed, covered)
  P39_AC_L4_h16 = polyline(z=-1.44mm, xy in mm: (-37.9853, 24.6459) (-37.8277, 25.0265) (-37.5365, 25.3177) (-37.1559, 25.4753) (-36.7441, 25.4753) (-36.3636, 25.3177) (-36.0723, 25.0264) (-35.9147, 24.6459) (-35.9147, 24.2341) (-36.0723, 23.8535) (-36.3635, 23.5623) (-36.95, 23.3844) (-37.354, 23.4648) (-37.6964, 23.6936) (-37.9252, 24.036) (-38.0056, 24.44) (-37.9853, 24.6459), closed, covered)
  P39_AC_L4_h17 = polyline(z=-1.44mm, xy in mm: (9.5147, 24.6459) (9.6723, 25.0265) (9.9635, 25.3177) (10.3441, 25.4753) (10.7559, 25.4753) (11.1364, 25.3177) (11.4277, 25.0264) (11.5853, 24.6459) (11.5853, 24.2341) (11.4277, 23.8535) (11.1365, 23.5623) (10.55, 23.3844) (10.146, 23.4648) (9.8036, 23.6936) (9.5748, 24.036) (9.4944, 24.44) (9.5147, 24.6459), closed, covered)
  P39_AC_L4_h18 = polyline(z=-1.44mm, xy in mm: (-38.0005, 22.7698) (-37.8198, 22.9505) (-36.0803, 22.9505) (-35.9554, 22.8946) (-35.8995, 22.7697) (-35.8995, 21.0303) (-35.9554, 20.9054) (-36.0802, 20.8495) (-37.8198, 20.8495) (-37.9445, 20.9054) (-38.0005, 21.0302) (-38.0005, 22.7697) (-38.0005, 22.7698), closed, covered)
  P39_AC_L4_h19 = polyline(z=-1.44mm, xy in mm: (9.4995, 22.7698) (9.6802, 22.9505) (11.4197, 22.9505) (11.5446, 22.8946) (11.6005, 22.7697) (11.6005, 21.0303) (11.5446, 20.9054) (11.4198, 20.8495) (9.6802, 20.8495) (9.5555, 20.9054) (9.4995, 21.0302) (9.4995, 22.7697) (9.4995, 22.7698), closed, covered)
  P39_AC_L4_h20 = polyline(z=-1.44mm, xy in mm: (-11.5853, 22.1059) (-11.4277, 22.4865) (-11.1365, 22.7777) (-10.7559, 22.9353) (-10.3441, 22.9353) (-9.9635, 22.7777) (-9.6723, 22.4865) (-9.5147, 22.1059) (-9.5147, 21.6941) (-9.6723, 21.3136) (-9.9635, 21.0223) (-10.55, 20.8444) (-10.954, 20.9248) (-11.2964, 21.1536) (-11.5252, 21.496) (-11.6056, 21.9) (-11.5853, 22.1059), closed, covered)
  P39_AC_L4_h21 = polyline(z=-1.44mm, xy in mm: (35.9147, 22.1059) (36.0723, 22.4865) (36.3635, 22.7777) (36.7441, 22.9353) (37.1559, 22.9353) (37.5365, 22.7777) (37.8277, 22.4865) (37.9853, 22.1059) (37.9853, 21.6941) (37.8277, 21.3136) (37.5365, 21.0223) (36.95, 20.8444) (36.546, 20.9248) (36.2036, 21.1536) (35.9748, 21.496) (35.8944, 21.9) (35.9147, 22.1059), closed, covered)
  P39_AC_L4_h22 = polyline(z=-1.44mm, xy in mm: (6.8648, 19.8925) (7.0189, 20.1321) (7.278, 20.2505) (7.5601, 20.21) (7.8276, 19.992) (8.278, 20.2505) (8.5601, 20.21) (8.8276, 19.992) (9.278, 20.2505) (9.5601, 20.21) (9.8276, 19.992) (10.278, 20.2505) (10.5601, 20.21) (10.8276, 19.992) (11.278, 20.2505) (11.5601, 20.21) (11.8276, 19.992) (12.278, 20.2505) (12.5601, 20.21) (12.8276, 19.992) (13.278, 20.2505) (13.5601, 20.21) (13.8276, 19.992) (14.278, 20.2505) (14.5601, 20.21) (14.8276, 19.992) (15.278, 20.2505) (15.5601, 20.21) (15.8276, 19.992) (16.278, 20.2505) (16.5601, 20.21) (16.8276, 19.992) (17.1399, 20.21) (17.422, 20.2505) (17.6811, 20.1321) (17.8352, 19.8925) (17.8352, 19.6075) (17.7197, 19.3835) (17.8556, 19) (17.7754, 18.7266) (17.422, 18.4995) (17.1399, 18.54) (16.8724, 18.758) (16.422, 18.4995) (16.1399, 18.54) (15.8724, 18.758) (15.422, 18.4995) (15.1399, 18.54) (14.8724, 18.758) (14.422, 18.4995) (14.1399, 18.54) (13.8724, 18.758) (13.422, 18.4995) (13.1399, 18.54) (12.8724, 18.758) (12.422, 18.4995) (12.1399, 18.54) (11.8724, 18.758) (11.422, 18.4995) (11.1399, 18.54) (10.8724, 18.758) (10.422, 18.4995) (10.1399, 18.54) (9.8724, 18.758) (9.422, 18.4995) (9.1399, 18.54) (8.8724, 18.758) (8.422, 18.4995) (8.1399, 18.54) (7.8724, 18.758) (7.5601, 18.54) (7.278, 18.4995) (7.0189, 18.6179) (6.8648, 18.8575) (6.8648, 19.1425) (6.9803, 19.3665) (6.8444, 19.75) (6.8648, 19.8925), closed, covered)
  P39_AC_L4_h23 = polyline(z=-1.44mm, xy in mm: (29.6648, 19.8925) (29.8189, 20.1321) (30.078, 20.2505) (30.3601, 20.21) (30.6276, 19.992) (31.078, 20.2505) (31.3601, 20.21) (31.6276, 19.992) (32.078, 20.2505) (32.3601, 20.21) (32.6276, 19.992) (33.078, 20.2505) (33.3601, 20.21) (33.6276, 19.992) (34.078, 20.2505) (34.3601, 20.21) (34.6276, 19.992) (35.078, 20.2505) (35.3601, 20.21) (35.6276, 19.992) (36.078, 20.2505) (36.3601, 20.21) (36.6276, 19.992) (37.078, 20.2505) (37.3601, 20.21) (37.6276, 19.992) (38.078, 20.2505) (38.3601, 20.21) (38.6276, 19.992) (39.078, 20.2505) (39.3601, 20.21) (39.6276, 19.992) (39.9399, 20.21) (40.222, 20.2505) (40.4811, 20.1321) (40.6352, 19.8925) (40.6352, 19.6075) (40.5197, 19.3835) (40.6556, 19) (40.5754, 18.7266) (40.222, 18.4995) (39.9399, 18.54) (39.6724, 18.758) (39.222, 18.4995) (38.9399, 18.54) (38.6724, 18.758) (38.222, 18.4995) (37.9399, 18.54) (37.6724, 18.758) (37.222, 18.4995) (36.9399, 18.54) (36.6724, 18.758) (36.222, 18.4995) (35.9399, 18.54) (35.6724, 18.758) (35.222, 18.4995) (34.9399, 18.54) (34.6724, 18.758) (34.222, 18.4995) (33.9399, 18.54) (33.6724, 18.758) (33.222, 18.4995) (32.9399, 18.54) (32.6724, 18.758) (32.222, 18.4995) (31.9399, 18.54) (31.6724, 18.758) (31.222, 18.4995) (30.9399, 18.54) (30.6724, 18.758) (30.3601, 18.54) (30.078, 18.4995) (29.8189, 18.6179) (29.6648, 18.8575) (29.6648, 19.1425) (29.7803, 19.3665) (29.6444, 19.75) (29.6648, 19.8925), closed, covered)
  P39_AC_L4_h24 = polyline(z=-1.44mm, xy in mm: (6.8648, 15.6425) (7.0189, 15.8821) (7.278, 16.0005) (7.5601, 15.96) (7.8276, 15.742) (8.1399, 15.96) (8.422, 16.0005) (8.6811, 15.8821) (8.8352, 15.6425) (8.7752, 15.0736) (8.8885, 15.0472) (9.278, 15.3005) (9.814, 15.1332) (9.8745, 15.2244) (9.8556, 15.6087) (9.3403, 15.6524) (9.0222, 15.8871) (9.0222, 16.8629) (9.3403, 17.0976) (11.2097, 17.0976) (11.4471, 16.9721) (11.5726, 16.7347) (11.5726, 16.0153) (11.4133, 15.7294) (11.4501, 15.619) (12.1597, 15.5976) (12.3972, 15.4721) (12.5961, 15.2255) (13.1373, 15.2255) (13.4168, 15.4141) (13.8632, 15.4141) (14.1041, 15.1732) (14.1041, 14.6268) (13.9704, 14.4359) (13.8143, 14.3795) (13.4168, 14.3859) (13.1373, 14.5745) (12.5961, 14.5745) (12.3972, 14.3278) (12.1597, 14.2024) (11.4495, 14.1806) (11.4136, 14.0699) (11.5755, 13.7543) (11.5278, 12.9371) (11.2097, 12.7024) (10.7163, 12.6806) (10.6755, 12.139) (10.7602, 11.6575) (10.4851, 11.34) (10.203, 11.2995) (9.9439, 11.4179) (9.7898, 11.6575) (9.7898, 11.9425) (9.8741, 12.1305) (9.8556, 12.6587) (9.2121, 12.7472) (9.0222, 12.9371) (8.9061, 13.2017) (8.422, 12.8995) (8.1399, 12.94) (7.8724, 13.158) (7.422, 12.8995) (7.1399, 12.94) (6.9246, 13.1266) (6.8444, 13.4) (6.9587, 13.7415) (6.8444, 14.1) (6.9587, 14.4415) (6.8444, 14.8) (6.9587, 15.1415) (6.8444, 15.5) (6.8648, 15.6425), closed, covered)
  P39_AC_L4_h25 = polyline(z=-1.44mm, xy in mm: (33.3959, 15.1732) (33.5296, 15.3641) (33.6857, 15.4205) (34.0832, 15.4141) (34.3627, 15.2255) (34.9039, 15.2255) (35.1029, 15.4722) (35.3403, 15.5976) (36.0505, 15.6194) (36.0864, 15.7301) (35.9274, 16.0153) (35.9245, 16.7043) (36.1621, 17.0528) (38.1597, 17.0976) (38.3972, 16.9721) (38.5226, 16.7347) (38.5226, 16.0153) (38.2879, 15.6972) (37.6663, 15.6306) (37.6444, 15.1662) (37.7551, 15.1303) (37.9399, 15.26) (38.222, 15.3005) (38.6885, 15.0472) (38.7587, 15.1415) (38.6648, 15.3575) (38.6648, 15.6425) (38.9399, 15.96) (39.3601, 15.96) (39.6276, 15.742) (39.9399, 15.96) (40.3601, 15.96) (40.5754, 15.7734) (40.6556, 15.5) (40.5413, 15.1585) (40.6556, 14.8) (40.5413, 14.4585) (40.6556, 14.1) (40.5413, 13.7585) (40.6352, 13.5425) (40.6352, 13.2575) (40.4811, 13.0179) (40.222, 12.8995) (39.9399, 12.94) (39.6724, 13.158) (39.3601, 12.94) (39.078, 12.8995) (38.6132, 13.2059) (38.2879, 12.7472) (37.6663, 12.6806) (37.6255, 12.139) (37.7102, 11.6575) (37.4351, 11.34) (37.153, 11.2995) (36.8939, 11.4179) (36.7398, 11.6575) (36.7398, 11.9425) (36.8241, 12.1305) (36.8056, 12.6587) (36.2903, 12.7024) (35.9722, 12.9371) (35.9245, 13.7543) (36.0867, 14.0706) (36.0499, 14.181) (35.3403, 14.2024) (35.1029, 14.3278) (34.9039, 14.5745) (34.3627, 14.5745) (34.0832, 14.3859) (33.6368, 14.3859) (33.3959, 14.6268) (33.3895, 15.1243) (33.3959, 15.1732), closed, covered)
  P39_AC_L4.subtract(P39_AC_L4_h0..P39_AC_L4_h25)
  P39_AC_L4.sweep_along_vector((0mm, 0mm, 0.07mm))
  V0_DCP = cylinder(axis=Z, base_centre=(-26.1192mm, -12.65mm, -1.44mm), radius=0.15mm, height=1.68mm)
  V1_DCP = cylinder(axis=Z, base_centre=(-1.15mm, -12.65mm, -1.44mm), radius=0.15mm, height=1.68mm)
  V2_DCP = cylinder(axis=Z, base_centre=(17.8269mm, -5.5mm, -1.44mm), radius=0.15mm, height=1.68mm)
  V3_DCP = cylinder(axis=Z, base_centre=(-9.5346mm, -5.5mm, -1.44mm), radius=0.15mm, height=1.68mm)
  V4_DCP = cylinder(axis=Z, base_centre=(-31.9mm, 2.5mm, -1.44mm), radius=0.15mm, height=1.68mm)
  V5_DCP = cylinder(axis=Z, base_centre=(-28.4885mm, -5.5mm, -1.44mm), radius=0.15mm, height=1.68mm)
  V6_DCP = cylinder(axis=Z, base_centre=(11.9038mm, -12.65mm, -1.44mm), radius=0.15mm, height=1.68mm)
  V7_DCP = cylinder(axis=Z, base_centre=(-1.15mm, -5.5mm, -1.44mm), radius=0.15mm, height=1.68mm)
  V8_DCP = cylinder(axis=Z, base_centre=(30.8577mm, -12.65mm, -1.44mm), radius=0.15mm, height=1.68mm)
  V9_DCP = cylinder(axis=Z, base_centre=(-22.5654mm, -5.5mm, -1.44mm), radius=0.15mm, height=1.68mm)
  V10_DCP = cylinder(axis=Z, base_centre=(-29.2mm, 2.5mm, -1.44mm), radius=0.15mm, height=1.68mm)
  V11_DCP = cylinder(axis=Z, base_centre=(8.35mm, -12.65mm, -1.44mm), radius=0.15mm, height=1.68mm)
  V12_DCP = cylinder(axis=Z, base_centre=(-7.15mm, -12.65mm, -1.44mm), radius=0.15mm, height=1.68mm)
  V13_DCP = cylinder(axis=Z, base_centre=(13.0885mm, -12.65mm, -1.44mm), radius=0.15mm, height=1.68mm)
  V14_DCP = cylinder(axis=Z, base_centre=(19.0115mm, -12.65mm, -1.44mm), radius=0.15mm, height=1.68mm)
  V15_DCP = cylinder(axis=Z, base_centre=(-37.9654mm, -12.65mm, -1.44mm), radius=0.15mm, height=1.68mm)
  V16_DCP = cylinder(axis=Z, base_centre=(16.5mm, 2.5mm, -1.44mm), radius=0.15mm, height=1.68mm)
  V17_DCP = cylinder(axis=Z, base_centre=(-12mm, 2.5mm, -1.44mm), radius=0.15mm, height=1.68mm)
  V18_DCP = cylinder(axis=Z, base_centre=(-13.0885mm, -5.5mm, -1.44mm), radius=0.15mm, height=1.68mm)
  V19_DCP = cylinder(axis=Z, base_centre=(4.85mm, -12.65mm, -1.44mm), radius=0.15mm, height=1.68mm)
  V20_DCP = cylinder(axis=Z, base_centre=(12mm, 2.5mm, -1.44mm), radius=0.15mm, height=1.68mm)
  V21_DCP = cylinder(axis=Z, base_centre=(29.2mm, 2.5mm, -1.44mm), radius=0.15mm, height=1.68mm)
  V22_DCP = cylinder(axis=Z, base_centre=(-16.6423mm, -5.5mm, -1.44mm), radius=0.15mm, height=1.68mm)
  V23_DCP = cylinder(axis=Z, base_centre=(8.35mm, -5.5mm, -1.44mm), radius=0.15mm, height=1.68mm)
  V24_DCP = cylinder(axis=Z, base_centre=(2.45mm, -12.65mm, -1.44mm), radius=0.15mm, height=1.68mm)
  V25_DCP = cylinder(axis=Z, base_centre=(31mm, 2.5mm, -1.44mm), radius=0.15mm, height=1.68mm)
  V26_DCP = cylinder(axis=Z, base_centre=(20.1962mm, -5.5mm, -1.44mm), radius=0.15mm, height=1.68mm)
  V27_DCP = cylinder(axis=Z, base_centre=(11.9038mm, -5.5mm, -1.44mm), radius=0.15mm, height=1.68mm)
  V28_DCP = cylinder(axis=Z, base_centre=(39.15mm, -12.65mm, -1.44mm), radius=0.15mm, height=1.68mm)
  V29_DCP = cylinder(axis=Z, base_centre=(-39.15mm, -12.65mm, -1.44mm), radius=0.15mm, height=1.68mm)
  V30_DCP = cylinder(axis=Z, base_centre=(1.25mm, -12.65mm, -1.44mm), radius=0.15mm, height=1.68mm)
  V31_DCP = cylinder(axis=Z, base_centre=(37.9654mm, -5.5mm, -1.44mm), radius=0.15mm, height=1.68mm)
  V32_DCP = cylinder(axis=Z, base_centre=(17.4mm, 2.5mm, -1.44mm), radius=0.15mm, height=1.68mm)
  V33_DCP = cylinder(axis=Z, base_centre=(-36.7808mm, -5.5mm, -1.44mm), radius=0.15mm, height=1.68mm)
  V34_DCP = cylinder(axis=Z, base_centre=(36.7808mm, -5.5mm, -1.44mm), radius=0.15mm, height=1.68mm)
  V35_DCP = cylinder(axis=Z, base_centre=(27.3038mm, -5.5mm, -1.44mm), radius=0.15mm, height=1.68mm)
  V36_DCP = cylinder(axis=Z, base_centre=(10.7192mm, -5.5mm, -1.44mm), radius=0.15mm, height=1.68mm)
  V37_DCP = cylinder(axis=Z, base_centre=(6.05mm, -12.65mm, -1.44mm), radius=0.15mm, height=1.68mm)
  V38_DCP = cylinder(axis=Z, base_centre=(30.1mm, 2.5mm, -1.44mm), radius=0.15mm, height=1.68mm)
  V39_DCP = cylinder(axis=Z, base_centre=(-13.0885mm, -12.65mm, -1.44mm), radius=0.15mm, height=1.68mm)
  V40_DCP = cylinder(axis=Z, base_centre=(-18.3mm, 2.5mm, -1.44mm), radius=0.15mm, height=1.68mm)
  V41_DCP = cylinder(axis=Z, base_centre=(-11.9038mm, -5.5mm, -1.44mm), radius=0.15mm, height=1.68mm)
  V42_DCP = cylinder(axis=Z, base_centre=(36.7808mm, -12.65mm, -1.44mm), radius=0.15mm, height=1.68mm)
  V43_DCP = cylinder(axis=Z, base_centre=(23.75mm, -12.65mm, -1.44mm), radius=0.15mm, height=1.68mm)
  V44_DCP = cylinder(axis=Z, base_centre=(-17.4mm, 2.5mm, -1.44mm), radius=0.15mm, height=1.68mm)
  V45_DCP = cylinder(axis=Z, base_centre=(35.5mm, 2.5mm, -1.44mm), radius=0.15mm, height=1.68mm)
  V46_DCP = cylinder(axis=Z, base_centre=(28.4885mm, -12.65mm, -1.44mm), radius=0.15mm, height=1.68mm)
  V47_DCP = cylinder(axis=Z, base_centre=(-20.1962mm, -12.65mm, -1.44mm), radius=0.15mm, height=1.68mm)
  V48_DCP = cylinder(axis=Z, base_centre=(-30.8577mm, -12.65mm, -1.44mm), radius=0.15mm, height=1.68mm)
  V49_DCP = cylinder(axis=Z, base_centre=(14.2731mm, -5.5mm, -1.44mm), radius=0.15mm, height=1.68mm)
  V50_DCP = cylinder(axis=Z, base_centre=(16.6423mm, -12.65mm, -1.44mm), radius=0.15mm, height=1.68mm)
  V51_DCP = cylinder(axis=Z, base_centre=(-15.6mm, 2.5mm, -1.44mm), radius=0.15mm, height=1.68mm)
  V52_DCP = cylinder(axis=Z, base_centre=(16.6423mm, -5.5mm, -1.44mm), radius=0.15mm, height=1.68mm)
  V53_DCP = cylinder(axis=Z, base_centre=(12.9mm, 2.5mm, -1.44mm), radius=0.15mm, height=1.68mm)
  V54_DCP = cylinder(axis=Z, base_centre=(-3.55mm, -12.65mm, -1.44mm), radius=0.15mm, height=1.68mm)
  V55_DCP = cylinder(axis=Z, base_centre=(4.85mm, -5.5mm, -1.44mm), radius=0.15mm, height=1.68mm)
  V56_DCP = cylinder(axis=Z, base_centre=(14.7mm, 2.5mm, -1.44mm), radius=0.15mm, height=1.68mm)
  V57_DCP = cylinder(axis=Z, base_centre=(-32.8mm, 2.5mm, -1.44mm), radius=0.15mm, height=1.68mm)
  V58_DCP = cylinder(axis=Z, base_centre=(34.4115mm, -12.65mm, -1.44mm), radius=0.15mm, height=1.68mm)
  V59_DCP = cylinder(axis=Z, base_centre=(-8.35mm, -12.65mm, -1.44mm), radius=0.15mm, height=1.68mm)
  V60_DCP = cylinder(axis=Z, base_centre=(-39.15mm, -5.5mm, -1.44mm), radius=0.15mm, height=1.68mm)
  V61_DCP = cylinder(axis=Z, base_centre=(32.0423mm, -12.65mm, -1.44mm), radius=0.15mm, height=1.68mm)
  V62_DCP = cylinder(axis=Z, base_centre=(31.9mm, 2.5mm, -1.44mm), radius=0.15mm, height=1.68mm)
  V63_DCP = cylinder(axis=Z, base_centre=(39.15mm, -5.5mm, -1.44mm), radius=0.15mm, height=1.68mm)
  V64_DCP = cylinder(axis=Z, base_centre=(33.2269mm, -12.65mm, -1.44mm), radius=0.15mm, height=1.68mm)
  V65_DCP = cylinder(axis=Z, base_centre=(-3.55mm, -5.5mm, -1.44mm), radius=0.15mm, height=1.68mm)
  V66_DCP = cylinder(axis=Z, base_centre=(29.6731mm, -5.5mm, -1.44mm), radius=0.15mm, height=1.68mm)
  V67_DCP = cylinder(axis=Z, base_centre=(10.7192mm, -12.65mm, -1.44mm), radius=0.15mm, height=1.68mm)
  V68_DCP = cylinder(axis=Z, base_centre=(-35.5962mm, -5.5mm, -1.44mm), radius=0.15mm, height=1.68mm)
  V69_DCP = cylinder(axis=Z, base_centre=(-31mm, 2.5mm, -1.44mm), radius=0.15mm, height=1.68mm)
  V70_DCP = cylinder(axis=Z, base_centre=(-20.1962mm, -5.5mm, -1.44mm), radius=0.15mm, height=1.68mm)
  V71_DCP = cylinder(axis=Z, base_centre=(-29.6731mm, -5.5mm, -1.44mm), radius=0.15mm, height=1.68mm)
  V72_DCP = cylinder(axis=Z, base_centre=(15.4577mm, -5.5mm, -1.44mm), radius=0.15mm, height=1.68mm)
  V73_DCP = cylinder(axis=Z, base_centre=(-19.0115mm, -12.65mm, -1.44mm), radius=0.15mm, height=1.68mm)
  V74_DCP = cylinder(axis=Z, base_centre=(-34.6mm, 2.5mm, -1.44mm), radius=0.15mm, height=1.68mm)
  V75_DCP = cylinder(axis=Z, base_centre=(-10.7192mm, -5.5mm, -1.44mm), radius=0.15mm, height=1.68mm)
  V76_DCP = cylinder(axis=Z, base_centre=(-29.6731mm, -12.65mm, -1.44mm), radius=0.15mm, height=1.68mm)
  V77_DCP = cylinder(axis=Z, base_centre=(-15.4577mm, -5.5mm, -1.44mm), radius=0.15mm, height=1.68mm)
  V78_DCP = cylinder(axis=Z, base_centre=(-24.9346mm, -5.5mm, -1.44mm), radius=0.15mm, height=1.68mm)
  V79_DCP = cylinder(axis=Z, base_centre=(0.05mm, -5.5mm, -1.44mm), radius=0.15mm, height=1.68mm)
  V80_DCP = cylinder(axis=Z, base_centre=(-15.4577mm, -12.65mm, -1.44mm), radius=0.15mm, height=1.68mm)
  V81_DCP = cylinder(axis=Z, base_centre=(-34.4115mm, -5.5mm, -1.44mm), radius=0.15mm, height=1.68mm)
  V82_DCP = cylinder(axis=Z, base_centre=(-26.1192mm, -5.5mm, -1.44mm), radius=0.15mm, height=1.68mm)
  V83_DCP = cylinder(axis=Z, base_centre=(-32.0423mm, -5.5mm, -1.44mm), radius=0.15mm, height=1.68mm)
  V84_DCP = cylinder(axis=Z, base_centre=(30.8577mm, -5.5mm, -1.44mm), radius=0.15mm, height=1.68mm)
  V85_DCP = cylinder(axis=Z, base_centre=(26.1192mm, -12.65mm, -1.44mm), radius=0.15mm, height=1.68mm)
  V86_DCP = cylinder(axis=Z, base_centre=(-7.15mm, -5.5mm, -1.44mm), radius=0.15mm, height=1.68mm)
  V87_DCP = cylinder(axis=Z, base_centre=(-33.2269mm, -5.5mm, -1.44mm), radius=0.15mm, height=1.68mm)
  V88_DCP = cylinder(axis=Z, base_centre=(0.05mm, -12.65mm, -1.44mm), radius=0.15mm, height=1.68mm)
  V89_DCP = cylinder(axis=Z, base_centre=(29.6731mm, -12.65mm, -1.44mm), radius=0.15mm, height=1.68mm)
  V90_DCP = cylinder(axis=Z, base_centre=(20.1962mm, -12.65mm, -1.44mm), radius=0.15mm, height=1.68mm)
  V91_DCP = cylinder(axis=Z, base_centre=(15.4577mm, -12.65mm, -1.44mm), radius=0.15mm, height=1.68mm)
  V92_DCP = cylinder(axis=Z, base_centre=(18.3mm, 2.5mm, -1.44mm), radius=0.15mm, height=1.68mm)
  V93_DCP = cylinder(axis=Z, base_centre=(-36.7808mm, -12.65mm, -1.44mm), radius=0.15mm, height=1.68mm)
  V94_DCP = cylinder(axis=Z, base_centre=(-13.8mm, 2.5mm, -1.44mm), radius=0.15mm, height=1.68mm)
  V95_DCP = cylinder(axis=Z, base_centre=(2.45mm, -5.5mm, -1.44mm), radius=0.15mm, height=1.68mm)
  V96_DCP = cylinder(axis=Z, base_centre=(-33.7mm, 2.5mm, -1.44mm), radius=0.15mm, height=1.68mm)
  V97_DCP = cylinder(axis=Z, base_centre=(-27.3038mm, -5.5mm, -1.44mm), radius=0.15mm, height=1.68mm)
  V98_DCP = cylinder(axis=Z, base_centre=(-27.3038mm, -12.65mm, -1.44mm), radius=0.15mm, height=1.68mm)
  V99_DCP = cylinder(axis=Z, base_centre=(-35.5962mm, -12.65mm, -1.44mm), radius=0.15mm, height=1.68mm)
  V100_DCP = cylinder(axis=Z, base_centre=(-5.95mm, -12.65mm, -1.44mm), radius=0.15mm, height=1.68mm)
  V101_DCP = cylinder(axis=Z, base_centre=(22.5654mm, -12.65mm, -1.44mm), radius=0.15mm, height=1.68mm)
  V102_DCP = cylinder(axis=Z, base_centre=(-22.5654mm, -12.65mm, -1.44mm), radius=0.15mm, height=1.68mm)
  V103_DCP = cylinder(axis=Z, base_centre=(-14.2731mm, -5.5mm, -1.44mm), radius=0.15mm, height=1.68mm)
  V104_DCP = cylinder(axis=Z, base_centre=(24.9346mm, -5.5mm, -1.44mm), radius=0.15mm, height=1.68mm)
  V105_DCP = cylinder(axis=Z, base_centre=(-14.2731mm, -12.65mm, -1.44mm), radius=0.15mm, height=1.68mm)
  V106_DCP = cylinder(axis=Z, base_centre=(-16.6423mm, -12.65mm, -1.44mm), radius=0.15mm, height=1.68mm)
  V107_DCP = cylinder(axis=Z, base_centre=(-30.1mm, 2.5mm, -1.44mm), radius=0.15mm, height=1.68mm)
  V108_DCP = cylinder(axis=Z, base_centre=(-32.0423mm, -12.65mm, -1.44mm), radius=0.15mm, height=1.68mm)
  V109_DCP = cylinder(axis=Z, base_centre=(17.8269mm, -12.65mm, -1.44mm), radius=0.15mm, height=1.68mm)
  V110_DCP = cylinder(axis=Z, base_centre=(-4.75mm, -12.65mm, -1.44mm), radius=0.15mm, height=1.68mm)
  V111_DCP = cylinder(axis=Z, base_centre=(-4.75mm, -5.5mm, -1.44mm), radius=0.15mm, height=1.68mm)
  V112_DCP = cylinder(axis=Z, base_centre=(-8.35mm, -5.5mm, -1.44mm), radius=0.15mm, height=1.68mm)
  V113_DCP = cylinder(axis=Z, base_centre=(13.8mm, 2.5mm, -1.44mm), radius=0.15mm, height=1.68mm)
  V114_DCP = cylinder(axis=Z, base_centre=(22.5654mm, -5.5mm, -1.44mm), radius=0.15mm, height=1.68mm)
  V115_DCP = cylinder(axis=Z, base_centre=(-12.9mm, 2.5mm, -1.44mm), radius=0.15mm, height=1.68mm)
  V116_DCP = cylinder(axis=Z, base_centre=(9.5346mm, -12.65mm, -1.44mm), radius=0.15mm, height=1.68mm)
  V117_DCP = cylinder(axis=Z, base_centre=(1.25mm, -5.5mm, -1.44mm), radius=0.15mm, height=1.68mm)
  V118_DCP = cylinder(axis=Z, base_centre=(21.3808mm, -5.5mm, -1.44mm), radius=0.15mm, height=1.68mm)
  V119_DCP = cylinder(axis=Z, base_centre=(32.8mm, 2.5mm, -1.44mm), radius=0.15mm, height=1.68mm)
  V120_DCP = cylinder(axis=Z, base_centre=(3.65mm, -12.65mm, -1.44mm), radius=0.15mm, height=1.68mm)
  V121_DCP = cylinder(axis=Z, base_centre=(-30.8577mm, -5.5mm, -1.44mm), radius=0.15mm, height=1.68mm)
  V122_DCP = cylinder(axis=Z, base_centre=(-35.5mm, 2.5mm, -1.44mm), radius=0.15mm, height=1.68mm)
  V123_DCP = cylinder(axis=Z, base_centre=(-2.35mm, -12.65mm, -1.44mm), radius=0.15mm, height=1.68mm)
  V124_DCP = cylinder(axis=Z, base_centre=(-23.75mm, -5.5mm, -1.44mm), radius=0.15mm, height=1.68mm)
  V125_DCP = cylinder(axis=Z, base_centre=(23.75mm, -5.5mm, -1.44mm), radius=0.15mm, height=1.68mm)
  V126_DCP = cylinder(axis=Z, base_centre=(33.7mm, 2.5mm, -1.44mm), radius=0.15mm, height=1.68mm)
  V127_DCP = cylinder(axis=Z, base_centre=(35.5962mm, -5.5mm, -1.44mm), radius=0.15mm, height=1.68mm)
  V128_DCP = cylinder(axis=Z, base_centre=(-24.9346mm, -12.65mm, -1.44mm), radius=0.15mm, height=1.68mm)
  V129_DCP = cylinder(axis=Z, base_centre=(6.05mm, -5.5mm, -1.44mm), radius=0.15mm, height=1.68mm)
  V130_DCP = cylinder(axis=Z, base_centre=(33.2269mm, -5.5mm, -1.44mm), radius=0.15mm, height=1.68mm)
  V131_DCP = cylinder(axis=Z, base_centre=(28.4885mm, -5.5mm, -1.44mm), radius=0.15mm, height=1.68mm)
  V132_DCP = cylinder(axis=Z, base_centre=(32.0423mm, -5.5mm, -1.44mm), radius=0.15mm, height=1.68mm)
  V133_DCP = cylinder(axis=Z, base_centre=(13.0885mm, -5.5mm, -1.44mm), radius=0.15mm, height=1.68mm)
  V134_DCP = cylinder(axis=Z, base_centre=(-28.4885mm, -12.65mm, -1.44mm), radius=0.15mm, height=1.68mm)
  V135_DCP = cylinder(axis=Z, base_centre=(15.6mm, 2.5mm, -1.44mm), radius=0.15mm, height=1.68mm)
  V136_DCP = cylinder(axis=Z, base_centre=(-23.75mm, -12.65mm, -1.44mm), radius=0.15mm, height=1.68mm)
  V137_DCP = cylinder(axis=Z, base_centre=(34.6mm, 2.5mm, -1.44mm), radius=0.15mm, height=1.68mm)
  V138_DCP = cylinder(axis=Z, base_centre=(37.9654mm, -12.65mm, -1.44mm), radius=0.15mm, height=1.68mm)
  V139_DCP = cylinder(axis=Z, base_centre=(-21.3808mm, -5.5mm, -1.44mm), radius=0.15mm, height=1.68mm)
  V140_DCP = cylinder(axis=Z, base_centre=(24.9346mm, -12.65mm, -1.44mm), radius=0.15mm, height=1.68mm)
  V141_DCP = cylinder(axis=Z, base_centre=(-10.7192mm, -12.65mm, -1.44mm), radius=0.15mm, height=1.68mm)
  V142_DCP = cylinder(axis=Z, base_centre=(19.0115mm, -5.5mm, -1.44mm), radius=0.15mm, height=1.68mm)
  V143_DCP = cylinder(axis=Z, base_centre=(14.2731mm, -12.65mm, -1.44mm), radius=0.15mm, height=1.68mm)
  V144_DCP = cylinder(axis=Z, base_centre=(-34.4115mm, -12.65mm, -1.44mm), radius=0.15mm, height=1.68mm)
  V145_DCP = cylinder(axis=Z, base_centre=(-14.7mm, 2.5mm, -1.44mm), radius=0.15mm, height=1.68mm)
  V146_DCP = cylinder(axis=Z, base_centre=(21.3808mm, -12.65mm, -1.44mm), radius=0.15mm, height=1.68mm)
  V147_DCP = cylinder(axis=Z, base_centre=(-19.0115mm, -5.5mm, -1.44mm), radius=0.15mm, height=1.68mm)
  V148_DCP = cylinder(axis=Z, base_centre=(35.5962mm, -12.65mm, -1.44mm), radius=0.15mm, height=1.68mm)
  V149_DCP = cylinder(axis=Z, base_centre=(-2.35mm, -5.5mm, -1.44mm), radius=0.15mm, height=1.68mm)
  V150_DCP = cylinder(axis=Z, base_centre=(34.4115mm, -5.5mm, -1.44mm), radius=0.15mm, height=1.68mm)
  V151_DCP = cylinder(axis=Z, base_centre=(9.5346mm, -5.5mm, -1.44mm), radius=0.15mm, height=1.68mm)
  V152_DCP = cylinder(axis=Z, base_centre=(-11.9038mm, -12.65mm, -1.44mm), radius=0.15mm, height=1.68mm)
  V153_DCP = cylinder(axis=Z, base_centre=(3.65mm, -5.5mm, -1.44mm), radius=0.15mm, height=1.68mm)
  V154_DCP = cylinder(axis=Z, base_centre=(-33.2269mm, -12.65mm, -1.44mm), radius=0.15mm, height=1.68mm)
  V155_DCP = cylinder(axis=Z, base_centre=(-16.5mm, 2.5mm, -1.44mm), radius=0.15mm, height=1.68mm)
  V156_DCP = cylinder(axis=Z, base_centre=(27.3038mm, -12.65mm, -1.44mm), radius=0.15mm, height=1.68mm)
  V157_DCP = cylinder(axis=Z, base_centre=(-17.8269mm, -12.65mm, -1.44mm), radius=0.15mm, height=1.68mm)
  V158_DCP = cylinder(axis=Z, base_centre=(-9.5346mm, -12.65mm, -1.44mm), radius=0.15mm, height=1.68mm)
  V159_DCP = cylinder(axis=Z, base_centre=(-5.95mm, -5.5mm, -1.44mm), radius=0.15mm, height=1.68mm)
  V160_DCP = cylinder(axis=Z, base_centre=(26.1192mm, -5.5mm, -1.44mm), radius=0.15mm, height=1.68mm)
  V161_DCP = cylinder(axis=Z, base_centre=(-17.8269mm, -5.5mm, -1.44mm), radius=0.15mm, height=1.68mm)
  V162_DCP = cylinder(axis=Z, base_centre=(-37.9654mm, -5.5mm, -1.44mm), radius=0.15mm, height=1.68mm)
  V163_DCP = cylinder(axis=Z, base_centre=(-21.3808mm, -12.65mm, -1.44mm), radius=0.15mm, height=1.68mm)
  V164_DCN = cylinder(axis=Z, base_centre=(-18.35mm, 13.4mm, -1.44mm), radius=0.15mm, height=1.68mm)
  V165_DCN = cylinder(axis=Z, base_centre=(-35.5962mm, -10.75mm, -1.44mm), radius=0.15mm, height=1.68mm)
  V166_DCN = cylinder(axis=Z, base_centre=(36.7808mm, -0.5mm, -1.44mm), radius=0.15mm, height=1.68mm)
  V167_DCN = cylinder(axis=Z, base_centre=(-16.35mm, 14.1mm, -1.44mm), radius=0.15mm, height=1.68mm)
  V168_DCN = cylinder(axis=Z, base_centre=(32.0423mm, -0.5mm, -1.44mm), radius=0.15mm, height=1.68mm)
  V169_DCN = cylinder(axis=Z, base_centre=(-41.15mm, 19mm, -1.44mm), radius=0.15mm, height=1.68mm)
  V170_DCN = cylinder(axis=Z, base_centre=(-13.0885mm, -10.75mm, -1.44mm), radius=0.15mm, height=1.68mm)
  V171_DCN = cylinder(axis=Z, base_centre=(31.15mm, 19mm, -1.44mm), radius=0.15mm, height=1.68mm)
  V172_DCN = cylinder(axis=Z, base_centre=(-10.7192mm, -10.75mm, -1.44mm), radius=0.15mm, height=1.68mm)
  V173_DCN = cylinder(axis=Z, base_centre=(-6.35mm, 19.75mm, -1.44mm), radius=0.15mm, height=1.68mm)
  V174_DCN = cylinder(axis=Z, base_centre=(16.6423mm, -10.75mm, -1.44mm), radius=0.15mm, height=1.68mm)
  V175_DCN = cylinder(axis=Z, base_centre=(29.6731mm, -0.5mm, -1.44mm), radius=0.15mm, height=1.68mm)
  V176_DCN = cylinder(axis=Z, base_centre=(15.4577mm, -0.5mm, -1.44mm), radius=0.15mm, height=1.68mm)
  V177_DCN = cylinder(axis=Z, base_centre=(-7.35mm, 15.5mm, -1.44mm), radius=0.15mm, height=1.68mm)
  V178_DCN = cylinder(axis=Z, base_centre=(-6.35mm, 14.1mm, -1.44mm), radius=0.15mm, height=1.68mm)
  V179_DCN = cylinder(axis=Z, base_centre=(-30.15mm, 14.8mm, -1.44mm), radius=0.15mm, height=1.68mm)
  V180_DCN = cylinder(axis=Z, base_centre=(35.5962mm, -0.5mm, -1.44mm), radius=0.15mm, height=1.68mm)
  V181_DCN = cylinder(axis=Z, base_centre=(31.15mm, 13.4mm, -1.44mm), radius=0.15mm, height=1.68mm)
  V182_DCN = cylinder(axis=Z, base_centre=(30.15mm, 19mm, -1.44mm), radius=0.15mm, height=1.68mm)
  V183_DCN = cylinder(axis=Z, base_centre=(29.15mm, 15.5mm, -1.44mm), radius=0.15mm, height=1.68mm)
  V184_DCN = cylinder(axis=Z, base_centre=(4.35mm, 14.8mm, -1.44mm), radius=0.15mm, height=1.68mm)
  V185_DCN = cylinder(axis=Z, base_centre=(-8.35mm, 13.4mm, -1.44mm), radius=0.15mm, height=1.68mm)
  V186_DCN = cylinder(axis=Z, base_centre=(-40.15mm, 15.5mm, -1.44mm), radius=0.15mm, height=1.68mm)
  V187_DCN = cylinder(axis=Z, base_centre=(11.35mm, 19mm, -1.44mm), radius=0.15mm, height=1.68mm)
  V188_DCN = cylinder(axis=Z, base_centre=(-19.0115mm, -10.75mm, -1.44mm), radius=0.15mm, height=1.68mm)
  V189_DCN = cylinder(axis=Z, base_centre=(43.15mm, 13.4mm, -1.44mm), radius=0.15mm, height=1.68mm)
  V190_DCN = cylinder(axis=Z, base_centre=(-20.1962mm, -10.75mm, -1.44mm), radius=0.15mm, height=1.68mm)
  V191_DCN = cylinder(axis=Z, base_centre=(31.15mm, 15.5mm, -1.44mm), radius=0.15mm, height=1.68mm)
  V192_DCN = cylinder(axis=Z, base_centre=(-23.75mm, -0.5mm, -1.44mm), radius=0.15mm, height=1.68mm)
  V193_DCN = cylinder(axis=Z, base_centre=(-27.3038mm, -0.5mm, -1.44mm), radius=0.15mm, height=1.68mm)
  V194_DCN = cylinder(axis=Z, base_centre=(7.35mm, 19mm, -1.44mm), radius=0.15mm, height=1.68mm)
  V195_DCN = cylinder(axis=Z, base_centre=(-11.35mm, 19mm, -1.44mm), radius=0.15mm, height=1.68mm)
  V196_DCN = cylinder(axis=Z, base_centre=(-22.5654mm, -0.5mm, -1.44mm), radius=0.15mm, height=1.68mm)
  V197_DCN = cylinder(axis=Z, base_centre=(13.0885mm, -10.75mm, -1.44mm), radius=0.15mm, height=1.68mm)
  V198_DCN = cylinder(axis=Z, base_centre=(-15.4577mm, -0.5mm, -1.44mm), radius=0.15mm, height=1.68mm)
  V199_DCN = cylinder(axis=Z, base_centre=(9.35mm, 14.8mm, -1.44mm), radius=0.15mm, height=1.68mm)
  V200_DCN = cylinder(axis=Z, base_centre=(16.35mm, 19.75mm, -1.44mm), radius=0.15mm, height=1.68mm)
  V201_DCN = cylinder(axis=Z, base_centre=(-16.35mm, 15.5mm, -1.44mm), radius=0.15mm, height=1.68mm)
  V202_DCN = cylinder(axis=Z, base_centre=(36.7808mm, -10.75mm, -1.44mm), radius=0.15mm, height=1.68mm)
  V203_DCN = cylinder(axis=Z, base_centre=(-33.2269mm, -10.75mm, -1.44mm), radius=0.15mm, height=1.68mm)
  V204_DCN = cylinder(axis=Z, base_centre=(-7.35mm, 14.8mm, -1.44mm), radius=0.15mm, height=1.68mm)
  V205_DCN = cylinder(axis=Z, base_centre=(-30.15mm, 19mm, -1.44mm), radius=0.15mm, height=1.68mm)
  V206_DCN = cylinder(axis=Z, base_centre=(-18.35mm, 14.1mm, -1.44mm), radius=0.15mm, height=1.68mm)
  V207_DCN = cylinder(axis=Z, base_centre=(-18.35mm, 15.5mm, -1.44mm), radius=0.15mm, height=1.68mm)
  V208_DCN = cylinder(axis=Z, base_centre=(11.9038mm, -10.75mm, -1.44mm), radius=0.15mm, height=1.68mm)
  V209_DCN = cylinder(axis=Z, base_centre=(-19.0115mm, -0.5mm, -1.44mm), radius=0.15mm, height=1.68mm)
  V210_DCN = cylinder(axis=Z, base_centre=(-16.35mm, 13.4mm, -1.44mm), radius=0.15mm, height=1.68mm)
  V211_DCN = cylinder(axis=Z, base_centre=(-35.5962mm, -0.5mm, -1.44mm), radius=0.15mm, height=1.68mm)
  V212_DCN = cylinder(axis=Z, base_centre=(6.05mm, -10.75mm, -1.44mm), radius=0.15mm, height=1.68mm)
  V213_DCN = cylinder(axis=Z, base_centre=(-42.15mm, 13.4mm, -1.44mm), radius=0.15mm, height=1.68mm)
  V214_DCN = cylinder(axis=Z, base_centre=(-6.35mm, 15.5mm, -1.44mm), radius=0.15mm, height=1.68mm)
  V215_DCN = cylinder(axis=Z, base_centre=(0.05mm, -0.5mm, -1.44mm), radius=0.15mm, height=1.68mm)
  V216_DCN = cylinder(axis=Z, base_centre=(32.15mm, 19.75mm, -1.44mm), radius=0.15mm, height=1.68mm)
  V217_DCN = cylinder(axis=Z, base_centre=(-43.15mm, 13.4mm, -1.44mm), radius=0.15mm, height=1.68mm)
  V218_DCN = cylinder(axis=Z, base_centre=(-1.15mm, -10.75mm, -1.44mm), radius=0.15mm, height=1.68mm)
  V219_DCN = cylinder(axis=Z, base_centre=(39.15mm, 19mm, -1.44mm), radius=0.15mm, height=1.68mm)
  V220_DCN = cylinder(axis=Z, base_centre=(-10.35mm, 19mm, -1.44mm), radius=0.15mm, height=1.68mm)
  V221_DCN = cylinder(axis=Z, base_centre=(34.15mm, 19.75mm, -1.44mm), radius=0.15mm, height=1.68mm)
  V222_DCN = cylinder(axis=Z, base_centre=(-13.0885mm, -0.5mm, -1.44mm), radius=0.15mm, height=1.68mm)
  V223_DCN = cylinder(axis=Z, base_centre=(-12.35mm, 19.75mm, -1.44mm), radius=0.15mm, height=1.68mm)
  V224_DCN = cylinder(axis=Z, base_centre=(-7.35mm, 14.1mm, -1.44mm), radius=0.15mm, height=1.68mm)
  V225_DCN = cylinder(axis=Z, base_centre=(43.15mm, 14.1mm, -1.44mm), radius=0.15mm, height=1.68mm)
  V226_DCN = cylinder(axis=Z, base_centre=(-35.15mm, 19.75mm, -1.44mm), radius=0.15mm, height=1.68mm)
  V227_DCN = cylinder(axis=Z, base_centre=(-5.35mm, 14.8mm, -1.44mm), radius=0.15mm, height=1.68mm)
  V228_DCN = cylinder(axis=Z, base_centre=(33.15mm, 19mm, -1.44mm), radius=0.15mm, height=1.68mm)
  V229_DCN = cylinder(axis=Z, base_centre=(-11.9038mm, -0.5mm, -1.44mm), radius=0.15mm, height=1.68mm)
  V230_DCN = cylinder(axis=Z, base_centre=(-8.35mm, 14.1mm, -1.44mm), radius=0.15mm, height=1.68mm)
  V231_DCN = cylinder(axis=Z, base_centre=(35.15mm, 19.75mm, -1.44mm), radius=0.15mm, height=1.68mm)
  V232_DCN = cylinder(axis=Z, base_centre=(33.2269mm, -0.5mm, -1.44mm), radius=0.15mm, height=1.68mm)
  V233_DCN = cylinder(axis=Z, base_centre=(-17.35mm, 15.5mm, -1.44mm), radius=0.15mm, height=1.68mm)
  V234_DCN = cylinder(axis=Z, base_centre=(-14.35mm, 19mm, -1.44mm), radius=0.15mm, height=1.68mm)
  V235_DCN = cylinder(axis=Z, base_centre=(0.05mm, -10.75mm, -1.44mm), radius=0.15mm, height=1.68mm)
  V236_DCN = cylinder(axis=Z, base_centre=(-22.5654mm, -10.75mm, -1.44mm), radius=0.15mm, height=1.68mm)
  V237_DCN = cylinder(axis=Z, base_centre=(13.35mm, 19.75mm, -1.44mm), radius=0.15mm, height=1.68mm)
  V238_DCN = cylinder(axis=Z, base_centre=(-12.35mm, 13.4mm, -1.44mm), radius=0.15mm, height=1.68mm)
  V239_DCN = cylinder(axis=Z, base_centre=(-33.15mm, 13.4mm, -1.44mm), radius=0.15mm, height=1.68mm)
  V240_DCN = cylinder(axis=Z, base_centre=(-6.35mm, 13.4mm, -1.44mm), radius=0.15mm, height=1.68mm)
  V241_DCN = cylinder(axis=Z, base_centre=(33.15mm, 13.4mm, -1.44mm), radius=0.15mm, height=1.68mm)
  V242_DCN = cylinder(axis=Z, base_centre=(-41.15mm, 14.1mm, -1.44mm), radius=0.15mm, height=1.68mm)
  V243_DCN = cylinder(axis=Z, base_centre=(24.9346mm, -10.75mm, -1.44mm), radius=0.15mm, height=1.68mm)
  V244_DCN = cylinder(axis=Z, base_centre=(40.15mm, 15.5mm, -1.44mm), radius=0.15mm, height=1.68mm)
  V245_DCN = cylinder(axis=Z, base_centre=(32.0423mm, -10.75mm, -1.44mm), radius=0.15mm, height=1.68mm)
  V246_DCN = cylinder(axis=Z, base_centre=(-5.35mm, 19mm, -1.44mm), radius=0.15mm, height=1.68mm)
  V247_DCN = cylinder(axis=Z, base_centre=(19.0115mm, -10.75mm, -1.44mm), radius=0.15mm, height=1.68mm)
  V248_DCN = cylinder(axis=Z, base_centre=(2.45mm, -10.75mm, -1.44mm), radius=0.15mm, height=1.68mm)
  V249_DCN = cylinder(axis=Z, base_centre=(-16.6423mm, -10.75mm, -1.44mm), radius=0.15mm, height=1.68mm)
  V250_DCN = cylinder(axis=Z, base_centre=(-13.35mm, 19.75mm, -1.44mm), radius=0.15mm, height=1.68mm)
  V251_DCN = cylinder(axis=Z, base_centre=(-16.35mm, 19.75mm, -1.44mm), radius=0.15mm, height=1.68mm)
  V252_DCN = cylinder(axis=Z, base_centre=(-21.3808mm, -0.5mm, -1.44mm), radius=0.15mm, height=1.68mm)
  V253_DCN = cylinder(axis=Z, base_centre=(8.35mm, 19.75mm, -1.44mm), radius=0.15mm, height=1.68mm)
  V254_DCN = cylinder(axis=Z, base_centre=(-8.35mm, -10.75mm, -1.44mm), radius=0.15mm, height=1.68mm)
  V255_DCN = cylinder(axis=Z, base_centre=(-4.35mm, 19mm, -1.44mm), radius=0.15mm, height=1.68mm)
  V256_DCN = cylinder(axis=Z, base_centre=(16.35mm, 14.8mm, -1.44mm), radius=0.15mm, height=1.68mm)
  V257_DCN = cylinder(axis=Z, base_centre=(16.35mm, 15.5mm, -1.44mm), radius=0.15mm, height=1.68mm)
  V258_DCN = cylinder(axis=Z, base_centre=(34.4115mm, -0.5mm, -1.44mm), radius=0.15mm, height=1.68mm)
  V259_DCN = cylinder(axis=Z, base_centre=(15.35mm, 13.4mm, -1.44mm), radius=0.15mm, height=1.68mm)
  V260_DCN = cylinder(axis=Z, base_centre=(15.35mm, 19.75mm, -1.44mm), radius=0.15mm, height=1.68mm)
  V261_DCN = cylinder(axis=Z, base_centre=(17.8269mm, -0.5mm, -1.44mm), radius=0.15mm, height=1.68mm)
  V262_DCN = cylinder(axis=Z, base_centre=(-34.15mm, 19mm, -1.44mm), radius=0.15mm, height=1.68mm)
  V263_DCN = cylinder(axis=Z, base_centre=(8.35mm, 14.1mm, -1.44mm), radius=0.15mm, height=1.68mm)
  V264_DCN = cylinder(axis=Z, base_centre=(4.35mm, 19mm, -1.44mm), radius=0.15mm, height=1.68mm)
  V265_DCN = cylinder(axis=Z, base_centre=(7.35mm, 14.8mm, -1.44mm), radius=0.15mm, height=1.68mm)
  V266_DCN = cylinder(axis=Z, base_centre=(-32.15mm, 19mm, -1.44mm), radius=0.15mm, height=1.68mm)
  V267_DCN = cylinder(axis=Z, base_centre=(-42.15mm, 14.8mm, -1.44mm), radius=0.15mm, height=1.68mm)
  V268_DCN = cylinder(axis=Z, base_centre=(8.35mm, -10.75mm, -1.44mm), radius=0.15mm, height=1.68mm)
  V269_DCN = cylinder(axis=Z, base_centre=(36.15mm, 19.75mm, -1.44mm), radius=0.15mm, height=1.68mm)
  V270_DCN = cylinder(axis=Z, base_centre=(-2.35mm, -0.5mm, -1.44mm), radius=0.15mm, height=1.68mm)
  V271_DCN = cylinder(axis=Z, base_centre=(-5.35mm, 13.4mm, -1.44mm), radius=0.15mm, height=1.68mm)
  V272_DCN = cylinder(axis=Z, base_centre=(30.15mm, 14.1mm, -1.44mm), radius=0.15mm, height=1.68mm)
  V273_DCN = cylinder(axis=Z, base_centre=(33.15mm, 19.75mm, -1.44mm), radius=0.15mm, height=1.68mm)
  V274_DCN = cylinder(axis=Z, base_centre=(-30.15mm, 19.75mm, -1.44mm), radius=0.15mm, height=1.68mm)
  V275_DCN = cylinder(axis=Z, base_centre=(4.85mm, -10.75mm, -1.44mm), radius=0.15mm, height=1.68mm)
  V276_DCN = cylinder(axis=Z, base_centre=(-9.5346mm, -0.5mm, -1.44mm), radius=0.15mm, height=1.68mm)
  V277_DCN = cylinder(axis=Z, base_centre=(34.15mm, 13.4mm, -1.44mm), radius=0.15mm, height=1.68mm)
  V278_DCN = cylinder(axis=Z, base_centre=(38.15mm, 19.75mm, -1.44mm), radius=0.15mm, height=1.68mm)
  V279_DCN = cylinder(axis=Z, base_centre=(30.15mm, 19.75mm, -1.44mm), radius=0.15mm, height=1.68mm)
  V280_DCN = cylinder(axis=Z, base_centre=(-30.15mm, 15.5mm, -1.44mm), radius=0.15mm, height=1.68mm)
  V281_DCN = cylinder(axis=Z, base_centre=(31.15mm, 19.75mm, -1.44mm), radius=0.15mm, height=1.68mm)
  V282_DCN = cylinder(axis=Z, base_centre=(33.2269mm, -10.75mm, -1.44mm), radius=0.15mm, height=1.68mm)
  V283_DCN = cylinder(axis=Z, base_centre=(-34.4115mm, -0.5mm, -1.44mm), radius=0.15mm, height=1.68mm)
  V284_DCN = cylinder(axis=Z, base_centre=(-5.95mm, -0.5mm, -1.44mm), radius=0.15mm, height=1.68mm)
  V285_DCN = cylinder(axis=Z, base_centre=(-7.15mm, -10.75mm, -1.44mm), radius=0.15mm, height=1.68mm)
  V286_DCN = cylinder(axis=Z, base_centre=(14.35mm, 19mm, -1.44mm), radius=0.15mm, height=1.68mm)
  V287_DCN = cylinder(axis=Z, base_centre=(-9.35mm, 19.75mm, -1.44mm), radius=0.15mm, height=1.68mm)
  V288_DCN = cylinder(axis=Z, base_centre=(3.65mm, -10.75mm, -1.44mm), radius=0.15mm, height=1.68mm)
  V289_DCN = cylinder(axis=Z, base_centre=(-33.15mm, 19.75mm, -1.44mm), radius=0.15mm, height=1.68mm)
  V290_DCN = cylinder(axis=Z, base_centre=(3.65mm, -0.5mm, -1.44mm), radius=0.15mm, height=1.68mm)
  V291_DCN = cylinder(axis=Z, base_centre=(15.4577mm, -10.75mm, -1.44mm), radius=0.15mm, height=1.68mm)
  V292_DCN = cylinder(axis=Z, base_centre=(32.15mm, 19mm, -1.44mm), radius=0.15mm, height=1.68mm)
  V293_DCN = cylinder(axis=Z, base_centre=(-14.35mm, 19.75mm, -1.44mm), radius=0.15mm, height=1.68mm)
  V294_DCN = cylinder(axis=Z, base_centre=(-24.9346mm, -10.75mm, -1.44mm), radius=0.15mm, height=1.68mm)
  V295_DCN = cylinder(axis=Z, base_centre=(16.6423mm, -0.5mm, -1.44mm), radius=0.15mm, height=1.68mm)
  V296_DCN = cylinder(axis=Z, base_centre=(-17.8269mm, -10.75mm, -1.44mm), radius=0.15mm, height=1.68mm)
  V297_DCN = cylinder(axis=Z, base_centre=(17.35mm, 13.4mm, -1.44mm), radius=0.15mm, height=1.68mm)
  V298_DCN = cylinder(axis=Z, base_centre=(-42.15mm, 19mm, -1.44mm), radius=0.15mm, height=1.68mm)
  V299_DCN = cylinder(axis=Z, base_centre=(43.15mm, 19.75mm, -1.44mm), radius=0.15mm, height=1.68mm)
  V300_DCN = cylinder(axis=Z, base_centre=(-29.6731mm, -0.5mm, -1.44mm), radius=0.15mm, height=1.68mm)
  V301_DCN = cylinder(axis=Z, base_centre=(-15.35mm, 19mm, -1.44mm), radius=0.15mm, height=1.68mm)
  V302_DCN = cylinder(axis=Z, base_centre=(-4.35mm, 14.1mm, -1.44mm), radius=0.15mm, height=1.68mm)
  V303_DCN = cylinder(axis=Z, base_centre=(-32.15mm, 13.4mm, -1.44mm), radius=0.15mm, height=1.68mm)
  V304_DCN = cylinder(axis=Z, base_centre=(-7.35mm, 13.4mm, -1.44mm), radius=0.15mm, height=1.68mm)
  V305_DCN = cylinder(axis=Z, base_centre=(-4.75mm, -0.5mm, -1.44mm), radius=0.15mm, height=1.68mm)
  V306_DCN = cylinder(axis=Z, base_centre=(38.15mm, 19mm, -1.44mm), radius=0.15mm, height=1.68mm)
  V307_DCN = cylinder(axis=Z, base_centre=(7.35mm, 19.75mm, -1.44mm), radius=0.15mm, height=1.68mm)
  V308_DCN = cylinder(axis=Z, base_centre=(40.15mm, 14.8mm, -1.44mm), radius=0.15mm, height=1.68mm)
  V309_DCN = cylinder(axis=Z, base_centre=(-39.15mm, 19.75mm, -1.44mm), radius=0.15mm, height=1.68mm)
  V310_DCN = cylinder(axis=Z, base_centre=(-38.15mm, 19mm, -1.44mm), radius=0.15mm, height=1.68mm)
  V311_DCN = cylinder(axis=Z, base_centre=(-21.3808mm, -10.75mm, -1.44mm), radius=0.15mm, height=1.68mm)
  V312_DCN = cylinder(axis=Z, base_centre=(-26.1192mm, -0.5mm, -1.44mm), radius=0.15mm, height=1.68mm)
  V313_DCN = cylinder(axis=Z, base_centre=(8.35mm, 13.4mm, -1.44mm), radius=0.15mm, height=1.68mm)
  V314_DCN = cylinder(axis=Z, base_centre=(-31.15mm, 19mm, -1.44mm), radius=0.15mm, height=1.68mm)
  V315_DCN = cylinder(axis=Z, base_centre=(8.35mm, 15.5mm, -1.44mm), radius=0.15mm, height=1.68mm)
  V316_DCN = cylinder(axis=Z, base_centre=(-2.35mm, -10.75mm, -1.44mm), radius=0.15mm, height=1.68mm)
  V317_DCN = cylinder(axis=Z, base_centre=(-32.0423mm, -10.75mm, -1.44mm), radius=0.15mm, height=1.68mm)
  V318_DCN = cylinder(axis=Z, base_centre=(12.35mm, 19mm, -1.44mm), radius=0.15mm, height=1.68mm)
  V319_DCN = cylinder(axis=Z, base_centre=(-13.35mm, 13.4mm, -1.44mm), radius=0.15mm, height=1.68mm)
  V320_DCN = cylinder(axis=Z, base_centre=(-43.15mm, 19.75mm, -1.44mm), radius=0.15mm, height=1.68mm)
  V321_DCN = cylinder(axis=Z, base_centre=(-4.35mm, 14.8mm, -1.44mm), radius=0.15mm, height=1.68mm)
  V322_DCN = cylinder(axis=Z, base_centre=(-16.6423mm, -0.5mm, -1.44mm), radius=0.15mm, height=1.68mm)
  V323_DCN = cylinder(axis=Z, base_centre=(-7.35mm, 19.75mm, -1.44mm), radius=0.15mm, height=1.68mm)
  V324_DCN = cylinder(axis=Z, base_centre=(-38.15mm, 19.75mm, -1.44mm), radius=0.15mm, height=1.68mm)
  V325_DCN = cylinder(axis=Z, base_centre=(-28.4885mm, -0.5mm, -1.44mm), radius=0.15mm, height=1.68mm)
  V326_DCN = cylinder(axis=Z, base_centre=(17.35mm, 14.8mm, -1.44mm), radius=0.15mm, height=1.68mm)
  V327_DCN = cylinder(axis=Z, base_centre=(28.4885mm, -0.5mm, -1.44mm), radius=0.15mm, height=1.68mm)
  V328_DCN = cylinder(axis=Z, base_centre=(32.15mm, 14.1mm, -1.44mm), radius=0.15mm, height=1.68mm)
  V329_DCN = cylinder(axis=Z, base_centre=(4.35mm, 15.5mm, -1.44mm), radius=0.15mm, height=1.68mm)
  V330_DCN = cylinder(axis=Z, base_centre=(-23.75mm, -10.75mm, -1.44mm), radius=0.15mm, height=1.68mm)
  V331_DCN = cylinder(axis=Z, base_centre=(-41.15mm, 13.4mm, -1.44mm), radius=0.15mm, height=1.68mm)
  V332_DCN = cylinder(axis=Z, base_centre=(30.15mm, 15.5mm, -1.44mm), radius=0.15mm, height=1.68mm)
  V333_DCN = cylinder(axis=Z, base_centre=(23.75mm, -0.5mm, -1.44mm), radius=0.15mm, height=1.68mm)
  V334_DCN = cylinder(axis=Z, base_centre=(14.2731mm, -10.75mm, -1.44mm), radius=0.15mm, height=1.68mm)
  V335_DCN = cylinder(axis=Z, base_centre=(17.35mm, 14.1mm, -1.44mm), radius=0.15mm, height=1.68mm)
  V336_DCN = cylinder(axis=Z, base_centre=(29.15mm, 14.8mm, -1.44mm), radius=0.15mm, height=1.68mm)
  V337_DCN = cylinder(axis=Z, base_centre=(11.9038mm, -0.5mm, -1.44mm), radius=0.15mm, height=1.68mm)
  V338_DCN = cylinder(axis=Z, base_centre=(9.5346mm, -0.5mm, -1.44mm), radius=0.15mm, height=1.68mm)
  V339_DCN = cylinder(axis=Z, base_centre=(-20.1962mm, -0.5mm, -1.44mm), radius=0.15mm, height=1.68mm)
  V340_DCN = cylinder(axis=Z, base_centre=(-17.35mm, 14.1mm, -1.44mm), radius=0.15mm, height=1.68mm)
  V341_DCN = cylinder(axis=Z, base_centre=(-5.35mm, 15.5mm, -1.44mm), radius=0.15mm, height=1.68mm)
  V342_DCN = cylinder(axis=Z, base_centre=(12.35mm, 13.4mm, -1.44mm), radius=0.15mm, height=1.68mm)
  V343_DCN = cylinder(axis=Z, base_centre=(1.25mm, -0.5mm, -1.44mm), radius=0.15mm, height=1.68mm)
  V344_DCN = cylinder(axis=Z, base_centre=(13.35mm, 19mm, -1.44mm), radius=0.15mm, height=1.68mm)
  V345_DCN = cylinder(axis=Z, base_centre=(15.35mm, 14.1mm, -1.44mm), radius=0.15mm, height=1.68mm)
  V346_DCN = cylinder(axis=Z, base_centre=(37.9654mm, -0.5mm, -1.44mm), radius=0.15mm, height=1.68mm)
  V347_DCN = cylinder(axis=Z, base_centre=(30.8577mm, -0.5mm, -1.44mm), radius=0.15mm, height=1.68mm)
  V348_DCN = cylinder(axis=Z, base_centre=(-26.1192mm, -10.75mm, -1.44mm), radius=0.15mm, height=1.68mm)
  V349_DCN = cylinder(axis=Z, base_centre=(40.15mm, 14.1mm, -1.44mm), radius=0.15mm, height=1.68mm)
  V350_DCN = cylinder(axis=Z, base_centre=(30.8577mm, -10.75mm, -1.44mm), radius=0.15mm, height=1.68mm)
  V351_DCN = cylinder(axis=Z, base_centre=(-32.0423mm, -0.5mm, -1.44mm), radius=0.15mm, height=1.68mm)
  V352_DCN = cylinder(axis=Z, base_centre=(-5.95mm, -10.75mm, -1.44mm), radius=0.15mm, height=1.68mm)
  V353_DCN = cylinder(axis=Z, base_centre=(14.35mm, 13.4mm, -1.44mm), radius=0.15mm, height=1.68mm)
  V354_DCN = cylinder(axis=Z, base_centre=(-14.2731mm, -0.5mm, -1.44mm), radius=0.15mm, height=1.68mm)
  V355_DCN = cylinder(axis=Z, base_centre=(-17.8269mm, -0.5mm, -1.44mm), radius=0.15mm, height=1.68mm)
  V356_DCN = cylinder(axis=Z, base_centre=(14.2731mm, -0.5mm, -1.44mm), radius=0.15mm, height=1.68mm)
  V357_DCN = cylinder(axis=Z, base_centre=(10.35mm, 19mm, -1.44mm), radius=0.15mm, height=1.68mm)
  V358_DCN = cylinder(axis=Z, base_centre=(-42.15mm, 19.75mm, -1.44mm), radius=0.15mm, height=1.68mm)
  V359_DCN = cylinder(axis=Z, base_centre=(-7.15mm, -0.5mm, -1.44mm), radius=0.15mm, height=1.68mm)
  V360_DCN = cylinder(axis=Z, base_centre=(16.35mm, 14.1mm, -1.44mm), radius=0.15mm, height=1.68mm)
  V361_DCN = cylinder(axis=Z, base_centre=(-34.15mm, 19.75mm, -1.44mm), radius=0.15mm, height=1.68mm)
  V362_DCN = cylinder(axis=Z, base_centre=(27.3038mm, -0.5mm, -1.44mm), radius=0.15mm, height=1.68mm)
  V363_DCN = cylinder(axis=Z, base_centre=(34.4115mm, -10.75mm, -1.44mm), radius=0.15mm, height=1.68mm)
  V364_DCN = cylinder(axis=Z, base_centre=(-16.35mm, 19mm, -1.44mm), radius=0.15mm, height=1.68mm)
  V365_DCN = cylinder(axis=Z, base_centre=(14.35mm, 19.75mm, -1.44mm), radius=0.15mm, height=1.68mm)
  V366_DCN = cylinder(axis=Z, base_centre=(-41.15mm, 14.8mm, -1.44mm), radius=0.15mm, height=1.68mm)
  V367_DCN = cylinder(axis=Z, base_centre=(-32.15mm, 19.75mm, -1.44mm), radius=0.15mm, height=1.68mm)
  V368_DCN = cylinder(axis=Z, base_centre=(29.15mm, 14.1mm, -1.44mm), radius=0.15mm, height=1.68mm)
  V369_DCN = cylinder(axis=Z, base_centre=(39.15mm, 15.5mm, -1.44mm), radius=0.15mm, height=1.68mm)
  V370_DCN = cylinder(axis=Z, base_centre=(-30.15mm, 14.1mm, -1.44mm), radius=0.15mm, height=1.68mm)
  V371_DCN = cylinder(axis=Z, base_centre=(-9.5346mm, -10.75mm, -1.44mm), radius=0.15mm, height=1.68mm)
  V372_DCN = cylinder(axis=Z, base_centre=(-4.35mm, 15.5mm, -1.44mm), radius=0.15mm, height=1.68mm)
  V373_DCN = cylinder(axis=Z, base_centre=(10.35mm, 19.75mm, -1.44mm), radius=0.15mm, height=1.68mm)
  V374_DCN = cylinder(axis=Z, base_centre=(-24.9346mm, -0.5mm, -1.44mm), radius=0.15mm, height=1.68mm)
  V375_DCN = cylinder(axis=Z, base_centre=(20.1962mm, -10.75mm, -1.44mm), radius=0.15mm, height=1.68mm)
  V376_DCN = cylinder(axis=Z, base_centre=(-5.35mm, 19.75mm, -1.44mm), radius=0.15mm, height=1.68mm)
  V377_DCN = cylinder(axis=Z, base_centre=(-37.9654mm, -0.5mm, -1.44mm), radius=0.15mm, height=1.68mm)
  V378_DCN = cylinder(axis=Z, base_centre=(-3.55mm, -10.75mm, -1.44mm), radius=0.15mm, height=1.68mm)
  V379_DCN = cylinder(axis=Z, base_centre=(4.85mm, -0.5mm, -1.44mm), radius=0.15mm, height=1.68mm)
  V380_DCN = cylinder(axis=Z, base_centre=(22.5654mm, -10.75mm, -1.44mm), radius=0.15mm, height=1.68mm)
  V381_DCN = cylinder(axis=Z, base_centre=(40.15mm, 19.75mm, -1.44mm), radius=0.15mm, height=1.68mm)
  V382_DCN = cylinder(axis=Z, base_centre=(31.15mm, 14.1mm, -1.44mm), radius=0.15mm, height=1.68mm)
  V383_DCN = cylinder(axis=Z, base_centre=(-39.15mm, -0.5mm, -1.44mm), radius=0.15mm, height=1.68mm)
  V384_DCN = cylinder(axis=Z, base_centre=(-39.15mm, -10.75mm, -1.44mm), radius=0.15mm, height=1.68mm)
  V385_DCN = cylinder(axis=Z, base_centre=(19.0115mm, -0.5mm, -1.44mm), radius=0.15mm, height=1.68mm)
  V386_DCN = cylinder(axis=Z, base_centre=(-5.35mm, 14.1mm, -1.44mm), radius=0.15mm, height=1.68mm)
  V387_DCN = cylinder(axis=Z, base_centre=(17.35mm, 15.5mm, -1.44mm), radius=0.15mm, height=1.68mm)
  V388_DCN = cylinder(axis=Z, base_centre=(-18.35mm, 14.8mm, -1.44mm), radius=0.15mm, height=1.68mm)
  V389_DCN = cylinder(axis=Z, base_centre=(-17.35mm, 19mm, -1.44mm), radius=0.15mm, height=1.68mm)
  V390_DCN = cylinder(axis=Z, base_centre=(21.3808mm, -10.75mm, -1.44mm), radius=0.15mm, height=1.68mm)
  V391_DCN = cylinder(axis=Z, base_centre=(-16.35mm, 14.8mm, -1.44mm), radius=0.15mm, height=1.68mm)
  V392_DCN = cylinder(axis=Z, base_centre=(-39.15mm, 13.4mm, -1.44mm), radius=0.15mm, height=1.68mm)
  V393_DCN = cylinder(axis=Z, base_centre=(22.5654mm, -0.5mm, -1.44mm), radius=0.15mm, height=1.68mm)
  V394_DCN = cylinder(axis=Z, base_centre=(4.35mm, 19.75mm, -1.44mm), radius=0.15mm, height=1.68mm)
  V395_DCN = cylinder(axis=Z, base_centre=(-30.15mm, 13.4mm, -1.44mm), radius=0.15mm, height=1.68mm)
  V396_DCN = cylinder(axis=Z, base_centre=(-14.35mm, 13.4mm, -1.44mm), radius=0.15mm, height=1.68mm)
  V397_DCN = cylinder(axis=Z, base_centre=(-6.35mm, 14.8mm, -1.44mm), radius=0.15mm, height=1.68mm)
  V398_DCN = cylinder(axis=Z, base_centre=(-37.15mm, 19mm, -1.44mm), radius=0.15mm, height=1.68mm)
  V399_DCN = cylinder(axis=Z, base_centre=(35.15mm, 19mm, -1.44mm), radius=0.15mm, height=1.68mm)
  V400_DCN = cylinder(axis=Z, base_centre=(-31.15mm, 15.5mm, -1.44mm), radius=0.15mm, height=1.68mm)
  V401_DCN = cylinder(axis=Z, base_centre=(2.45mm, -0.5mm, -1.44mm), radius=0.15mm, height=1.68mm)
  V402_DCN = cylinder(axis=Z, base_centre=(-40.15mm, 14.8mm, -1.44mm), radius=0.15mm, height=1.68mm)
  V403_DCN = cylinder(axis=Z, base_centre=(29.6731mm, -10.75mm, -1.44mm), radius=0.15mm, height=1.68mm)
  V404_DCN = cylinder(axis=Z, base_centre=(-11.35mm, 19.75mm, -1.44mm), radius=0.15mm, height=1.68mm)
  V405_DCN = cylinder(axis=Z, base_centre=(-36.7808mm, -10.75mm, -1.44mm), radius=0.15mm, height=1.68mm)
  V406_DCN = cylinder(axis=Z, base_centre=(-8.35mm, -0.5mm, -1.44mm), radius=0.15mm, height=1.68mm)
  V407_DCN = cylinder(axis=Z, base_centre=(-10.7192mm, -0.5mm, -1.44mm), radius=0.15mm, height=1.68mm)
  V408_DCN = cylinder(axis=Z, base_centre=(-15.35mm, 14.1mm, -1.44mm), radius=0.15mm, height=1.68mm)
  V409_DCN = cylinder(axis=Z, base_centre=(-15.35mm, 19.75mm, -1.44mm), radius=0.15mm, height=1.68mm)
  V410_DCN = cylinder(axis=Z, base_centre=(8.35mm, 14.8mm, -1.44mm), radius=0.15mm, height=1.68mm)
  V411_DCN = cylinder(axis=Z, base_centre=(21.3808mm, -0.5mm, -1.44mm), radius=0.15mm, height=1.68mm)
  V412_DCN = cylinder(axis=Z, base_centre=(-4.35mm, 19.75mm, -1.44mm), radius=0.15mm, height=1.68mm)
  V413_DCN = cylinder(axis=Z, base_centre=(35.5962mm, -10.75mm, -1.44mm), radius=0.15mm, height=1.68mm)
  V414_DCN = cylinder(axis=Z, base_centre=(-41.15mm, 15.5mm, -1.44mm), radius=0.15mm, height=1.68mm)
  V415_DCN = cylinder(axis=Z, base_centre=(-12.35mm, 19mm, -1.44mm), radius=0.15mm, height=1.68mm)
  V416_DCN = cylinder(axis=Z, base_centre=(4.35mm, 13.4mm, -1.44mm), radius=0.15mm, height=1.68mm)
  V417_DCN = cylinder(axis=Z, base_centre=(39.15mm, 14.8mm, -1.44mm), radius=0.15mm, height=1.68mm)
  V418_DCN = cylinder(axis=Z, base_centre=(-42.15mm, 15.5mm, -1.44mm), radius=0.15mm, height=1.68mm)
  V419_DCN = cylinder(axis=Z, base_centre=(27.3038mm, -10.75mm, -1.44mm), radius=0.15mm, height=1.68mm)
  V420_DCN = cylinder(axis=Z, base_centre=(26.1192mm, -0.5mm, -1.44mm), radius=0.15mm, height=1.68mm)
  V421_DCN = cylinder(axis=Z, base_centre=(-8.35mm, 19mm, -1.44mm), radius=0.15mm, height=1.68mm)
  V422_DCN = cylinder(axis=Z, base_centre=(30.15mm, 13.4mm, -1.44mm), radius=0.15mm, height=1.68mm)
  V423_DCN = cylinder(axis=Z, base_centre=(1.25mm, -10.75mm, -1.44mm), radius=0.15mm, height=1.68mm)
  V424_DCN = cylinder(axis=Z, base_centre=(9.35mm, 19mm, -1.44mm), radius=0.15mm, height=1.68mm)
  V425_DCN = cylinder(axis=Z, base_centre=(16.35mm, 19mm, -1.44mm), radius=0.15mm, height=1.68mm)
  V426_DCN = cylinder(axis=Z, base_centre=(29.15mm, 13.4mm, -1.44mm), radius=0.15mm, height=1.68mm)
  V427_DCN = cylinder(axis=Z, base_centre=(-10.35mm, 19.75mm, -1.44mm), radius=0.15mm, height=1.68mm)
  V428_DCN = cylinder(axis=Z, base_centre=(7mm, 4mm, -1.44mm), radius=0.15mm, height=1.68mm)
  V429_DCN = cylinder(axis=Z, base_centre=(-37.9654mm, -10.75mm, -1.44mm), radius=0.15mm, height=1.68mm)
  V430_DCN = cylinder(axis=Z, base_centre=(-32.15mm, 14.1mm, -1.44mm), radius=0.15mm, height=1.68mm)
  V431_DCN = cylinder(axis=Z, base_centre=(10.7192mm, -10.75mm, -1.44mm), radius=0.15mm, height=1.68mm)
  V432_DCN = cylinder(axis=Z, base_centre=(-35.15mm, 19mm, -1.44mm), radius=0.15mm, height=1.68mm)
  V433_DCN = cylinder(axis=Z, base_centre=(-39.15mm, 14.8mm, -1.44mm), radius=0.15mm, height=1.68mm)
  V434_DCN = cylinder(axis=Z, base_centre=(39.15mm, -10.75mm, -1.44mm), radius=0.15mm, height=1.68mm)
  V435_DCN = cylinder(axis=Z, base_centre=(17.35mm, 19.75mm, -1.44mm), radius=0.15mm, height=1.68mm)
  V436_DCN = cylinder(axis=Z, base_centre=(-3.55mm, -0.5mm, -1.44mm), radius=0.15mm, height=1.68mm)
  V437_DCN = cylinder(axis=Z, base_centre=(9.35mm, 19.75mm, -1.44mm), radius=0.15mm, height=1.68mm)
  V438_DCN = cylinder(axis=Z, base_centre=(24.9346mm, -0.5mm, -1.44mm), radius=0.15mm, height=1.68mm)
  V439_DCN = cylinder(axis=Z, base_centre=(43.15mm, 15.5mm, -1.44mm), radius=0.15mm, height=1.68mm)
  V440_DCN = cylinder(axis=Z, base_centre=(15.35mm, 19mm, -1.44mm), radius=0.15mm, height=1.68mm)
  V441_DCN = cylinder(axis=Z, base_centre=(26.1192mm, -10.75mm, -1.44mm), radius=0.15mm, height=1.68mm)
  V442_DCN = cylinder(axis=Z, base_centre=(39.15mm, 19.75mm, -1.44mm), radius=0.15mm, height=1.68mm)
  V443_DCN = cylinder(axis=Z, base_centre=(-39.15mm, 15.5mm, -1.44mm), radius=0.15mm, height=1.68mm)
  V444_DCN = cylinder(axis=Z, base_centre=(-31.15mm, 13.4mm, -1.44mm), radius=0.15mm, height=1.68mm)
  V445_DCN = cylinder(axis=Z, base_centre=(23.75mm, -10.75mm, -1.44mm), radius=0.15mm, height=1.68mm)
  V446_DCN = cylinder(axis=Z, base_centre=(12.35mm, 19.75mm, -1.44mm), radius=0.15mm, height=1.68mm)
  V447_DCN = cylinder(axis=Z, base_centre=(-29.6731mm, -10.75mm, -1.44mm), radius=0.15mm, height=1.68mm)
  V448_DCN = cylinder(axis=Z, base_centre=(13.0885mm, -0.5mm, -1.44mm), radius=0.15mm, height=1.68mm)
  V449_DCN = cylinder(axis=Z, base_centre=(7.35mm, 13.4mm, -1.44mm), radius=0.15mm, height=1.68mm)
  V450_DCN = cylinder(axis=Z, base_centre=(32.15mm, 13.4mm, -1.44mm), radius=0.15mm, height=1.68mm)
  V451_DCN = cylinder(axis=Z, base_centre=(-40.15mm, 13.4mm, -1.44mm), radius=0.15mm, height=1.68mm)
  V452_DCN = cylinder(axis=Z, base_centre=(28.4885mm, -10.75mm, -1.44mm), radius=0.15mm, height=1.68mm)
  V453_DCN = cylinder(axis=Z, base_centre=(40.15mm, 13.4mm, -1.44mm), radius=0.15mm, height=1.68mm)
  V454_DCN = cylinder(axis=Z, base_centre=(-14.2731mm, -10.75mm, -1.44mm), radius=0.15mm, height=1.68mm)
  V455_DCN = cylinder(axis=Z, base_centre=(-40.15mm, 14.1mm, -1.44mm), radius=0.15mm, height=1.68mm)
  V456_DCN = cylinder(axis=Z, base_centre=(-37.15mm, 19.75mm, -1.44mm), radius=0.15mm, height=1.68mm)
  V457_DCN = cylinder(axis=Z, base_centre=(-15.35mm, 13.4mm, -1.44mm), radius=0.15mm, height=1.68mm)
  V458_DCN = cylinder(axis=Z, base_centre=(-43.15mm, 15.5mm, -1.44mm), radius=0.15mm, height=1.68mm)
  V459_DCN = cylinder(axis=Z, base_centre=(-17.35mm, 13.4mm, -1.44mm), radius=0.15mm, height=1.68mm)
  V460_DCN = cylinder(axis=Z, base_centre=(-36.15mm, 19.75mm, -1.44mm), radius=0.15mm, height=1.68mm)
  V461_DCN = cylinder(axis=Z, base_centre=(36.15mm, 19mm, -1.44mm), radius=0.15mm, height=1.68mm)
  V462_DCN = cylinder(axis=Z, base_centre=(6.05mm, -0.5mm, -1.44mm), radius=0.15mm, height=1.68mm)
  V463_DCN = cylinder(axis=Z, base_centre=(-8.35mm, 14.8mm, -1.44mm), radius=0.15mm, height=1.68mm)
  V464_DCN = cylinder(axis=Z, base_centre=(-28.4885mm, -10.75mm, -1.44mm), radius=0.15mm, height=1.68mm)
  V465_DCN = cylinder(axis=Z, base_centre=(-17.35mm, 19.75mm, -1.44mm), radius=0.15mm, height=1.68mm)
  V466_DCN = cylinder(axis=Z, base_centre=(-7.35mm, 19mm, -1.44mm), radius=0.15mm, height=1.68mm)
  V467_DCN = cylinder(axis=Z, base_centre=(40.15mm, 19mm, -1.44mm), radius=0.15mm, height=1.68mm)
  V468_DCN = cylinder(axis=Z, base_centre=(-11.9038mm, -10.75mm, -1.44mm), radius=0.15mm, height=1.68mm)
  V469_DCN = cylinder(axis=Z, base_centre=(17.35mm, 19mm, -1.44mm), radius=0.15mm, height=1.68mm)
  V470_DCN = cylinder(axis=Z, base_centre=(39.15mm, -0.5mm, -1.44mm), radius=0.15mm, height=1.68mm)
  V471_DCN = cylinder(axis=Z, base_centre=(31.15mm, 14.8mm, -1.44mm), radius=0.15mm, height=1.68mm)
  V472_DCN = cylinder(axis=Z, base_centre=(-42.15mm, 14.1mm, -1.44mm), radius=0.15mm, height=1.68mm)
  V473_DCN = cylinder(axis=Z, base_centre=(-17.35mm, 14.8mm, -1.44mm), radius=0.15mm, height=1.68mm)
  V474_DCN = cylinder(axis=Z, base_centre=(-15.4577mm, -10.75mm, -1.44mm), radius=0.15mm, height=1.68mm)
  V475_DCN = cylinder(axis=Z, base_centre=(4.35mm, 14.1mm, -1.44mm), radius=0.15mm, height=1.68mm)
  V476_DCN = cylinder(axis=Z, base_centre=(-30.8577mm, -10.75mm, -1.44mm), radius=0.15mm, height=1.68mm)
  V477_DCN = cylinder(axis=Z, base_centre=(-4.35mm, 13.4mm, -1.44mm), radius=0.15mm, height=1.68mm)
  V478_DCN = cylinder(axis=Z, base_centre=(20.1962mm, -0.5mm, -1.44mm), radius=0.15mm, height=1.68mm)
  V479_DCN = cylinder(axis=Z, base_centre=(-41.15mm, 19.75mm, -1.44mm), radius=0.15mm, height=1.68mm)
  V480_DCN = cylinder(axis=Z, base_centre=(8.35mm, 19mm, -1.44mm), radius=0.15mm, height=1.68mm)
  V481_DCN = cylinder(axis=Z, base_centre=(-43.15mm, 14.1mm, -1.44mm), radius=0.15mm, height=1.68mm)
  V482_DCN = cylinder(axis=Z, base_centre=(-36.15mm, 19mm, -1.44mm), radius=0.15mm, height=1.68mm)
  V483_DCN = cylinder(axis=Z, base_centre=(-9.35mm, 19mm, -1.44mm), radius=0.15mm, height=1.68mm)
  V484_DCN = cylinder(axis=Z, base_centre=(-36.7808mm, -0.5mm, -1.44mm), radius=0.15mm, height=1.68mm)
  V485_DCN = cylinder(axis=Z, base_centre=(9.5346mm, -10.75mm, -1.44mm), radius=0.15mm, height=1.68mm)
  V486_DCN = cylinder(axis=Z, base_centre=(7.35mm, 14.1mm, -1.44mm), radius=0.15mm, height=1.68mm)
  V487_DCN = cylinder(axis=Z, base_centre=(13.35mm, 13.4mm, -1.44mm), radius=0.15mm, height=1.68mm)
  V488_DCN = cylinder(axis=Z, base_centre=(11.35mm, 19.75mm, -1.44mm), radius=0.15mm, height=1.68mm)
  V489_DCN = cylinder(axis=Z, base_centre=(30.15mm, 14.8mm, -1.44mm), radius=0.15mm, height=1.68mm)
  V490_DCN = cylinder(axis=Z, base_centre=(8.35mm, -0.5mm, -1.44mm), radius=0.15mm, height=1.68mm)
  V491_DCN = cylinder(axis=Z, base_centre=(-31.15mm, 14.1mm, -1.44mm), radius=0.15mm, height=1.68mm)
  V492_DCN = cylinder(axis=Z, base_centre=(-40.15mm, 19.75mm, -1.44mm), radius=0.15mm, height=1.68mm)
  V493_DCN = cylinder(axis=Z, base_centre=(10.7192mm, -0.5mm, -1.44mm), radius=0.15mm, height=1.68mm)
  V494_DCN = cylinder(axis=Z, base_centre=(-8.35mm, 19.75mm, -1.44mm), radius=0.15mm, height=1.68mm)
  V495_DCN = cylinder(axis=Z, base_centre=(17.8269mm, -10.75mm, -1.44mm), radius=0.15mm, height=1.68mm)
  V496_DCN = cylinder(axis=Z, base_centre=(-43.15mm, 14.8mm, -1.44mm), radius=0.15mm, height=1.68mm)
  V497_DCN = cylinder(axis=Z, base_centre=(34.15mm, 19mm, -1.44mm), radius=0.15mm, height=1.68mm)
  V498_DCN = cylinder(axis=Z, base_centre=(-33.15mm, 19mm, -1.44mm), radius=0.15mm, height=1.68mm)
  V499_DCN = cylinder(axis=Z, base_centre=(16.35mm, 13.4mm, -1.44mm), radius=0.15mm, height=1.68mm)
  V500_DCN = cylinder(axis=Z, base_centre=(43.15mm, 14.8mm, -1.44mm), radius=0.15mm, height=1.68mm)
  V501_DCN = cylinder(axis=Z, base_centre=(-27.3038mm, -10.75mm, -1.44mm), radius=0.15mm, height=1.68mm)
  V502_DCN = cylinder(axis=Z, base_centre=(-34.15mm, 13.4mm, -1.44mm), radius=0.15mm, height=1.68mm)
  V503_DCN = cylinder(axis=Z, base_centre=(-6.35mm, 19mm, -1.44mm), radius=0.15mm, height=1.68mm)
  V504_DCN = cylinder(axis=Z, base_centre=(-33.2269mm, -0.5mm, -1.44mm), radius=0.15mm, height=1.68mm)
  V505_DCN = cylinder(axis=Z, base_centre=(37.15mm, 19.75mm, -1.44mm), radius=0.15mm, height=1.68mm)
  V506_DCN = cylinder(axis=Z, base_centre=(-38.15mm, 14.8mm, -1.44mm), radius=0.15mm, height=1.68mm)
  V507_DCN = cylinder(axis=Z, base_centre=(-40.15mm, 19mm, -1.44mm), radius=0.15mm, height=1.68mm)
  V508_DCN = cylinder(axis=Z, base_centre=(-31.15mm, 19.75mm, -1.44mm), radius=0.15mm, height=1.68mm)
  V509_DCN = cylinder(axis=Z, base_centre=(-9.35mm, 14.8mm, -1.44mm), radius=0.15mm, height=1.68mm)
  V510_DCN = cylinder(axis=Z, base_centre=(39.15mm, 14.1mm, -1.44mm), radius=0.15mm, height=1.68mm)
  V511_DCN = cylinder(axis=Z, base_centre=(-35.15mm, 13.4mm, -1.44mm), radius=0.15mm, height=1.68mm)
  V512_DCN = cylinder(axis=Z, base_centre=(-30.8577mm, -0.5mm, -1.44mm), radius=0.15mm, height=1.68mm)
  V513_DCN = cylinder(axis=Z, base_centre=(43.15mm, 19mm, -1.44mm), radius=0.15mm, height=1.68mm)
  V514_DCN = cylinder(axis=Z, base_centre=(38.15mm, 14.8mm, -1.44mm), radius=0.15mm, height=1.68mm)
  V515_DCN = cylinder(axis=Z, base_centre=(35.15mm, 13.4mm, -1.44mm), radius=0.15mm, height=1.68mm)
  V516_DCN = cylinder(axis=Z, base_centre=(-4.75mm, -10.75mm, -1.44mm), radius=0.15mm, height=1.68mm)
  V517_DCN = cylinder(axis=Z, base_centre=(-43.15mm, 19mm, -1.44mm), radius=0.15mm, height=1.68mm)
  V518_DCN = cylinder(axis=Z, base_centre=(-39.15mm, 14.1mm, -1.44mm), radius=0.15mm, height=1.68mm)
  V519_DCN = cylinder(axis=Z, base_centre=(7.35mm, 15.5mm, -1.44mm), radius=0.15mm, height=1.68mm)
  V520_DCN = cylinder(axis=Z, base_centre=(-8.35mm, 15.5mm, -1.44mm), radius=0.15mm, height=1.68mm)
  V521_DCN = cylinder(axis=Z, base_centre=(37.15mm, 19mm, -1.44mm), radius=0.15mm, height=1.68mm)
  V522_DCN = cylinder(axis=Z, base_centre=(39.15mm, 13.4mm, -1.44mm), radius=0.15mm, height=1.68mm)
  V523_DCN = cylinder(axis=Z, base_centre=(-31.15mm, 14.8mm, -1.44mm), radius=0.15mm, height=1.68mm)
  V524_DCN = cylinder(axis=Z, base_centre=(-13.35mm, 19mm, -1.44mm), radius=0.15mm, height=1.68mm)
  V525_DCN = cylinder(axis=Z, base_centre=(-39.15mm, 19mm, -1.44mm), radius=0.15mm, height=1.68mm)
  V526_DCN = cylinder(axis=Z, base_centre=(37.9654mm, -10.75mm, -1.44mm), radius=0.15mm, height=1.68mm)
  V527_DCN = cylinder(axis=Z, base_centre=(-1.15mm, -0.5mm, -1.44mm), radius=0.15mm, height=1.68mm)
  V528_DCN = cylinder(axis=Z, base_centre=(-34.4115mm, -10.75mm, -1.44mm), radius=0.15mm, height=1.68mm)
  V529_AC = cylinder(axis=Z, base_centre=(-43.05mm, 26.4mm, -1.44mm), radius=0.15mm, height=1.68mm)
  V530_AC = cylinder(axis=Z, base_centre=(-6.05mm, 26.4mm, -1.44mm), radius=0.15mm, height=1.68mm)
  V531_AC = cylinder(axis=Z, base_centre=(-41.85mm, 24mm, -1.44mm), radius=0.15mm, height=1.68mm)
  V532_AC = cylinder(axis=Z, base_centre=(-6.05mm, 24mm, -1.44mm), radius=0.15mm, height=1.68mm)
  V533_AC = cylinder(axis=Z, base_centre=(-40.65mm, 26.4mm, -1.44mm), radius=0.15mm, height=1.68mm)
  V534_AC = cylinder(axis=Z, base_centre=(-39.45mm, 27.6mm, -1.44mm), radius=0.15mm, height=1.68mm)
  V535_AC = cylinder(axis=Z, base_centre=(-43.05mm, 24mm, -1.44mm), radius=0.15mm, height=1.68mm)
  V536_AC = cylinder(axis=Z, base_centre=(-40.65mm, 27.6mm, -1.44mm), radius=0.15mm, height=1.68mm)
  V537_AC = cylinder(axis=Z, base_centre=(-39.45mm, 21.6mm, -1.44mm), radius=0.15mm, height=1.68mm)
  V538_AC = cylinder(axis=Z, base_centre=(9.25mm, 30mm, -1.44mm), radius=0.15mm, height=1.68mm)
  V539_AC = cylinder(axis=Z, base_centre=(-7.25mm, 27.6mm, -1.44mm), radius=0.15mm, height=1.68mm)
  V540_AC = cylinder(axis=Z, base_centre=(9.25mm, 27.6mm, -1.44mm), radius=0.15mm, height=1.68mm)
  V541_AC = cylinder(axis=Z, base_centre=(40.25mm, 30mm, -1.44mm), radius=0.15mm, height=1.68mm)
  V542_AC = cylinder(axis=Z, base_centre=(-40.65mm, 25.2mm, -1.44mm), radius=0.15mm, height=1.68mm)
  V543_AC = cylinder(axis=Z, base_centre=(-7.25mm, 26.4mm, -1.44mm), radius=0.15mm, height=1.68mm)
  V544_AC = cylinder(axis=Z, base_centre=(6.85mm, 24mm, -1.44mm), radius=0.15mm, height=1.68mm)
  V545_AC = cylinder(axis=Z, base_centre=(-39.45mm, 26.4mm, -1.44mm), radius=0.15mm, height=1.68mm)
  V546_AC = cylinder(axis=Z, base_centre=(42.65mm, 27.6mm, -1.44mm), radius=0.15mm, height=1.68mm)
  V547_AC = cylinder(axis=Z, base_centre=(41.45mm, 28.8mm, -1.44mm), radius=0.15mm, height=1.68mm)
  V548_AC = cylinder(axis=Z, base_centre=(39.05mm, 30mm, -1.44mm), radius=0.15mm, height=1.68mm)
  V549_AC = cylinder(axis=Z, base_centre=(-39.45mm, 25.2mm, -1.44mm), radius=0.15mm, height=1.68mm)
  V550_AC = cylinder(axis=Z, base_centre=(8.05mm, 28.8mm, -1.44mm), radius=0.15mm, height=1.68mm)
  V551_AC = cylinder(axis=Z, base_centre=(40.25mm, 26.4mm, -1.44mm), radius=0.15mm, height=1.68mm)
  V552_AC = cylinder(axis=Z, base_centre=(42.65mm, 22.8mm, -1.44mm), radius=0.15mm, height=1.68mm)
  V553_AC = cylinder(axis=Z, base_centre=(6.85mm, 21.6mm, -1.44mm), radius=0.15mm, height=1.68mm)
  V554_AC = cylinder(axis=Z, base_centre=(-38.25mm, 30mm, -1.44mm), radius=0.15mm, height=1.68mm)
  V555_AC = cylinder(axis=Z, base_centre=(40.25mm, 28.8mm, -1.44mm), radius=0.15mm, height=1.68mm)
  V556_AC = cylinder(axis=Z, base_centre=(-6.05mm, 25.2mm, -1.44mm), radius=0.15mm, height=1.68mm)
  V557_AC = cylinder(axis=Z, base_centre=(42.65mm, 24mm, -1.44mm), radius=0.15mm, height=1.68mm)
  V558_AC = cylinder(axis=Z, base_centre=(-41.85mm, 30mm, -1.44mm), radius=0.15mm, height=1.68mm)
  V559_AC = cylinder(axis=Z, base_centre=(-39.45mm, 28.8mm, -1.44mm), radius=0.15mm, height=1.68mm)
  V560_AC = cylinder(axis=Z, base_centre=(6.85mm, 25.2mm, -1.44mm), radius=0.15mm, height=1.68mm)
  V561_AC = cylinder(axis=Z, base_centre=(5.65mm, 28.8mm, -1.44mm), radius=0.15mm, height=1.68mm)
  V562_AC = cylinder(axis=Z, base_centre=(8.05mm, 22.8mm, -1.44mm), radius=0.15mm, height=1.68mm)
  V563_AC = cylinder(axis=Z, base_centre=(6.85mm, 22.8mm, -1.44mm), radius=0.15mm, height=1.68mm)
  V564_AC = cylinder(axis=Z, base_centre=(40.25mm, 21.6mm, -1.44mm), radius=0.15mm, height=1.68mm)
  V565_AC = cylinder(axis=Z, base_centre=(-6.05mm, 22.8mm, -1.44mm), radius=0.15mm, height=1.68mm)
  V566_AC = cylinder(axis=Z, base_centre=(-7.25mm, 24mm, -1.44mm), radius=0.15mm, height=1.68mm)
  V567_AC = cylinder(axis=Z, base_centre=(6.85mm, 27.6mm, -1.44mm), radius=0.15mm, height=1.68mm)
  V568_AC = cylinder(axis=Z, base_centre=(-4.85mm, 30mm, -1.44mm), radius=0.15mm, height=1.68mm)
  V569_AC = cylinder(axis=Z, base_centre=(9.25mm, 28.8mm, -1.44mm), radius=0.15mm, height=1.68mm)
  V570_AC = cylinder(axis=Z, base_centre=(-7.25mm, 28.8mm, -1.44mm), radius=0.15mm, height=1.68mm)
  V571_AC = cylinder(axis=Z, base_centre=(6.85mm, 26.4mm, -1.44mm), radius=0.15mm, height=1.68mm)
  V572_AC = cylinder(axis=Z, base_centre=(-43.05mm, 25.2mm, -1.44mm), radius=0.15mm, height=1.68mm)
  V573_AC = cylinder(axis=Z, base_centre=(-41.85mm, 25.2mm, -1.44mm), radius=0.15mm, height=1.68mm)
  V574_AC = cylinder(axis=Z, base_centre=(42.65mm, 28.8mm, -1.44mm), radius=0.15mm, height=1.68mm)
  V575_AC = cylinder(axis=Z, base_centre=(42.65mm, 25.2mm, -1.44mm), radius=0.15mm, height=1.68mm)
  V576_AC = cylinder(axis=Z, base_centre=(-7.25mm, 21.6mm, -1.44mm), radius=0.15mm, height=1.68mm)
  V577_AC = cylinder(axis=Z, base_centre=(-8.45mm, 25.2mm, -1.44mm), radius=0.15mm, height=1.68mm)
  V578_AC = cylinder(axis=Z, base_centre=(37.85mm, 28.8mm, -1.44mm), radius=0.15mm, height=1.68mm)
  V579_AC = cylinder(axis=Z, base_centre=(-41.85mm, 26.4mm, -1.44mm), radius=0.15mm, height=1.68mm)
  V580_AC = cylinder(axis=Z, base_centre=(42.65mm, 26.4mm, -1.44mm), radius=0.15mm, height=1.68mm)
  V581_AC = cylinder(axis=Z, base_centre=(41.45mm, 26.4mm, -1.44mm), radius=0.15mm, height=1.68mm)
  V582_AC = cylinder(axis=Z, base_centre=(39.05mm, 28.8mm, -1.44mm), radius=0.15mm, height=1.68mm)
  V583_AC = cylinder(axis=Z, base_centre=(41.45mm, 27.6mm, -1.44mm), radius=0.15mm, height=1.68mm)
  V584_AC = cylinder(axis=Z, base_centre=(-38.25mm, 28.8mm, -1.44mm), radius=0.15mm, height=1.68mm)
  V585_AC = cylinder(axis=Z, base_centre=(39.05mm, 21.6mm, -1.44mm), radius=0.15mm, height=1.68mm)
  V586_AC = cylinder(axis=Z, base_centre=(-6.05mm, 30mm, -1.44mm), radius=0.15mm, height=1.68mm)
  V587_AC = cylinder(axis=Z, base_centre=(8.05mm, 24mm, -1.44mm), radius=0.15mm, height=1.68mm)
  V588_AC = cylinder(axis=Z, base_centre=(4.45mm, 22.8mm, -1.44mm), radius=0.15mm, height=1.68mm)
  V589_AC = cylinder(axis=Z, base_centre=(-8.45mm, 30mm, -1.44mm), radius=0.15mm, height=1.68mm)
  V590_AC = cylinder(axis=Z, base_centre=(5.65mm, 24mm, -1.44mm), radius=0.15mm, height=1.68mm)
  V591_AC = cylinder(axis=Z, base_centre=(-4.85mm, 22.8mm, -1.44mm), radius=0.15mm, height=1.68mm)
  V592_AC = cylinder(axis=Z, base_centre=(8.05mm, 30mm, -1.44mm), radius=0.15mm, height=1.68mm)
  V593_AC = cylinder(axis=Z, base_centre=(-7.25mm, 30mm, -1.44mm), radius=0.15mm, height=1.68mm)
  V594_AC = cylinder(axis=Z, base_centre=(4.45mm, 28.8mm, -1.44mm), radius=0.15mm, height=1.68mm)
  V595_AC = cylinder(axis=Z, base_centre=(40.25mm, 22.8mm, -1.44mm), radius=0.15mm, height=1.68mm)
  V596_AC = cylinder(axis=Z, base_centre=(41.45mm, 25.2mm, -1.44mm), radius=0.15mm, height=1.68mm)
  V597_AC = cylinder(axis=Z, base_centre=(8.05mm, 21.6mm, -1.44mm), radius=0.15mm, height=1.68mm)
  V598_AC = cylinder(axis=Z, base_centre=(-29.2mm, 7.05mm, -1.44mm), radius=0.15mm, height=1.68mm)
  V599_AC = cylinder(axis=Z, base_centre=(-8.45mm, 27.6mm, -1.44mm), radius=0.15mm, height=1.68mm)
  V600_AC = cylinder(axis=Z, base_centre=(-9.65mm, 26.4mm, -1.44mm), radius=0.15mm, height=1.68mm)
  V601_AC = cylinder(axis=Z, base_centre=(40.25mm, 24mm, -1.44mm), radius=0.15mm, height=1.68mm)
  V602_AC = cylinder(axis=Z, base_centre=(-4.85mm, 27.6mm, -1.44mm), radius=0.15mm, height=1.68mm)
  V603_AC = cylinder(axis=Z, base_centre=(8.05mm, 26.4mm, -1.44mm), radius=0.15mm, height=1.68mm)
  V604_AC = cylinder(axis=Z, base_centre=(-41.85mm, 28.8mm, -1.44mm), radius=0.15mm, height=1.68mm)
  V605_AC = cylinder(axis=Z, base_centre=(-4.85mm, 26.4mm, -1.44mm), radius=0.15mm, height=1.68mm)
  V606_AC = cylinder(axis=Z, base_centre=(5.65mm, 26.4mm, -1.44mm), radius=0.15mm, height=1.68mm)
  V607_AC = cylinder(axis=Z, base_centre=(-7.25mm, 22.8mm, -1.44mm), radius=0.15mm, height=1.68mm)
  V608_AC = cylinder(axis=Z, base_centre=(-43.05mm, 28.8mm, -1.44mm), radius=0.15mm, height=1.68mm)
  V609_AC = cylinder(axis=Z, base_centre=(-6.05mm, 27.6mm, -1.44mm), radius=0.15mm, height=1.68mm)
  V610_AC = cylinder(axis=Z, base_centre=(-40.65mm, 28.8mm, -1.44mm), radius=0.15mm, height=1.68mm)
  V611_AC = cylinder(axis=Z, base_centre=(-39.45mm, 22.8mm, -1.44mm), radius=0.15mm, height=1.68mm)
  V612_AC = cylinder(axis=Z, base_centre=(-9.65mm, 27.6mm, -1.44mm), radius=0.15mm, height=1.68mm)
  V613_AC = cylinder(axis=Z, base_centre=(-8.45mm, 24mm, -1.44mm), radius=0.15mm, height=1.68mm)
  V614_AC = cylinder(axis=Z, base_centre=(-9.65mm, 28.8mm, -1.44mm), radius=0.15mm, height=1.68mm)
  V615_AC = cylinder(axis=Z, base_centre=(4.45mm, 24mm, -1.44mm), radius=0.15mm, height=1.68mm)
  V616_AC = cylinder(axis=Z, base_centre=(-41.85mm, 21.6mm, -1.44mm), radius=0.15mm, height=1.68mm)
  V617_AC = cylinder(axis=Z, base_centre=(-8.45mm, 28.8mm, -1.44mm), radius=0.15mm, height=1.68mm)
  V618_AC = cylinder(axis=Z, base_centre=(6.85mm, 28.8mm, -1.44mm), radius=0.15mm, height=1.68mm)
  V619_AC = cylinder(axis=Z, base_centre=(41.45mm, 21.6mm, -1.44mm), radius=0.15mm, height=1.68mm)
  V620_AC = cylinder(axis=Z, base_centre=(5.65mm, 22.8mm, -1.44mm), radius=0.15mm, height=1.68mm)
  V621_AC = cylinder(axis=Z, base_centre=(4.45mm, 30mm, -1.44mm), radius=0.15mm, height=1.68mm)
  V622_AC = cylinder(axis=Z, base_centre=(-9.65mm, 30mm, -1.44mm), radius=0.15mm, height=1.68mm)
  V623_AC = cylinder(axis=Z, base_centre=(18.3mm, 7.05mm, -1.44mm), radius=0.15mm, height=1.68mm)
  V624_AC = cylinder(axis=Z, base_centre=(4.45mm, 26.4mm, -1.44mm), radius=0.15mm, height=1.68mm)
  V625_AC = cylinder(axis=Z, base_centre=(-40.65mm, 30mm, -1.44mm), radius=0.15mm, height=1.68mm)
  V626_AC = cylinder(axis=Z, base_centre=(-4.85mm, 21.6mm, -1.44mm), radius=0.15mm, height=1.68mm)
  V627_AC = cylinder(axis=Z, base_centre=(39.05mm, 24mm, -1.44mm), radius=0.15mm, height=1.68mm)
  V628_AC = cylinder(axis=Z, base_centre=(39.05mm, 26.4mm, -1.44mm), radius=0.15mm, height=1.68mm)
  V629_AC = cylinder(axis=Z, base_centre=(40.25mm, 27.6mm, -1.44mm), radius=0.15mm, height=1.68mm)
  V630_AC = cylinder(axis=Z, base_centre=(6.85mm, 30mm, -1.44mm), radius=0.15mm, height=1.68mm)
  V631_AC = cylinder(axis=Z, base_centre=(-38.25mm, 26.4mm, -1.44mm), radius=0.15mm, height=1.68mm)
  V632_AC = cylinder(axis=Z, base_centre=(8.05mm, 27.6mm, -1.44mm), radius=0.15mm, height=1.68mm)
  V633_AC = cylinder(axis=Z, base_centre=(-4.85mm, 28.8mm, -1.44mm), radius=0.15mm, height=1.68mm)
  V634_AC = cylinder(axis=Z, base_centre=(42.65mm, 21.6mm, -1.44mm), radius=0.15mm, height=1.68mm)
  V635_AC = cylinder(axis=Z, base_centre=(41.45mm, 30mm, -1.44mm), radius=0.15mm, height=1.68mm)
  V636_AC = cylinder(axis=Z, base_centre=(-38.25mm, 27.6mm, -1.44mm), radius=0.15mm, height=1.68mm)
  V637_AC = cylinder(axis=Z, base_centre=(29.2mm, 7.05mm, -1.44mm), radius=0.15mm, height=1.68mm)
  V638_AC = cylinder(axis=Z, base_centre=(5.65mm, 30mm, -1.44mm), radius=0.15mm, height=1.68mm)
  V639_AC = cylinder(axis=Z, base_centre=(-40.65mm, 24mm, -1.44mm), radius=0.15mm, height=1.68mm)
  V640_AC = cylinder(axis=Z, base_centre=(8.05mm, 25.2mm, -1.44mm), radius=0.15mm, height=1.68mm)
  V641_AC = cylinder(axis=Z, base_centre=(4.45mm, 25.2mm, -1.44mm), radius=0.15mm, height=1.68mm)
  V642_AC = cylinder(axis=Z, base_centre=(5.65mm, 27.6mm, -1.44mm), radius=0.15mm, height=1.68mm)
  V643_AC = cylinder(axis=Z, base_centre=(-6.05mm, 28.8mm, -1.44mm), radius=0.15mm, height=1.68mm)
  V644_AC = cylinder(axis=Z, base_centre=(-8.45mm, 26.4mm, -1.44mm), radius=0.15mm, height=1.68mm)
  V645_AC = cylinder(axis=Z, base_centre=(37.85mm, 26.4mm, -1.44mm), radius=0.15mm, height=1.68mm)
  V646_AC = cylinder(axis=Z, base_centre=(-8.45mm, 21.6mm, -1.44mm), radius=0.15mm, height=1.68mm)
  V647_AC = cylinder(axis=Z, base_centre=(37.85mm, 27.6mm, -1.44mm), radius=0.15mm, height=1.68mm)
  V648_AC = cylinder(axis=Z, base_centre=(-6.05mm, 21.6mm, -1.44mm), radius=0.15mm, height=1.68mm)
  V649_AC = cylinder(axis=Z, base_centre=(5.65mm, 25.2mm, -1.44mm), radius=0.15mm, height=1.68mm)
  V650_AC = cylinder(axis=Z, base_centre=(-7.25mm, 25.2mm, -1.44mm), radius=0.15mm, height=1.68mm)
  V651_AC = cylinder(axis=Z, base_centre=(-39.45mm, 24mm, -1.44mm), radius=0.15mm, height=1.68mm)
  V652_AC = cylinder(axis=Z, base_centre=(39.05mm, 27.6mm, -1.44mm), radius=0.15mm, height=1.68mm)
  V653_AC = cylinder(axis=Z, base_centre=(42.65mm, 30mm, -1.44mm), radius=0.15mm, height=1.68mm)
  V654_AC = cylinder(axis=Z, base_centre=(-4.85mm, 24mm, -1.44mm), radius=0.15mm, height=1.68mm)
  V655_AC = cylinder(axis=Z, base_centre=(39.05mm, 22.8mm, -1.44mm), radius=0.15mm, height=1.68mm)
  V656_AC = cylinder(axis=Z, base_centre=(41.45mm, 22.8mm, -1.44mm), radius=0.15mm, height=1.68mm)
  V657_AC = cylinder(axis=Z, base_centre=(-43.05mm, 21.6mm, -1.44mm), radius=0.15mm, height=1.68mm)
  V658_AC = cylinder(axis=Z, base_centre=(41.45mm, 24mm, -1.44mm), radius=0.15mm, height=1.68mm)
  V659_AC = cylinder(axis=Z, base_centre=(9.25mm, 26.4mm, -1.44mm), radius=0.15mm, height=1.68mm)
  V660_AC = cylinder(axis=Z, base_centre=(-40.65mm, 22.8mm, -1.44mm), radius=0.15mm, height=1.68mm)
  V661_AC = cylinder(axis=Z, base_centre=(-8.45mm, 22.8mm, -1.44mm), radius=0.15mm, height=1.68mm)
  V662_AC = cylinder(axis=Z, base_centre=(39.05mm, 25.2mm, -1.44mm), radius=0.15mm, height=1.68mm)
  V663_AC = cylinder(axis=Z, base_centre=(-41.85mm, 27.6mm, -1.44mm), radius=0.15mm, height=1.68mm)
  V664_AC = cylinder(axis=Z, base_centre=(37.85mm, 30mm, -1.44mm), radius=0.15mm, height=1.68mm)
  V665_AC = cylinder(axis=Z, base_centre=(-41.85mm, 22.8mm, -1.44mm), radius=0.15mm, height=1.68mm)
  V666_AC = cylinder(axis=Z, base_centre=(-40.65mm, 21.6mm, -1.44mm), radius=0.15mm, height=1.68mm)
  V667_AC = cylinder(axis=Z, base_centre=(-39.45mm, 30mm, -1.44mm), radius=0.15mm, height=1.68mm)
  V668_AC = cylinder(axis=Z, base_centre=(4.45mm, 27.6mm, -1.44mm), radius=0.15mm, height=1.68mm)
  V669_AC = cylinder(axis=Z, base_centre=(-43.05mm, 22.8mm, -1.44mm), radius=0.15mm, height=1.68mm)
  V670_AC = cylinder(axis=Z, base_centre=(-4.85mm, 25.2mm, -1.44mm), radius=0.15mm, height=1.68mm)
  V671_AC = cylinder(axis=Z, base_centre=(-43.05mm, 30mm, -1.44mm), radius=0.15mm, height=1.68mm)
  V672_AC = cylinder(axis=Z, base_centre=(40.25mm, 25.2mm, -1.44mm), radius=0.15mm, height=1.68mm)
  V673_AC = cylinder(axis=Z, base_centre=(-18.3mm, 7.05mm, -1.44mm), radius=0.15mm, height=1.68mm)
  V674_AC = cylinder(axis=Z, base_centre=(-43.05mm, 27.6mm, -1.44mm), radius=0.15mm, height=1.68mm)
  V675_LSRC1 = cylinder(axis=Z, base_centre=(-37.225mm, 11.8mm, -1.44mm), radius=0.15mm, height=1.68mm)
  V676_LSRC2 = cylinder(axis=Z, base_centre=(-10.275mm, 11.8mm, -1.44mm), radius=0.15mm, height=1.68mm)
  V677_LSRC3 = cylinder(axis=Z, base_centre=(10.275mm, 11.8mm, -1.44mm), radius=0.15mm, height=1.68mm)
  V678_LSRC4 = cylinder(axis=Z, base_centre=(37.225mm, 11.8mm, -1.44mm), radius=0.15mm, height=1.68mm)
  V679_DCP = cylinder(axis=Z, base_centre=(-8.935mm, -21.735mm, -1.44mm), radius=0.925mm, height=1.68mm)
  V680_DCP = cylinder(axis=Z, base_centre=(-8.935mm, -15.865mm, -1.44mm), radius=0.925mm, height=1.68mm)
  V681_DCP = cylinder(axis=Z, base_centre=(-3.065mm, -21.735mm, -1.44mm), radius=0.925mm, height=1.68mm)
  V682_DCP = cylinder(axis=Z, base_centre=(-3.065mm, -15.865mm, -1.44mm), radius=0.925mm, height=1.68mm)
  V683_DCN = cylinder(axis=Z, base_centre=(3.065mm, -21.735mm, -1.44mm), radius=0.925mm, height=1.68mm)
  V684_DCN = cylinder(axis=Z, base_centre=(3.065mm, -15.865mm, -1.44mm), radius=0.925mm, height=1.68mm)
  V685_DCN = cylinder(axis=Z, base_centre=(8.935mm, -21.735mm, -1.44mm), radius=0.925mm, height=1.68mm)
  V686_DCN = cylinder(axis=Z, base_centre=(8.935mm, -15.865mm, -1.44mm), radius=0.925mm, height=1.68mm)
  V687_AC = cylinder(axis=Z, base_centre=(6.85mm, 34.8mm, -1.44mm), radius=0.15mm, height=1.68mm)
  V688_AC = cylinder(axis=Z, base_centre=(27.25mm, 48mm, -1.44mm), radius=0.15mm, height=1.68mm)
  V689_AC = cylinder(axis=Z, base_centre=(16.05mm, 52.8mm, -1.44mm), radius=0.15mm, height=1.68mm)
  V690_AC = cylinder(axis=Z, base_centre=(-33.55mm, 44.8mm, -1.44mm), radius=0.15mm, height=1.68mm)
  V691_AC = cylinder(axis=Z, base_centre=(17.65mm, 48mm, -1.44mm), radius=0.15mm, height=1.68mm)
  V692_AC = cylinder(axis=Z, base_centre=(22.45mm, 48mm, -1.44mm), radius=0.15mm, height=1.68mm)
  V693_AC = cylinder(axis=Z, base_centre=(-43.05mm, 31.2mm, -1.44mm), radius=0.15mm, height=1.68mm)
  V694_AC = cylinder(axis=Z, base_centre=(-22.35mm, 40mm, -1.44mm), radius=0.15mm, height=1.68mm)
  V695_AC = cylinder(axis=Z, base_centre=(-33.55mm, 52.8mm, -1.44mm), radius=0.15mm, height=1.68mm)
  V696_AC = cylinder(axis=Z, base_centre=(-25.55mm, 43.2mm, -1.44mm), radius=0.15mm, height=1.68mm)
  V697_AC = cylinder(axis=Z, base_centre=(38.45mm, 52.8mm, -1.44mm), radius=0.15mm, height=1.68mm)
  V698_AC = cylinder(axis=Z, base_centre=(-38.35mm, 49.6mm, -1.44mm), radius=0.15mm, height=1.68mm)
  V699_AC = cylinder(axis=Z, base_centre=(16.05mm, 40mm, -1.44mm), radius=0.15mm, height=1.68mm)
  V700_AC = cylinder(axis=Z, base_centre=(9.65mm, 43.2mm, -1.44mm), radius=0.15mm, height=1.68mm)
  V701_AC = cylinder(axis=Z, base_centre=(40.05mm, 52.8mm, -1.44mm), radius=0.15mm, height=1.68mm)
  V702_AC = cylinder(axis=Z, base_centre=(-9.55mm, 48mm, -1.44mm), radius=0.15mm, height=1.68mm)
  V703_AC = cylinder(axis=Z, base_centre=(-11.15mm, 41.6mm, -1.44mm), radius=0.15mm, height=1.68mm)
  V704_AC = cylinder(axis=Z, base_centre=(-43.15mm, 40mm, -1.44mm), radius=0.15mm, height=1.68mm)
  V705_AC = cylinder(axis=Z, base_centre=(-11.15mm, 48mm, -1.44mm), radius=0.15mm, height=1.68mm)
  V706_AC = cylinder(axis=Z, base_centre=(-30.35mm, 52.8mm, -1.44mm), radius=0.15mm, height=1.68mm)
  V707_AC = cylinder(axis=Z, base_centre=(-8.45mm, 31.2mm, -1.44mm), radius=0.15mm, height=1.68mm)
  V708_AC = cylinder(axis=Z, base_centre=(9.65mm, 44.8mm, -1.44mm), radius=0.15mm, height=1.68mm)
  V709_AC = cylinder(axis=Z, base_centre=(6.45mm, 52.8mm, -1.44mm), radius=0.15mm, height=1.68mm)
  V710_AC = cylinder(axis=Z, base_centre=(-39.45mm, 34.8mm, -1.44mm), radius=0.15mm, height=1.68mm)
  V711_AC = cylinder(axis=Z, base_centre=(-4.75mm, 40mm, -1.44mm), radius=0.15mm, height=1.68mm)
  V712_AC = cylinder(axis=Z, base_centre=(-19.15mm, 46.4mm, -1.44mm), radius=0.15mm, height=1.68mm)
  V713_AC = cylinder(axis=Z, base_centre=(19.25mm, 41.6mm, -1.44mm), radius=0.15mm, height=1.68mm)
  V714_AC = cylinder(axis=Z, base_centre=(27.25mm, 43.2mm, -1.44mm), radius=0.15mm, height=1.68mm)
  V715_AC = cylinder(axis=Z, base_centre=(-33.55mm, 49.6mm, -1.44mm), radius=0.15mm, height=1.68mm)
  V716_AC = cylinder(axis=Z, base_centre=(37.85mm, 33.6mm, -1.44mm), radius=0.15mm, height=1.68mm)
  V717_AC = cylinder(axis=Z, base_centre=(9.25mm, 33.6mm, -1.44mm), radius=0.15mm, height=1.68mm)
  V718_AC = cylinder(axis=Z, base_centre=(-36.75mm, 41.6mm, -1.44mm), radius=0.15mm, height=1.68mm)
  V719_AC = cylinder(axis=Z, base_centre=(-33.55mm, 43.2mm, -1.44mm), radius=0.15mm, height=1.68mm)
  V720_AC = cylinder(axis=Z, base_centre=(-30.35mm, 46.4mm, -1.44mm), radius=0.15mm, height=1.68mm)
  V721_AC = cylinder(axis=Z, base_centre=(40.05mm, 46.4mm, -1.44mm), radius=0.15mm, height=1.68mm)
  V722_AC = cylinder(axis=Z, base_centre=(33.65mm, 51.2mm, -1.44mm), radius=0.15mm, height=1.68mm)
  V723_AC = cylinder(axis=Z, base_centre=(-4.85mm, 36mm, -1.44mm), radius=0.15mm, height=1.68mm)
  V724_AC = cylinder(axis=Z, base_centre=(-39.45mm, 38.4mm, -1.44mm), radius=0.15mm, height=1.68mm)
  V725_AC = cylinder(axis=Z, base_centre=(41.65mm, 43.2mm, -1.44mm), radius=0.15mm, height=1.68mm)
  V726_AC = cylinder(axis=Z, base_centre=(-6.05mm, 31.2mm, -1.44mm), radius=0.15mm, height=1.68mm)
  V727_AC = cylinder(axis=Z, base_centre=(37.85mm, 36mm, -1.44mm), radius=0.15mm, height=1.68mm)
  V728_AC = cylinder(axis=Z, base_centre=(-38.35mm, 51.2mm, -1.44mm), radius=0.15mm, height=1.68mm)
  V729_AC = cylinder(axis=Z, base_centre=(42.65mm, 31.2mm, -1.44mm), radius=0.15mm, height=1.68mm)
  V730_AC = cylinder(axis=Z, base_centre=(22.45mm, 44.8mm, -1.44mm), radius=0.15mm, height=1.68mm)
  V731_AC = cylinder(axis=Z, base_centre=(-39.95mm, 51.2mm, -1.44mm), radius=0.15mm, height=1.68mm)
  V732_AC = cylinder(axis=Z, base_centre=(22.45mm, 51.2mm, -1.44mm), radius=0.15mm, height=1.68mm)
  V733_AC = cylinder(axis=Z, base_centre=(41.45mm, 31.2mm, -1.44mm), radius=0.15mm, height=1.68mm)
  V734_AC = cylinder(axis=Z, base_centre=(22.45mm, 43.2mm, -1.44mm), radius=0.15mm, height=1.68mm)
  V735_AC = cylinder(axis=Z, base_centre=(-17.55mm, 51.2mm, -1.44mm), radius=0.15mm, height=1.68mm)
  V736_AC = cylinder(axis=Z, base_centre=(41.45mm, 33.6mm, -1.44mm), radius=0.15mm, height=1.68mm)
  V737_AC = cylinder(axis=Z, base_centre=(-35.15mm, 43.2mm, -1.44mm), radius=0.15mm, height=1.68mm)
  V738_AC = cylinder(axis=Z, base_centre=(-9.55mm, 52.8mm, -1.44mm), radius=0.15mm, height=1.68mm)
  V739_AC = cylinder(axis=Z, base_centre=(-9.65mm, 37.2mm, -1.44mm), radius=0.15mm, height=1.68mm)
  V740_AC = cylinder(axis=Z, base_centre=(-38.35mm, 48mm, -1.44mm), radius=0.15mm, height=1.68mm)
  V741_AC = cylinder(axis=Z, base_centre=(-43.05mm, 38.4mm, -1.44mm), radius=0.15mm, height=1.68mm)
  V742_AC = cylinder(axis=Z, base_centre=(-19.15mm, 44.8mm, -1.44mm), radius=0.15mm, height=1.68mm)
  V743_AC = cylinder(axis=Z, base_centre=(14.45mm, 43.2mm, -1.44mm), radius=0.15mm, height=1.68mm)
  V744_AC = cylinder(axis=Z, base_centre=(-14.35mm, 44.8mm, -1.44mm), radius=0.15mm, height=1.68mm)
  V745_AC = cylinder(axis=Z, base_centre=(-6.05mm, 33.6mm, -1.44mm), radius=0.15mm, height=1.68mm)
  V746_AC = cylinder(axis=Z, base_centre=(6.85mm, 31.2mm, -1.44mm), radius=0.15mm, height=1.68mm)
  V747_AC = cylinder(axis=Z, base_centre=(24.05mm, 44.8mm, -1.44mm), radius=0.15mm, height=1.68mm)
  V748_AC = cylinder(axis=Z, base_centre=(-30.35mm, 40mm, -1.44mm), radius=0.15mm, height=1.68mm)
  V749_AC = cylinder(axis=Z, base_centre=(-11.15mm, 52.8mm, -1.44mm), radius=0.15mm, height=1.68mm)
  V750_AC = cylinder(axis=Z, base_centre=(38.45mm, 43.2mm, -1.44mm), radius=0.15mm, height=1.68mm)
  V751_AC = cylinder(axis=Z, base_centre=(-23.95mm, 48mm, -1.44mm), radius=0.15mm, height=1.68mm)
  V752_AC = cylinder(axis=Z, base_centre=(38.45mm, 44.8mm, -1.44mm), radius=0.15mm, height=1.68mm)
  V753_AC = cylinder(axis=Z, base_centre=(-20.75mm, 46.4mm, -1.44mm), radius=0.15mm, height=1.68mm)
  V754_AC = cylinder(axis=Z, base_centre=(33.65mm, 52.8mm, -1.44mm), radius=0.15mm, height=1.68mm)
  V755_AC = cylinder(axis=Z, base_centre=(14.45mm, 48mm, -1.44mm), radius=0.15mm, height=1.68mm)
  V756_AC = cylinder(axis=Z, base_centre=(30.45mm, 48mm, -1.44mm), radius=0.15mm, height=1.68mm)
  V757_AC = cylinder(axis=Z, base_centre=(-9.65mm, 32.4mm, -1.44mm), radius=0.15mm, height=1.68mm)
  V758_AC = cylinder(axis=Z, base_centre=(37.85mm, 31.2mm, -1.44mm), radius=0.15mm, height=1.68mm)
  V759_AC = cylinder(axis=Z, base_centre=(36.85mm, 43.2mm, -1.44mm), radius=0.15mm, height=1.68mm)
  V760_AC = cylinder(axis=Z, base_centre=(14.45mm, 51.2mm, -1.44mm), radius=0.15mm, height=1.68mm)
  V761_AC = cylinder(axis=Z, base_centre=(12.85mm, 46.4mm, -1.44mm), radius=0.15mm, height=1.68mm)
  V762_AC = cylinder(axis=Z, base_centre=(-12.75mm, 48mm, -1.44mm), radius=0.15mm, height=1.68mm)
  V763_AC = cylinder(axis=Z, base_centre=(-33.55mm, 41.6mm, -1.44mm), radius=0.15mm, height=1.68mm)
  V764_AC = cylinder(axis=Z, base_centre=(33.65mm, 48mm, -1.44mm), radius=0.15mm, height=1.68mm)
  V765_AC = cylinder(axis=Z, base_centre=(-41.55mm, 49.6mm, -1.44mm), radius=0.15mm, height=1.68mm)
  V766_AC = cylinder(axis=Z, base_centre=(-19.15mm, 52.8mm, -1.44mm), radius=0.15mm, height=1.68mm)
  V767_AC = cylinder(axis=Z, base_centre=(-43.15mm, 41.6mm, -1.44mm), radius=0.15mm, height=1.68mm)
  V768_AC = cylinder(axis=Z, base_centre=(19.25mm, 43.2mm, -1.44mm), radius=0.15mm, height=1.68mm)
  V769_AC = cylinder(axis=Z, base_centre=(9.25mm, 37.2mm, -1.44mm), radius=0.15mm, height=1.68mm)
  V770_AC = cylinder(axis=Z, base_centre=(25.65mm, 52.8mm, -1.44mm), radius=0.15mm, height=1.68mm)
  V771_AC = cylinder(axis=Z, base_centre=(12.85mm, 49.6mm, -1.44mm), radius=0.15mm, height=1.68mm)
  V772_AC = cylinder(axis=Z, base_centre=(17.65mm, 40mm, -1.44mm), radius=0.15mm, height=1.68mm)
  V773_AC = cylinder(axis=Z, base_centre=(40.25mm, 38.4mm, -1.44mm), radius=0.15mm, height=1.68mm)
  V774_AC = cylinder(axis=Z, base_centre=(-33.55mm, 51.2mm, -1.44mm), radius=0.15mm, height=1.68mm)
  V775_AC = cylinder(axis=Z, base_centre=(-9.55mm, 44.8mm, -1.44mm), radius=0.15mm, height=1.68mm)
  V776_AC = cylinder(axis=Z, base_centre=(-6.35mm, 41.6mm, -1.44mm), radius=0.15mm, height=1.68mm)
  V777_AC = cylinder(axis=Z, base_centre=(41.45mm, 37.2mm, -1.44mm), radius=0.15mm, height=1.68mm)
  V778_AC = cylinder(axis=Z, base_centre=(-36.75mm, 48mm, -1.44mm), radius=0.15mm, height=1.68mm)
  V779_AC = cylinder(axis=Z, base_centre=(35.25mm, 40mm, -1.44mm), radius=0.15mm, height=1.68mm)
  V780_AC = cylinder(axis=Z, base_centre=(8.05mm, 31.2mm, -1.44mm), radius=0.15mm, height=1.68mm)
  V781_AC = cylinder(axis=Z, base_centre=(8.05mm, 49.6mm, -1.44mm), radius=0.15mm, height=1.68mm)
  V782_AC = cylinder(axis=Z, base_centre=(19.25mm, 49.6mm, -1.44mm), radius=0.15mm, height=1.68mm)
  V783_AC = cylinder(axis=Z, base_centre=(-9.55mm, 49.6mm, -1.44mm), radius=0.15mm, height=1.68mm)
  V784_AC = cylinder(axis=Z, base_centre=(38.45mm, 49.6mm, -1.44mm), radius=0.15mm, height=1.68mm)
  V785_AC = cylinder(axis=Z, base_centre=(42.65mm, 36mm, -1.44mm), radius=0.15mm, height=1.68mm)
  V786_AC = cylinder(axis=Z, base_centre=(-27.15mm, 52.8mm, -1.44mm), radius=0.15mm, height=1.68mm)
  V787_AC = cylinder(axis=Z, base_centre=(-9.55mm, 51.2mm, -1.44mm), radius=0.15mm, height=1.68mm)
  V788_AC = cylinder(axis=Z, base_centre=(14.45mm, 41.6mm, -1.44mm), radius=0.15mm, height=1.68mm)
  V789_AC = cylinder(axis=Z, base_centre=(14.45mm, 49.6mm, -1.44mm), radius=0.15mm, height=1.68mm)
  V790_AC = cylinder(axis=Z, base_centre=(25.65mm, 48mm, -1.44mm), radius=0.15mm, height=1.68mm)
  V791_AC = cylinder(axis=Z, base_centre=(9.65mm, 51.2mm, -1.44mm), radius=0.15mm, height=1.68mm)
  V792_AC = cylinder(axis=Z, base_centre=(-22.35mm, 48mm, -1.44mm), radius=0.15mm, height=1.68mm)
  V793_AC = cylinder(axis=Z, base_centre=(28.85mm, 46.4mm, -1.44mm), radius=0.15mm, height=1.68mm)
  V794_AC = cylinder(axis=Z, base_centre=(30.45mm, 43.2mm, -1.44mm), radius=0.15mm, height=1.68mm)
  V795_AC = cylinder(axis=Z, base_centre=(-12.75mm, 52.8mm, -1.44mm), radius=0.15mm, height=1.68mm)
  V796_AC = cylinder(axis=Z, base_centre=(30.45mm, 46.4mm, -1.44mm), radius=0.15mm, height=1.68mm)
  V797_AC = cylinder(axis=Z, base_centre=(-40.65mm, 34.8mm, -1.44mm), radius=0.15mm, height=1.68mm)
  V798_AC = cylinder(axis=Z, base_centre=(40.05mm, 43.2mm, -1.44mm), radius=0.15mm, height=1.68mm)
  V799_AC = cylinder(axis=Z, base_centre=(8.05mm, 40mm, -1.44mm), radius=0.15mm, height=1.68mm)
  V800_AC = cylinder(axis=Z, base_centre=(-41.85mm, 33.6mm, -1.44mm), radius=0.15mm, height=1.68mm)
  V801_AC = cylinder(axis=Z, base_centre=(-31.95mm, 49.6mm, -1.44mm), radius=0.15mm, height=1.68mm)
  V802_AC = cylinder(axis=Z, base_centre=(-43.15mm, 48mm, -1.44mm), radius=0.15mm, height=1.68mm)
  V803_AC = cylinder(axis=Z, base_centre=(-17.55mm, 48mm, -1.44mm), radius=0.15mm, height=1.68mm)
  V804_AC = cylinder(axis=Z, base_centre=(19.25mm, 40mm, -1.44mm), radius=0.15mm, height=1.68mm)
  V805_AC = cylinder(axis=Z, base_centre=(-43.05mm, 37.2mm, -1.44mm), radius=0.15mm, height=1.68mm)
  V806_AC = cylinder(axis=Z, base_centre=(30.45mm, 44.8mm, -1.44mm), radius=0.15mm, height=1.68mm)
  V807_AC = cylinder(axis=Z, base_centre=(6.45mm, 41.6mm, -1.44mm), radius=0.15mm, height=1.68mm)
  V808_AC = cylinder(axis=Z, base_centre=(39.05mm, 31.2mm, -1.44mm), radius=0.15mm, height=1.68mm)
  V809_AC = cylinder(axis=Z, base_centre=(30.45mm, 40mm, -1.44mm), radius=0.15mm, height=1.68mm)
  V810_AC = cylinder(axis=Z, base_centre=(-20.75mm, 51.2mm, -1.44mm), radius=0.15mm, height=1.68mm)
  V811_AC = cylinder(axis=Z, base_centre=(19.25mm, 44.8mm, -1.44mm), radius=0.15mm, height=1.68mm)
  V812_AC = cylinder(axis=Z, base_centre=(22.45mm, 49.6mm, -1.44mm), radius=0.15mm, height=1.68mm)
  V813_AC = cylinder(axis=Z, base_centre=(32.05mm, 44.8mm, -1.44mm), radius=0.15mm, height=1.68mm)
  V814_AC = cylinder(axis=Z, base_centre=(17.65mm, 41.6mm, -1.44mm), radius=0.15mm, height=1.68mm)
  V815_AC = cylinder(axis=Z, base_centre=(25.65mm, 51.2mm, -1.44mm), radius=0.15mm, height=1.68mm)
  V816_AC = cylinder(axis=Z, base_centre=(24.05mm, 41.6mm, -1.44mm), radius=0.15mm, height=1.68mm)
  V817_AC = cylinder(axis=Z, base_centre=(11.25mm, 48mm, -1.44mm), radius=0.15mm, height=1.68mm)
  V818_AC = cylinder(axis=Z, base_centre=(-38.25mm, 36mm, -1.44mm), radius=0.15mm, height=1.68mm)
  V819_AC = cylinder(axis=Z, base_centre=(4.85mm, 40mm, -1.44mm), radius=0.15mm, height=1.68mm)
  V820_AC = cylinder(axis=Z, base_centre=(-27.15mm, 46.4mm, -1.44mm), radius=0.15mm, height=1.68mm)
  V821_AC = cylinder(axis=Z, base_centre=(-35.15mm, 40mm, -1.44mm), radius=0.15mm, height=1.68mm)
  V822_AC = cylinder(axis=Z, base_centre=(-15.95mm, 49.6mm, -1.44mm), radius=0.15mm, height=1.68mm)
  V823_AC = cylinder(axis=Z, base_centre=(9.25mm, 34.8mm, -1.44mm), radius=0.15mm, height=1.68mm)
  V824_AC = cylinder(axis=Z, base_centre=(8.05mm, 52.8mm, -1.44mm), radius=0.15mm, height=1.68mm)
  V825_AC = cylinder(axis=Z, base_centre=(-38.25mm, 37.2mm, -1.44mm), radius=0.15mm, height=1.68mm)
  V826_AC = cylinder(axis=Z, base_centre=(35.25mm, 48mm, -1.44mm), radius=0.15mm, height=1.68mm)
  V827_AC = cylinder(axis=Z, base_centre=(41.65mm, 44.8mm, -1.44mm), radius=0.15mm, height=1.68mm)
  V828_AC = cylinder(axis=Z, base_centre=(-15.95mm, 46.4mm, -1.44mm), radius=0.15mm, height=1.68mm)
  V829_AC = cylinder(axis=Z, base_centre=(-41.55mm, 51.2mm, -1.44mm), radius=0.15mm, height=1.68mm)
  V830_AC = cylinder(axis=Z, base_centre=(-8.45mm, 38.4mm, -1.44mm), radius=0.15mm, height=1.68mm)
  V831_AC = cylinder(axis=Z, base_centre=(4.45mm, 32.4mm, -1.44mm), radius=0.15mm, height=1.68mm)
  V832_AC = cylinder(axis=Z, base_centre=(17.65mm, 43.2mm, -1.44mm), radius=0.15mm, height=1.68mm)
  V833_AC = cylinder(axis=Z, base_centre=(-43.05mm, 34.8mm, -1.44mm), radius=0.15mm, height=1.68mm)
  V834_AC = cylinder(axis=Z, base_centre=(-9.55mm, 46.4mm, -1.44mm), radius=0.15mm, height=1.68mm)
  V835_AC = cylinder(axis=Z, base_centre=(40.25mm, 32.4mm, -1.44mm), radius=0.15mm, height=1.68mm)
  V836_AC = cylinder(axis=Z, base_centre=(-15.95mm, 40mm, -1.44mm), radius=0.15mm, height=1.68mm)
  V837_AC = cylinder(axis=Z, base_centre=(27.25mm, 41.6mm, -1.44mm), radius=0.15mm, height=1.68mm)
  V838_AC = cylinder(axis=Z, base_centre=(41.45mm, 38.4mm, -1.44mm), radius=0.15mm, height=1.68mm)
  V839_AC = cylinder(axis=Z, base_centre=(-35.15mm, 51.2mm, -1.44mm), radius=0.15mm, height=1.68mm)
  V840_AC = cylinder(axis=Z, base_centre=(42.65mm, 34.8mm, -1.44mm), radius=0.15mm, height=1.68mm)
  V841_AC = cylinder(axis=Z, base_centre=(-25.55mm, 52.8mm, -1.44mm), radius=0.15mm, height=1.68mm)
  V842_AC = cylinder(axis=Z, base_centre=(-41.55mm, 40mm, -1.44mm), radius=0.15mm, height=1.68mm)
  V843_AC = cylinder(axis=Z, base_centre=(-31.95mm, 52.8mm, -1.44mm), radius=0.15mm, height=1.68mm)
  V844_AC = cylinder(axis=Z, base_centre=(32.05mm, 51.2mm, -1.44mm), radius=0.15mm, height=1.68mm)
  V845_AC = cylinder(axis=Z, base_centre=(-41.85mm, 34.8mm, -1.44mm), radius=0.15mm, height=1.68mm)
  V846_AC = cylinder(axis=Z, base_centre=(-15.95mm, 51.2mm, -1.44mm), radius=0.15mm, height=1.68mm)
  V847_AC = cylinder(axis=Z, base_centre=(32.05mm, 41.6mm, -1.44mm), radius=0.15mm, height=1.68mm)
  V848_AC = cylinder(axis=Z, base_centre=(24.05mm, 51.2mm, -1.44mm), radius=0.15mm, height=1.68mm)
  V849_AC = cylinder(axis=Z, base_centre=(16.05mm, 48mm, -1.44mm), radius=0.15mm, height=1.68mm)
  V850_AC = cylinder(axis=Z, base_centre=(-14.35mm, 52.8mm, -1.44mm), radius=0.15mm, height=1.68mm)
  V851_AC = cylinder(axis=Z, base_centre=(5.65mm, 32.4mm, -1.44mm), radius=0.15mm, height=1.68mm)
  V852_AC = cylinder(axis=Z, base_centre=(9.65mm, 46.4mm, -1.44mm), radius=0.15mm, height=1.68mm)
  V853_AC = cylinder(axis=Z, base_centre=(22.45mm, 52.8mm, -1.44mm), radius=0.15mm, height=1.68mm)
  V854_AC = cylinder(axis=Z, base_centre=(37.85mm, 32.4mm, -1.44mm), radius=0.15mm, height=1.68mm)
  V855_AC = cylinder(axis=Z, base_centre=(28.85mm, 52.8mm, -1.44mm), radius=0.15mm, height=1.68mm)
  V856_AC = cylinder(axis=Z, base_centre=(5.65mm, 34.8mm, -1.44mm), radius=0.15mm, height=1.68mm)
  V857_AC = cylinder(axis=Z, base_centre=(-17.55mm, 44.8mm, -1.44mm), radius=0.15mm, height=1.68mm)
  V858_AC = cylinder(axis=Z, base_centre=(4.45mm, 38.4mm, -1.44mm), radius=0.15mm, height=1.68mm)
  V859_AC = cylinder(axis=Z, base_centre=(30.45mm, 52.8mm, -1.44mm), radius=0.15mm, height=1.68mm)
  V860_AC = cylinder(axis=Z, base_centre=(-14.35mm, 43.2mm, -1.44mm), radius=0.15mm, height=1.68mm)
  V861_AC = cylinder(axis=Z, base_centre=(-41.85mm, 36mm, -1.44mm), radius=0.15mm, height=1.68mm)
  V862_AC = cylinder(axis=Z, base_centre=(38.45mm, 41.6mm, -1.44mm), radius=0.15mm, height=1.68mm)
  V863_AC = cylinder(axis=Z, base_centre=(-41.55mm, 48mm, -1.44mm), radius=0.15mm, height=1.68mm)
  V864_AC = cylinder(axis=Z, base_centre=(39.05mm, 34.8mm, -1.44mm), radius=0.15mm, height=1.68mm)
  V865_AC = cylinder(axis=Z, base_centre=(24.05mm, 52.8mm, -1.44mm), radius=0.15mm, height=1.68mm)
  V866_AC = cylinder(axis=Z, base_centre=(-7.25mm, 36mm, -1.44mm), radius=0.15mm, height=1.68mm)
  V867_AC = cylinder(axis=Z, base_centre=(20.85mm, 46.4mm, -1.44mm), radius=0.15mm, height=1.68mm)
  V868_AC = cylinder(axis=Z, base_centre=(-17.55mm, 40mm, -1.44mm), radius=0.15mm, height=1.68mm)
  V869_AC = cylinder(axis=Z, base_centre=(12.85mm, 44.8mm, -1.44mm), radius=0.15mm, height=1.68mm)
  V870_AC = cylinder(axis=Z, base_centre=(-20.75mm, 44.8mm, -1.44mm), radius=0.15mm, height=1.68mm)
  V871_AC = cylinder(axis=Z, base_centre=(9.65mm, 49.6mm, -1.44mm), radius=0.15mm, height=1.68mm)
  V872_AC = cylinder(axis=Z, base_centre=(36.85mm, 40mm, -1.44mm), radius=0.15mm, height=1.68mm)
  V873_AC = cylinder(axis=Z, base_centre=(11.25mm, 40mm, -1.44mm), radius=0.15mm, height=1.68mm)
  V874_AC = cylinder(axis=Z, base_centre=(-9.65mm, 34.8mm, -1.44mm), radius=0.15mm, height=1.68mm)
  V875_AC = cylinder(axis=Z, base_centre=(-30.35mm, 51.2mm, -1.44mm), radius=0.15mm, height=1.68mm)
  V876_AC = cylinder(axis=Z, base_centre=(-39.95mm, 52.8mm, -1.44mm), radius=0.15mm, height=1.68mm)
  V877_AC = cylinder(axis=Z, base_centre=(25.65mm, 44.8mm, -1.44mm), radius=0.15mm, height=1.68mm)
  V878_AC = cylinder(axis=Z, base_centre=(-22.35mm, 43.2mm, -1.44mm), radius=0.15mm, height=1.68mm)
  V879_AC = cylinder(axis=Z, base_centre=(20.85mm, 44.8mm, -1.44mm), radius=0.15mm, height=1.68mm)
  V880_AC = cylinder(axis=Z, base_centre=(-35.15mm, 46.4mm, -1.44mm), radius=0.15mm, height=1.68mm)
  V881_AC = cylinder(axis=Z, base_centre=(-30.35mm, 41.6mm, -1.44mm), radius=0.15mm, height=1.68mm)
  V882_AC = cylinder(axis=Z, base_centre=(-7.95mm, 51.2mm, -1.44mm), radius=0.15mm, height=1.68mm)
  V883_AC = cylinder(axis=Z, base_centre=(35.25mm, 51.2mm, -1.44mm), radius=0.15mm, height=1.68mm)
  V884_AC = cylinder(axis=Z, base_centre=(-22.35mm, 41.6mm, -1.44mm), radius=0.15mm, height=1.68mm)
  V885_AC = cylinder(axis=Z, base_centre=(-8.45mm, 36mm, -1.44mm), radius=0.15mm, height=1.68mm)
  V886_AC = cylinder(axis=Z, base_centre=(30.45mm, 41.6mm, -1.44mm), radius=0.15mm, height=1.68mm)
  V887_AC = cylinder(axis=Z, base_centre=(-33.55mm, 48mm, -1.44mm), radius=0.15mm, height=1.68mm)
  V888_AC = cylinder(axis=Z, base_centre=(5.65mm, 31.2mm, -1.44mm), radius=0.15mm, height=1.68mm)
  V889_AC = cylinder(axis=Z, base_centre=(-38.35mm, 46.4mm, -1.44mm), radius=0.15mm, height=1.68mm)
  V890_AC = cylinder(axis=Z, base_centre=(-39.95mm, 46.4mm, -1.44mm), radius=0.15mm, height=1.68mm)
  V891_AC = cylinder(axis=Z, base_centre=(40.05mm, 40mm, -1.44mm), radius=0.15mm, height=1.68mm)
  V892_AC = cylinder(axis=Z, base_centre=(11.25mm, 44.8mm, -1.44mm), radius=0.15mm, height=1.68mm)
  V893_AC = cylinder(axis=Z, base_centre=(-15.95mm, 41.6mm, -1.44mm), radius=0.15mm, height=1.68mm)
  V894_AC = cylinder(axis=Z, base_centre=(40.25mm, 31.2mm, -1.44mm), radius=0.15mm, height=1.68mm)
  V895_AC = cylinder(axis=Z, base_centre=(-39.45mm, 33.6mm, -1.44mm), radius=0.15mm, height=1.68mm)
  V896_AC = cylinder(axis=Z, base_centre=(28.85mm, 41.6mm, -1.44mm), radius=0.15mm, height=1.68mm)
  V897_AC = cylinder(axis=Z, base_centre=(-14.35mm, 48mm, -1.44mm), radius=0.15mm, height=1.68mm)
  V898_AC = cylinder(axis=Z, base_centre=(4.45mm, 36mm, -1.44mm), radius=0.15mm, height=1.68mm)
  V899_AC = cylinder(axis=Z, base_centre=(-9.55mm, 41.6mm, -1.44mm), radius=0.15mm, height=1.68mm)
  V900_AC = cylinder(axis=Z, base_centre=(-23.95mm, 43.2mm, -1.44mm), radius=0.15mm, height=1.68mm)
  V901_AC = cylinder(axis=Z, base_centre=(12.85mm, 41.6mm, -1.44mm), radius=0.15mm, height=1.68mm)
  V902_AC = cylinder(axis=Z, base_centre=(-7.25mm, 37.2mm, -1.44mm), radius=0.15mm, height=1.68mm)
  V903_AC = cylinder(axis=Z, base_centre=(-22.35mm, 49.6mm, -1.44mm), radius=0.15mm, height=1.68mm)
  V904_AC = cylinder(axis=Z, base_centre=(36.85mm, 41.6mm, -1.44mm), radius=0.15mm, height=1.68mm)
  V905_AC = cylinder(axis=Z, base_centre=(35.25mm, 44.8mm, -1.44mm), radius=0.15mm, height=1.68mm)
  V906_AC = cylinder(axis=Z, base_centre=(30.45mm, 51.2mm, -1.44mm), radius=0.15mm, height=1.68mm)
  V907_AC = cylinder(axis=Z, base_centre=(4.45mm, 34.8mm, -1.44mm), radius=0.15mm, height=1.68mm)
  V908_AC = cylinder(axis=Z, base_centre=(-41.85mm, 38.4mm, -1.44mm), radius=0.15mm, height=1.68mm)
  V909_AC = cylinder(axis=Z, base_centre=(32.05mm, 52.8mm, -1.44mm), radius=0.15mm, height=1.68mm)
  V910_AC = cylinder(axis=Z, base_centre=(4.45mm, 31.2mm, -1.44mm), radius=0.15mm, height=1.68mm)
  V911_AC = cylinder(axis=Z, base_centre=(32.05mm, 48mm, -1.44mm), radius=0.15mm, height=1.68mm)
  V912_AC = cylinder(axis=Z, base_centre=(-39.95mm, 40mm, -1.44mm), radius=0.15mm, height=1.68mm)
  V913_AC = cylinder(axis=Z, base_centre=(-7.25mm, 38.4mm, -1.44mm), radius=0.15mm, height=1.68mm)
  V914_AC = cylinder(axis=Z, base_centre=(-43.15mm, 44.8mm, -1.44mm), radius=0.15mm, height=1.68mm)
  V915_AC = cylinder(axis=Z, base_centre=(-23.95mm, 46.4mm, -1.44mm), radius=0.15mm, height=1.68mm)
  V916_AC = cylinder(axis=Z, base_centre=(-31.95mm, 51.2mm, -1.44mm), radius=0.15mm, height=1.68mm)
  V917_AC = cylinder(axis=Z, base_centre=(-23.95mm, 44.8mm, -1.44mm), radius=0.15mm, height=1.68mm)
  V918_AC = cylinder(axis=Z, base_centre=(-9.65mm, 33.6mm, -1.44mm), radius=0.15mm, height=1.68mm)
  V919_AC = cylinder(axis=Z, base_centre=(24.05mm, 49.6mm, -1.44mm), radius=0.15mm, height=1.68mm)
  V920_AC = cylinder(axis=Z, base_centre=(-41.85mm, 37.2mm, -1.44mm), radius=0.15mm, height=1.68mm)
  V921_AC = cylinder(axis=Z, base_centre=(27.25mm, 40mm, -1.44mm), radius=0.15mm, height=1.68mm)
  V922_AC = cylinder(axis=Z, base_centre=(-4.85mm, 34.8mm, -1.44mm), radius=0.15mm, height=1.68mm)
  V923_AC = cylinder(axis=Z, base_centre=(-30.35mm, 49.6mm, -1.44mm), radius=0.15mm, height=1.68mm)
  V924_AC = cylinder(axis=Z, base_centre=(-41.55mm, 46.4mm, -1.44mm), radius=0.15mm, height=1.68mm)
  V925_AC = cylinder(axis=Z, base_centre=(36.85mm, 52.8mm, -1.44mm), radius=0.15mm, height=1.68mm)
  V926_AC = cylinder(axis=Z, base_centre=(39.05mm, 32.4mm, -1.44mm), radius=0.15mm, height=1.68mm)
  V927_AC = cylinder(axis=Z, base_centre=(-7.95mm, 46.4mm, -1.44mm), radius=0.15mm, height=1.68mm)
  V928_AC = cylinder(axis=Z, base_centre=(35.25mm, 41.6mm, -1.44mm), radius=0.15mm, height=1.68mm)
  V929_AC = cylinder(axis=Z, base_centre=(8.05mm, 33.6mm, -1.44mm), radius=0.15mm, height=1.68mm)
  V930_AC = cylinder(axis=Z, base_centre=(16.05mm, 41.6mm, -1.44mm), radius=0.15mm, height=1.68mm)
  V931_AC = cylinder(axis=Z, base_centre=(-27.15mm, 49.6mm, -1.44mm), radius=0.15mm, height=1.68mm)
  V932_AC = cylinder(axis=Z, base_centre=(8.05mm, 36mm, -1.44mm), radius=0.15mm, height=1.68mm)
  V933_AC = cylinder(axis=Z, base_centre=(-19.15mm, 43.2mm, -1.44mm), radius=0.15mm, height=1.68mm)
  V934_AC = cylinder(axis=Z, base_centre=(25.65mm, 46.4mm, -1.44mm), radius=0.15mm, height=1.68mm)
  V935_AC = cylinder(axis=Z, base_centre=(9.25mm, 32.4mm, -1.44mm), radius=0.15mm, height=1.68mm)
  V936_AC = cylinder(axis=Z, base_centre=(-40.65mm, 32.4mm, -1.44mm), radius=0.15mm, height=1.68mm)
  V937_AC = cylinder(axis=Z, base_centre=(-4.85mm, 33.6mm, -1.44mm), radius=0.15mm, height=1.68mm)
  V938_AC = cylinder(axis=Z, base_centre=(-11.15mm, 49.6mm, -1.44mm), radius=0.15mm, height=1.68mm)
  V939_AC = cylinder(axis=Z, base_centre=(-15.95mm, 43.2mm, -1.44mm), radius=0.15mm, height=1.68mm)
  V940_AC = cylinder(axis=Z, base_centre=(6.85mm, 32.4mm, -1.44mm), radius=0.15mm, height=1.68mm)
  V941_AC = cylinder(axis=Z, base_centre=(33.65mm, 46.4mm, -1.44mm), radius=0.15mm, height=1.68mm)
  V942_AC = cylinder(axis=Z, base_centre=(-41.55mm, 43.2mm, -1.44mm), radius=0.15mm, height=1.68mm)
  V943_AC = cylinder(axis=Z, base_centre=(36.85mm, 51.2mm, -1.44mm), radius=0.15mm, height=1.68mm)
  V944_AC = cylinder(axis=Z, base_centre=(-6.35mm, 40mm, -1.44mm), radius=0.15mm, height=1.68mm)
  V945_AC = cylinder(axis=Z, base_centre=(-35.15mm, 49.6mm, -1.44mm), radius=0.15mm, height=1.68mm)
  V946_AC = cylinder(axis=Z, base_centre=(8.05mm, 41.6mm, -1.44mm), radius=0.15mm, height=1.68mm)
  V947_AC = cylinder(axis=Z, base_centre=(11.25mm, 49.6mm, -1.44mm), radius=0.15mm, height=1.68mm)
  V948_AC = cylinder(axis=Z, base_centre=(-41.85mm, 31.2mm, -1.44mm), radius=0.15mm, height=1.68mm)
  V949_AC = cylinder(axis=Z, base_centre=(-38.35mm, 44.8mm, -1.44mm), radius=0.15mm, height=1.68mm)
  V950_AC = cylinder(axis=Z, base_centre=(-39.95mm, 41.6mm, -1.44mm), radius=0.15mm, height=1.68mm)
  V951_AC = cylinder(axis=Z, base_centre=(17.65mm, 52.8mm, -1.44mm), radius=0.15mm, height=1.68mm)
  V952_AC = cylinder(axis=Z, base_centre=(41.65mm, 46.4mm, -1.44mm), radius=0.15mm, height=1.68mm)
  V953_AC = cylinder(axis=Z, base_centre=(-8.45mm, 37.2mm, -1.44mm), radius=0.15mm, height=1.68mm)
  V954_AC = cylinder(axis=Z, base_centre=(-8.45mm, 32.4mm, -1.44mm), radius=0.15mm, height=1.68mm)
  V955_AC = cylinder(axis=Z, base_centre=(-36.75mm, 49.6mm, -1.44mm), radius=0.15mm, height=1.68mm)
  V956_AC = cylinder(axis=Z, base_centre=(-43.05mm, 32.4mm, -1.44mm), radius=0.15mm, height=1.68mm)
  V957_AC = cylinder(axis=Z, base_centre=(19.25mm, 52.8mm, -1.44mm), radius=0.15mm, height=1.68mm)
  V958_AC = cylinder(axis=Z, base_centre=(-39.45mm, 37.2mm, -1.44mm), radius=0.15mm, height=1.68mm)
  V959_AC = cylinder(axis=Z, base_centre=(-11.15mm, 46.4mm, -1.44mm), radius=0.15mm, height=1.68mm)
  V960_AC = cylinder(axis=Z, base_centre=(5.65mm, 38.4mm, -1.44mm), radius=0.15mm, height=1.68mm)
  V961_AC = cylinder(axis=Z, base_centre=(-35.15mm, 44.8mm, -1.44mm), radius=0.15mm, height=1.68mm)
  V962_AC = cylinder(axis=Z, base_centre=(36.85mm, 44.8mm, -1.44mm), radius=0.15mm, height=1.68mm)
  V963_AC = cylinder(axis=Z, base_centre=(-23.95mm, 40mm, -1.44mm), radius=0.15mm, height=1.68mm)
  V964_AC = cylinder(axis=Z, base_centre=(35.25mm, 49.6mm, -1.44mm), radius=0.15mm, height=1.68mm)
  V965_AC = cylinder(axis=Z, base_centre=(19.25mm, 48mm, -1.44mm), radius=0.15mm, height=1.68mm)
  V966_AC = cylinder(axis=Z, base_centre=(42.65mm, 37.2mm, -1.44mm), radius=0.15mm, height=1.68mm)
  V967_AC = cylinder(axis=Z, base_centre=(-22.35mm, 44.8mm, -1.44mm), radius=0.15mm, height=1.68mm)
  V968_AC = cylinder(axis=Z, base_centre=(-28.75mm, 43.2mm, -1.44mm), radius=0.15mm, height=1.68mm)
  V969_AC = cylinder(axis=Z, base_centre=(5.65mm, 37.2mm, -1.44mm), radius=0.15mm, height=1.68mm)
  V970_AC = cylinder(axis=Z, base_centre=(-12.75mm, 46.4mm, -1.44mm), radius=0.15mm, height=1.68mm)
  V971_AC = cylinder(axis=Z, base_centre=(12.85mm, 40mm, -1.44mm), radius=0.15mm, height=1.68mm)
  V972_AC = cylinder(axis=Z, base_centre=(-20.75mm, 40mm, -1.44mm), radius=0.15mm, height=1.68mm)
  V973_AC = cylinder(axis=Z, base_centre=(-12.75mm, 44.8mm, -1.44mm), radius=0.15mm, height=1.68mm)
  V974_AC = cylinder(axis=Z, base_centre=(40.05mm, 48mm, -1.44mm), radius=0.15mm, height=1.68mm)
  V975_AC = cylinder(axis=Z, base_centre=(-19.15mm, 48mm, -1.44mm), radius=0.15mm, height=1.68mm)
  V976_AC = cylinder(axis=Z, base_centre=(16.05mm, 49.6mm, -1.44mm), radius=0.15mm, height=1.68mm)
  V977_AC = cylinder(axis=Z, base_centre=(35.25mm, 43.2mm, -1.44mm), radius=0.15mm, height=1.68mm)
  V978_AC = cylinder(axis=Z, base_centre=(-17.55mm, 41.6mm, -1.44mm), radius=0.15mm, height=1.68mm)
  V979_AC = cylinder(axis=Z, base_centre=(-38.35mm, 41.6mm, -1.44mm), radius=0.15mm, height=1.68mm)
  V980_AC = cylinder(axis=Z, base_centre=(36.85mm, 46.4mm, -1.44mm), radius=0.15mm, height=1.68mm)
  V981_AC = cylinder(axis=Z, base_centre=(33.65mm, 49.6mm, -1.44mm), radius=0.15mm, height=1.68mm)
  V982_AC = cylinder(axis=Z, base_centre=(-7.95mm, 43.2mm, -1.44mm), radius=0.15mm, height=1.68mm)
  V983_AC = cylinder(axis=Z, base_centre=(20.85mm, 51.2mm, -1.44mm), radius=0.15mm, height=1.68mm)
  V984_AC = cylinder(axis=Z, base_centre=(-40.65mm, 38.4mm, -1.44mm), radius=0.15mm, height=1.68mm)
  V985_AC = cylinder(axis=Z, base_centre=(27.25mm, 51.2mm, -1.44mm), radius=0.15mm, height=1.68mm)
  V986_AC = cylinder(axis=Z, base_centre=(-17.55mm, 52.8mm, -1.44mm), radius=0.15mm, height=1.68mm)
  V987_AC = cylinder(axis=Z, base_centre=(-8.45mm, 33.6mm, -1.44mm), radius=0.15mm, height=1.68mm)
  V988_AC = cylinder(axis=Z, base_centre=(-36.75mm, 52.8mm, -1.44mm), radius=0.15mm, height=1.68mm)
  V989_AC = cylinder(axis=Z, base_centre=(-20.75mm, 41.6mm, -1.44mm), radius=0.15mm, height=1.68mm)
  V990_AC = cylinder(axis=Z, base_centre=(36.85mm, 48mm, -1.44mm), radius=0.15mm, height=1.68mm)
  V991_AC = cylinder(axis=Z, base_centre=(-36.75mm, 51.2mm, -1.44mm), radius=0.15mm, height=1.68mm)
  V992_AC = cylinder(axis=Z, base_centre=(-17.55mm, 46.4mm, -1.44mm), radius=0.15mm, height=1.68mm)
  V993_AC = cylinder(axis=Z, base_centre=(40.25mm, 37.2mm, -1.44mm), radius=0.15mm, height=1.68mm)
  V994_AC = cylinder(axis=Z, base_centre=(6.85mm, 37.2mm, -1.44mm), radius=0.15mm, height=1.68mm)
  V995_AC = cylinder(axis=Z, base_centre=(-28.75mm, 44.8mm, -1.44mm), radius=0.15mm, height=1.68mm)
  V996_AC = cylinder(axis=Z, base_centre=(39.05mm, 37.2mm, -1.44mm), radius=0.15mm, height=1.68mm)
  V997_AC = cylinder(axis=Z, base_centre=(-39.95mm, 43.2mm, -1.44mm), radius=0.15mm, height=1.68mm)
  V998_AC = cylinder(axis=Z, base_centre=(-28.75mm, 49.6mm, -1.44mm), radius=0.15mm, height=1.68mm)
  V999_AC = cylinder(axis=Z, base_centre=(16.05mm, 51.2mm, -1.44mm), radius=0.15mm, height=1.68mm)
  V1000_AC = cylinder(axis=Z, base_centre=(-14.35mm, 40mm, -1.44mm), radius=0.15mm, height=1.68mm)
  V1001_AC = cylinder(axis=Z, base_centre=(40.05mm, 49.6mm, -1.44mm), radius=0.15mm, height=1.68mm)
  V1002_AC = cylinder(axis=Z, base_centre=(-38.25mm, 32.4mm, -1.44mm), radius=0.15mm, height=1.68mm)
  V1003_AC = cylinder(axis=Z, base_centre=(-28.75mm, 51.2mm, -1.44mm), radius=0.15mm, height=1.68mm)
  V1004_AC = cylinder(axis=Z, base_centre=(8.05mm, 34.8mm, -1.44mm), radius=0.15mm, height=1.68mm)
  V1005_AC = cylinder(axis=Z, base_centre=(-20.75mm, 48mm, -1.44mm), radius=0.15mm, height=1.68mm)
  V1006_AC = cylinder(axis=Z, base_centre=(-39.95mm, 48mm, -1.44mm), radius=0.15mm, height=1.68mm)
  V1007_AC = cylinder(axis=Z, base_centre=(-23.95mm, 52.8mm, -1.44mm), radius=0.15mm, height=1.68mm)
  V1008_AC = cylinder(axis=Z, base_centre=(-3.15mm, 40mm, -1.44mm), radius=0.15mm, height=1.68mm)
  V1009_AC = cylinder(axis=Z, base_centre=(-14.35mm, 46.4mm, -1.44mm), radius=0.15mm, height=1.68mm)
  V1010_AC = cylinder(axis=Z, base_centre=(-6.05mm, 37.2mm, -1.44mm), radius=0.15mm, height=1.68mm)
  V1011_AC = cylinder(axis=Z, base_centre=(11.25mm, 41.6mm, -1.44mm), radius=0.15mm, height=1.68mm)
  V1012_AC = cylinder(axis=Z, base_centre=(33.65mm, 40mm, -1.44mm), radius=0.15mm, height=1.68mm)
  V1013_AC = cylinder(axis=Z, base_centre=(-8.45mm, 34.8mm, -1.44mm), radius=0.15mm, height=1.68mm)
  V1014_AC = cylinder(axis=Z, base_centre=(32.05mm, 46.4mm, -1.44mm), radius=0.15mm, height=1.68mm)
  V1015_AC = cylinder(axis=Z, base_centre=(-27.15mm, 43.2mm, -1.44mm), radius=0.15mm, height=1.68mm)
  V1016_AC = cylinder(axis=Z, base_centre=(25.65mm, 41.6mm, -1.44mm), radius=0.15mm, height=1.68mm)
  V1017_AC = cylinder(axis=Z, base_centre=(-40.65mm, 36mm, -1.44mm), radius=0.15mm, height=1.68mm)
  V1018_AC = cylinder(axis=Z, base_centre=(-43.05mm, 33.6mm, -1.44mm), radius=0.15mm, height=1.68mm)
  V1019_AC = cylinder(axis=Z, base_centre=(-33.55mm, 40mm, -1.44mm), radius=0.15mm, height=1.68mm)
  V1020_AC = cylinder(axis=Z, base_centre=(-4.85mm, 37.2mm, -1.44mm), radius=0.15mm, height=1.68mm)
  V1021_AC = cylinder(axis=Z, base_centre=(-12.75mm, 43.2mm, -1.44mm), radius=0.15mm, height=1.68mm)
  V1022_AC = cylinder(axis=Z, base_centre=(-28.75mm, 41.6mm, -1.44mm), radius=0.15mm, height=1.68mm)
  V1023_AC = cylinder(axis=Z, base_centre=(28.85mm, 49.6mm, -1.44mm), radius=0.15mm, height=1.68mm)
  V1024_AC = cylinder(axis=Z, base_centre=(-31.95mm, 48mm, -1.44mm), radius=0.15mm, height=1.68mm)
  V1025_AC = cylinder(axis=Z, base_centre=(12.85mm, 48mm, -1.44mm), radius=0.15mm, height=1.68mm)
  V1026_AC = cylinder(axis=Z, base_centre=(24.05mm, 48mm, -1.44mm), radius=0.15mm, height=1.68mm)
  V1027_AC = cylinder(axis=Z, base_centre=(-19.15mm, 51.2mm, -1.44mm), radius=0.15mm, height=1.68mm)
  V1028_AC = cylinder(axis=Z, base_centre=(-39.45mm, 31.2mm, -1.44mm), radius=0.15mm, height=1.68mm)
  V1029_AC = cylinder(axis=Z, base_centre=(-11.15mm, 51.2mm, -1.44mm), radius=0.15mm, height=1.68mm)
  V1030_AC = cylinder(axis=Z, base_centre=(20.85mm, 43.2mm, -1.44mm), radius=0.15mm, height=1.68mm)
  V1031_AC = cylinder(axis=Z, base_centre=(38.45mm, 48mm, -1.44mm), radius=0.15mm, height=1.68mm)
  V1032_AC = cylinder(axis=Z, base_centre=(40.05mm, 51.2mm, -1.44mm), radius=0.15mm, height=1.68mm)
  V1033_AC = cylinder(axis=Z, base_centre=(-31.95mm, 41.6mm, -1.44mm), radius=0.15mm, height=1.68mm)
  V1034_AC = cylinder(axis=Z, base_centre=(-11.15mm, 43.2mm, -1.44mm), radius=0.15mm, height=1.68mm)
  V1035_AC = cylinder(axis=Z, base_centre=(-9.55mm, 43.2mm, -1.44mm), radius=0.15mm, height=1.68mm)
  V1036_AC = cylinder(axis=Z, base_centre=(14.45mm, 40mm, -1.44mm), radius=0.15mm, height=1.68mm)
  V1037_AC = cylinder(axis=Z, base_centre=(-7.95mm, 41.6mm, -1.44mm), radius=0.15mm, height=1.68mm)
  V1038_AC = cylinder(axis=Z, base_centre=(-7.25mm, 32.4mm, -1.44mm), radius=0.15mm, height=1.68mm)
  V1039_AC = cylinder(axis=Z, base_centre=(41.65mm, 51.2mm, -1.44mm), radius=0.15mm, height=1.68mm)
  V1040_AC = cylinder(axis=Z, base_centre=(22.45mm, 40mm, -1.44mm), radius=0.15mm, height=1.68mm)
  V1041_AC = cylinder(axis=Z, base_centre=(6.85mm, 38.4mm, -1.44mm), radius=0.15mm, height=1.68mm)
  V1042_AC = cylinder(axis=Z, base_centre=(-40.65mm, 37.2mm, -1.44mm), radius=0.15mm, height=1.68mm)
  V1043_AC = cylinder(axis=Z, base_centre=(-23.95mm, 41.6mm, -1.44mm), radius=0.15mm, height=1.68mm)
  V1044_AC = cylinder(axis=Z, base_centre=(11.25mm, 43.2mm, -1.44mm), radius=0.15mm, height=1.68mm)
  V1045_AC = cylinder(axis=Z, base_centre=(20.85mm, 49.6mm, -1.44mm), radius=0.15mm, height=1.68mm)
  V1046_AC = cylinder(axis=Z, base_centre=(-36.75mm, 46.4mm, -1.44mm), radius=0.15mm, height=1.68mm)
  V1047_AC = cylinder(axis=Z, base_centre=(4.45mm, 37.2mm, -1.44mm), radius=0.15mm, height=1.68mm)
  V1048_AC = cylinder(axis=Z, base_centre=(22.45mm, 46.4mm, -1.44mm), radius=0.15mm, height=1.68mm)
  V1049_AC = cylinder(axis=Z, base_centre=(9.25mm, 31.2mm, -1.44mm), radius=0.15mm, height=1.68mm)
  V1050_AC = cylinder(axis=Z, base_centre=(-11.15mm, 44.8mm, -1.44mm), radius=0.15mm, height=1.68mm)
  V1051_AC = cylinder(axis=Z, base_centre=(9.65mm, 52.8mm, -1.44mm), radius=0.15mm, height=1.68mm)
  V1052_AC = cylinder(axis=Z, base_centre=(32.05mm, 43.2mm, -1.44mm), radius=0.15mm, height=1.68mm)
  V1053_AC = cylinder(axis=Z, base_centre=(41.45mm, 34.8mm, -1.44mm), radius=0.15mm, height=1.68mm)
  V1054_AC = cylinder(axis=Z, base_centre=(-6.35mm, 52.8mm, -1.44mm), radius=0.15mm, height=1.68mm)
  V1055_AC = cylinder(axis=Z, base_centre=(-31.95mm, 44.8mm, -1.44mm), radius=0.15mm, height=1.68mm)
  V1056_AC = cylinder(axis=Z, base_centre=(41.65mm, 48mm, -1.44mm), radius=0.15mm, height=1.68mm)
  V1057_AC = cylinder(axis=Z, base_centre=(-9.65mm, 36mm, -1.44mm), radius=0.15mm, height=1.68mm)
  V1058_AC = cylinder(axis=Z, base_centre=(17.65mm, 49.6mm, -1.44mm), radius=0.15mm, height=1.68mm)
  V1059_AC = cylinder(axis=Z, base_centre=(-28.75mm, 52.8mm, -1.44mm), radius=0.15mm, height=1.68mm)
  V1060_AC = cylinder(axis=Z, base_centre=(-7.95mm, 52.8mm, -1.44mm), radius=0.15mm, height=1.68mm)
  V1061_AC = cylinder(axis=Z, base_centre=(17.65mm, 44.8mm, -1.44mm), radius=0.15mm, height=1.68mm)
  V1062_AC = cylinder(axis=Z, base_centre=(-39.45mm, 36mm, -1.44mm), radius=0.15mm, height=1.68mm)
  V1063_AC = cylinder(axis=Z, base_centre=(17.65mm, 51.2mm, -1.44mm), radius=0.15mm, height=1.68mm)
  V1064_AC = cylinder(axis=Z, base_centre=(-36.75mm, 40mm, -1.44mm), radius=0.15mm, height=1.68mm)
  V1065_AC = cylinder(axis=Z, base_centre=(3.25mm, 40mm, -1.44mm), radius=0.15mm, height=1.68mm)
  V1066_AC = cylinder(axis=Z, base_centre=(20.85mm, 52.8mm, -1.44mm), radius=0.15mm, height=1.68mm)
  V1067_AC = cylinder(axis=Z, base_centre=(-41.85mm, 32.4mm, -1.44mm), radius=0.15mm, height=1.68mm)
  V1068_AC = cylinder(axis=Z, base_centre=(11.25mm, 51.2mm, -1.44mm), radius=0.15mm, height=1.68mm)
  V1069_AC = cylinder(axis=Z, base_centre=(-41.55mm, 41.6mm, -1.44mm), radius=0.15mm, height=1.68mm)
  V1070_AC = cylinder(axis=Z, base_centre=(8.05mm, 38.4mm, -1.44mm), radius=0.15mm, height=1.68mm)
  V1071_AC = cylinder(axis=Z, base_centre=(24.05mm, 43.2mm, -1.44mm), radius=0.15mm, height=1.68mm)
  V1072_AC = cylinder(axis=Z, base_centre=(-7.95mm, 48mm, -1.44mm), radius=0.15mm, height=1.68mm)
  V1073_AC = cylinder(axis=Z, base_centre=(12.85mm, 51.2mm, -1.44mm), radius=0.15mm, height=1.68mm)
  V1074_AC = cylinder(axis=Z, base_centre=(-38.25mm, 31.2mm, -1.44mm), radius=0.15mm, height=1.68mm)
  V1075_AC = cylinder(axis=Z, base_centre=(4.45mm, 33.6mm, -1.44mm), radius=0.15mm, height=1.68mm)
  V1076_AC = cylinder(axis=Z, base_centre=(22.45mm, 41.6mm, -1.44mm), radius=0.15mm, height=1.68mm)
  V1077_AC = cylinder(axis=Z, base_centre=(-30.35mm, 48mm, -1.44mm), radius=0.15mm, height=1.68mm)
  V1078_AC = cylinder(axis=Z, base_centre=(37.85mm, 37.2mm, -1.44mm), radius=0.15mm, height=1.68mm)
  V1079_AC = cylinder(axis=Z, base_centre=(-19.15mm, 40mm, -1.44mm), radius=0.15mm, height=1.68mm)
  V1080_AC = cylinder(axis=Z, base_centre=(-9.55mm, 40mm, -1.44mm), radius=0.15mm, height=1.68mm)
  V1081_AC = cylinder(axis=Z, base_centre=(-27.15mm, 44.8mm, -1.44mm), radius=0.15mm, height=1.68mm)
  V1082_AC = cylinder(axis=Z, base_centre=(-39.95mm, 49.6mm, -1.44mm), radius=0.15mm, height=1.68mm)
  V1083_AC = cylinder(axis=Z, base_centre=(-22.35mm, 51.2mm, -1.44mm), radius=0.15mm, height=1.68mm)
  V1084_AC = cylinder(axis=Z, base_centre=(-43.15mm, 43.2mm, -1.44mm), radius=0.15mm, height=1.68mm)
  V1085_AC = cylinder(axis=Z, base_centre=(38.45mm, 51.2mm, -1.44mm), radius=0.15mm, height=1.68mm)
  V1086_AC = cylinder(axis=Z, base_centre=(-12.75mm, 49.6mm, -1.44mm), radius=0.15mm, height=1.68mm)
  V1087_AC = cylinder(axis=Z, base_centre=(-4.85mm, 31.2mm, -1.44mm), radius=0.15mm, height=1.68mm)
  V1088_AC = cylinder(axis=Z, base_centre=(8.05mm, 37.2mm, -1.44mm), radius=0.15mm, height=1.68mm)
  V1089_AC = cylinder(axis=Z, base_centre=(-7.25mm, 31.2mm, -1.44mm), radius=0.15mm, height=1.68mm)
  V1090_AC = cylinder(axis=Z, base_centre=(-12.75mm, 40mm, -1.44mm), radius=0.15mm, height=1.68mm)
  V1091_AC = cylinder(axis=Z, base_centre=(32.05mm, 49.6mm, -1.44mm), radius=0.15mm, height=1.68mm)
  V1092_AC = cylinder(axis=Z, base_centre=(-33.55mm, 46.4mm, -1.44mm), radius=0.15mm, height=1.68mm)
  V1093_AC = cylinder(axis=Z, base_centre=(-30.35mm, 43.2mm, -1.44mm), radius=0.15mm, height=1.68mm)
  V1094_AC = cylinder(axis=Z, base_centre=(19.25mm, 46.4mm, -1.44mm), radius=0.15mm, height=1.68mm)
  V1095_AC = cylinder(axis=Z, base_centre=(41.45mm, 36mm, -1.44mm), radius=0.15mm, height=1.68mm)
  V1096_AC = cylinder(axis=Z, base_centre=(40.25mm, 34.8mm, -1.44mm), radius=0.15mm, height=1.68mm)
  V1097_AC = cylinder(axis=Z, base_centre=(-36.75mm, 43.2mm, -1.44mm), radius=0.15mm, height=1.68mm)
  V1098_AC = cylinder(axis=Z, base_centre=(35.25mm, 52.8mm, -1.44mm), radius=0.15mm, height=1.68mm)
  V1099_AC = cylinder(axis=Z, base_centre=(-27.15mm, 48mm, -1.44mm), radius=0.15mm, height=1.68mm)
  V1100_AC = cylinder(axis=Z, base_centre=(25.65mm, 40mm, -1.44mm), radius=0.15mm, height=1.68mm)
  V1101_AC = cylinder(axis=Z, base_centre=(-15.95mm, 52.8mm, -1.44mm), radius=0.15mm, height=1.68mm)
  V1102_AC = cylinder(axis=Z, base_centre=(14.45mm, 52.8mm, -1.44mm), radius=0.15mm, height=1.68mm)
  V1103_AC = cylinder(axis=Z, base_centre=(41.65mm, 49.6mm, -1.44mm), radius=0.15mm, height=1.68mm)
  V1104_AC = cylinder(axis=Z, base_centre=(35.25mm, 46.4mm, -1.44mm), radius=0.15mm, height=1.68mm)
  V1105_AC = cylinder(axis=Z, base_centre=(27.25mm, 44.8mm, -1.44mm), radius=0.15mm, height=1.68mm)
  V1106_AC = cylinder(axis=Z, base_centre=(39.05mm, 33.6mm, -1.44mm), radius=0.15mm, height=1.68mm)
  V1107_AC = cylinder(axis=Z, base_centre=(-38.35mm, 40mm, -1.44mm), radius=0.15mm, height=1.68mm)
  V1108_AC = cylinder(axis=Z, base_centre=(-25.55mm, 41.6mm, -1.44mm), radius=0.15mm, height=1.68mm)
  V1109_AC = cylinder(axis=Z, base_centre=(-25.55mm, 44.8mm, -1.44mm), radius=0.15mm, height=1.68mm)
  V1110_AC = cylinder(axis=Z, base_centre=(-25.55mm, 49.6mm, -1.44mm), radius=0.15mm, height=1.68mm)
  V1111_AC = cylinder(axis=Z, base_centre=(-43.05mm, 36mm, -1.44mm), radius=0.15mm, height=1.68mm)
  V1112_AC = cylinder(axis=Z, base_centre=(-15.95mm, 44.8mm, -1.44mm), radius=0.15mm, height=1.68mm)
  V1113_AC = cylinder(axis=Z, base_centre=(-12.75mm, 41.6mm, -1.44mm), radius=0.15mm, height=1.68mm)
  V1114_AC = cylinder(axis=Z, base_centre=(25.65mm, 43.2mm, -1.44mm), radius=0.15mm, height=1.68mm)
  V1115_AC = cylinder(axis=Z, base_centre=(-28.75mm, 48mm, -1.44mm), radius=0.15mm, height=1.68mm)
  V1116_AC = cylinder(axis=Z, base_centre=(42.65mm, 38.4mm, -1.44mm), radius=0.15mm, height=1.68mm)
  V1117_AC = cylinder(axis=Z, base_centre=(-39.95mm, 44.8mm, -1.44mm), radius=0.15mm, height=1.68mm)
  V1118_AC = cylinder(axis=Z, base_centre=(-39.45mm, 32.4mm, -1.44mm), radius=0.15mm, height=1.68mm)
  V1119_AC = cylinder(axis=Z, base_centre=(-9.65mm, 31.2mm, -1.44mm), radius=0.15mm, height=1.68mm)
  V1120_AC = cylinder(axis=Z, base_centre=(8.05mm, 46.4mm, -1.44mm), radius=0.15mm, height=1.68mm)
  V1121_AC = cylinder(axis=Z, base_centre=(30.45mm, 49.6mm, -1.44mm), radius=0.15mm, height=1.68mm)
  V1122_AC = cylinder(axis=Z, base_centre=(-7.95mm, 44.8mm, -1.44mm), radius=0.15mm, height=1.68mm)
  V1123_AC = cylinder(axis=Z, base_centre=(-38.35mm, 52.8mm, -1.44mm), radius=0.15mm, height=1.68mm)
  V1124_AC = cylinder(axis=Z, base_centre=(42.65mm, 33.6mm, -1.44mm), radius=0.15mm, height=1.68mm)
  V1125_AC = cylinder(axis=Z, base_centre=(-7.25mm, 34.8mm, -1.44mm), radius=0.15mm, height=1.68mm)
  V1126_AC = cylinder(axis=Z, base_centre=(20.85mm, 48mm, -1.44mm), radius=0.15mm, height=1.68mm)
  V1127_AC = cylinder(axis=Z, base_centre=(-19.15mm, 49.6mm, -1.44mm), radius=0.15mm, height=1.68mm)
  V1128_AC = cylinder(axis=Z, base_centre=(5.65mm, 36mm, -1.44mm), radius=0.15mm, height=1.68mm)
  V1129_AC = cylinder(axis=Z, base_centre=(28.85mm, 51.2mm, -1.44mm), radius=0.15mm, height=1.68mm)
  V1130_AC = cylinder(axis=Z, base_centre=(32.05mm, 40mm, -1.44mm), radius=0.15mm, height=1.68mm)
  V1131_AC = cylinder(axis=Z, base_centre=(11.25mm, 46.4mm, -1.44mm), radius=0.15mm, height=1.68mm)
  V1132_AC = cylinder(axis=Z, base_centre=(36.85mm, 49.6mm, -1.44mm), radius=0.15mm, height=1.68mm)
  V1133_AC = cylinder(axis=Z, base_centre=(40.05mm, 44.8mm, -1.44mm), radius=0.15mm, height=1.68mm)
  V1134_AC = cylinder(axis=Z, base_centre=(-6.05mm, 38.4mm, -1.44mm), radius=0.15mm, height=1.68mm)
  V1135_AC = cylinder(axis=Z, base_centre=(-28.75mm, 40mm, -1.44mm), radius=0.15mm, height=1.68mm)
  V1136_AC = cylinder(axis=Z, base_centre=(27.25mm, 52.8mm, -1.44mm), radius=0.15mm, height=1.68mm)
  V1137_AC = cylinder(axis=Z, base_centre=(20.85mm, 40mm, -1.44mm), radius=0.15mm, height=1.68mm)
  V1138_AC = cylinder(axis=Z, base_centre=(5.65mm, 33.6mm, -1.44mm), radius=0.15mm, height=1.68mm)
  V1139_AC = cylinder(axis=Z, base_centre=(27.25mm, 49.6mm, -1.44mm), radius=0.15mm, height=1.68mm)
  V1140_AC = cylinder(axis=Z, base_centre=(8.05mm, 32.4mm, -1.44mm), radius=0.15mm, height=1.68mm)
  V1141_AC = cylinder(axis=Z, base_centre=(-38.35mm, 43.2mm, -1.44mm), radius=0.15mm, height=1.68mm)
  V1142_AC = cylinder(axis=Z, base_centre=(27.25mm, 46.4mm, -1.44mm), radius=0.15mm, height=1.68mm)
  V1143_AC = cylinder(axis=Z, base_centre=(-38.25mm, 33.6mm, -1.44mm), radius=0.15mm, height=1.68mm)
  V1144_AC = cylinder(axis=Z, base_centre=(-35.15mm, 48mm, -1.44mm), radius=0.15mm, height=1.68mm)
  V1145_AC = cylinder(axis=Z, base_centre=(-7.95mm, 40mm, -1.44mm), radius=0.15mm, height=1.68mm)
  V1146_AC = cylinder(axis=Z, base_centre=(-27.15mm, 51.2mm, -1.44mm), radius=0.15mm, height=1.68mm)
  V1147_AC = cylinder(axis=Z, base_centre=(-6.05mm, 32.4mm, -1.44mm), radius=0.15mm, height=1.68mm)
  V1148_AC = cylinder(axis=Z, base_centre=(24.05mm, 40mm, -1.44mm), radius=0.15mm, height=1.68mm)
  V1149_AC = cylinder(axis=Z, base_centre=(-14.35mm, 49.6mm, -1.44mm), radius=0.15mm, height=1.68mm)
  V1150_AC = cylinder(axis=Z, base_centre=(-6.05mm, 36mm, -1.44mm), radius=0.15mm, height=1.68mm)
  V1151_AC = cylinder(axis=Z, base_centre=(-4.85mm, 38.4mm, -1.44mm), radius=0.15mm, height=1.68mm)
  V1152_AC = cylinder(axis=Z, base_centre=(33.65mm, 41.6mm, -1.44mm), radius=0.15mm, height=1.68mm)
  V1153_AC = cylinder(axis=Z, base_centre=(-7.95mm, 49.6mm, -1.44mm), radius=0.15mm, height=1.68mm)
  V1154_AC = cylinder(axis=Z, base_centre=(9.65mm, 48mm, -1.44mm), radius=0.15mm, height=1.68mm)
  V1155_AC = cylinder(axis=Z, base_centre=(17.65mm, 46.4mm, -1.44mm), radius=0.15mm, height=1.68mm)
  V1156_AC = cylinder(axis=Z, base_centre=(-6.05mm, 34.8mm, -1.44mm), radius=0.15mm, height=1.68mm)
  V1157_AC = cylinder(axis=Z, base_centre=(-43.15mm, 51.2mm, -1.44mm), radius=0.15mm, height=1.68mm)
  V1158_AC = cylinder(axis=Z, base_centre=(-22.35mm, 46.4mm, -1.44mm), radius=0.15mm, height=1.68mm)
  V1159_AC = cylinder(axis=Z, base_centre=(12.85mm, 52.8mm, -1.44mm), radius=0.15mm, height=1.68mm)
  V1160_AC = cylinder(axis=Z, base_centre=(-14.35mm, 51.2mm, -1.44mm), radius=0.15mm, height=1.68mm)
  V1161_AC = cylinder(axis=Z, base_centre=(-40.65mm, 31.2mm, -1.44mm), radius=0.15mm, height=1.68mm)
  V1162_AC = cylinder(axis=Z, base_centre=(-20.75mm, 49.6mm, -1.44mm), radius=0.15mm, height=1.68mm)
  V1163_AC = cylinder(axis=Z, base_centre=(33.65mm, 44.8mm, -1.44mm), radius=0.15mm, height=1.68mm)
  V1164_AC = cylinder(axis=Z, base_centre=(8.05mm, 43.2mm, -1.44mm), radius=0.15mm, height=1.68mm)
  V1165_AC = cylinder(axis=Z, base_centre=(14.45mm, 44.8mm, -1.44mm), radius=0.15mm, height=1.68mm)
  V1166_AC = cylinder(axis=Z, base_centre=(-27.15mm, 40mm, -1.44mm), radius=0.15mm, height=1.68mm)
  V1167_AC = cylinder(axis=Z, base_centre=(19.25mm, 51.2mm, -1.44mm), radius=0.15mm, height=1.68mm)
  V1168_AC = cylinder(axis=Z, base_centre=(9.65mm, 41.6mm, -1.44mm), radius=0.15mm, height=1.68mm)
  V1169_AC = cylinder(axis=Z, base_centre=(39.05mm, 38.4mm, -1.44mm), radius=0.15mm, height=1.68mm)
  V1170_AC = cylinder(axis=Z, base_centre=(-38.25mm, 38.4mm, -1.44mm), radius=0.15mm, height=1.68mm)
  V1171_AC = cylinder(axis=Z, base_centre=(25.65mm, 49.6mm, -1.44mm), radius=0.15mm, height=1.68mm)
  V1172_AC = cylinder(axis=Z, base_centre=(-31.95mm, 40mm, -1.44mm), radius=0.15mm, height=1.68mm)
  V1173_AC = cylinder(axis=Z, base_centre=(-9.65mm, 38.4mm, -1.44mm), radius=0.15mm, height=1.68mm)
  V1174_AC = cylinder(axis=Z, base_centre=(-7.25mm, 33.6mm, -1.44mm), radius=0.15mm, height=1.68mm)
  V1175_AC = cylinder(axis=Z, base_centre=(-35.15mm, 41.6mm, -1.44mm), radius=0.15mm, height=1.68mm)
  V1176_AC = cylinder(axis=Z, base_centre=(-25.55mm, 46.4mm, -1.44mm), radius=0.15mm, height=1.68mm)
  V1177_AC = cylinder(axis=Z, base_centre=(-43.15mm, 46.4mm, -1.44mm), radius=0.15mm, height=1.68mm)
  V1178_AC = cylinder(axis=Z, base_centre=(41.65mm, 41.6mm, -1.44mm), radius=0.15mm, height=1.68mm)
  V1179_AC = cylinder(axis=Z, base_centre=(9.65mm, 40mm, -1.44mm), radius=0.15mm, height=1.68mm)
  V1180_AC = cylinder(axis=Z, base_centre=(9.25mm, 36mm, -1.44mm), radius=0.15mm, height=1.68mm)
  V1181_AC = cylinder(axis=Z, base_centre=(-25.55mm, 40mm, -1.44mm), radius=0.15mm, height=1.68mm)
  V1182_AC = cylinder(axis=Z, base_centre=(6.45mm, 40mm, -1.44mm), radius=0.15mm, height=1.68mm)
  V1183_AC = cylinder(axis=Z, base_centre=(6.85mm, 33.6mm, -1.44mm), radius=0.15mm, height=1.68mm)
  V1184_AC = cylinder(axis=Z, base_centre=(-17.55mm, 43.2mm, -1.44mm), radius=0.15mm, height=1.68mm)
  V1185_AC = cylinder(axis=Z, base_centre=(-31.95mm, 43.2mm, -1.44mm), radius=0.15mm, height=1.68mm)
  V1186_AC = cylinder(axis=Z, base_centre=(-27.15mm, 41.6mm, -1.44mm), radius=0.15mm, height=1.68mm)
  V1187_AC = cylinder(axis=Z, base_centre=(-20.75mm, 43.2mm, -1.44mm), radius=0.15mm, height=1.68mm)
  V1188_AC = cylinder(axis=Z, base_centre=(-43.15mm, 49.6mm, -1.44mm), radius=0.15mm, height=1.68mm)
  V1189_AC = cylinder(axis=Z, base_centre=(41.45mm, 32.4mm, -1.44mm), radius=0.15mm, height=1.68mm)
  V1190_AC = cylinder(axis=Z, base_centre=(-25.55mm, 48mm, -1.44mm), radius=0.15mm, height=1.68mm)
  V1191_AC = cylinder(axis=Z, base_centre=(-12.75mm, 51.2mm, -1.44mm), radius=0.15mm, height=1.68mm)
  V1192_AC = cylinder(axis=Z, base_centre=(-19.15mm, 41.6mm, -1.44mm), radius=0.15mm, height=1.68mm)
  V1193_AC = cylinder(axis=Z, base_centre=(-25.55mm, 51.2mm, -1.44mm), radius=0.15mm, height=1.68mm)
  V1194_AC = cylinder(axis=Z, base_centre=(-30.35mm, 44.8mm, -1.44mm), radius=0.15mm, height=1.68mm)
  V1195_AC = cylinder(axis=Z, base_centre=(40.05mm, 41.6mm, -1.44mm), radius=0.15mm, height=1.68mm)
  V1196_AC = cylinder(axis=Z, base_centre=(-41.55mm, 44.8mm, -1.44mm), radius=0.15mm, height=1.68mm)
  V1197_AC = cylinder(axis=Z, base_centre=(-17.55mm, 49.6mm, -1.44mm), radius=0.15mm, height=1.68mm)
  V1198_AC = cylinder(axis=Z, base_centre=(39.05mm, 36mm, -1.44mm), radius=0.15mm, height=1.68mm)
  V1199_AC = cylinder(axis=Z, base_centre=(28.85mm, 48mm, -1.44mm), radius=0.15mm, height=1.68mm)
  V1200_AC = cylinder(axis=Z, base_centre=(-14.35mm, 41.6mm, -1.44mm), radius=0.15mm, height=1.68mm)
  V1201_AC = cylinder(axis=Z, base_centre=(37.85mm, 38.4mm, -1.44mm), radius=0.15mm, height=1.68mm)
  V1202_AC = cylinder(axis=Z, base_centre=(14.45mm, 46.4mm, -1.44mm), radius=0.15mm, height=1.68mm)
  V1203_AC = cylinder(axis=Z, base_centre=(38.45mm, 46.4mm, -1.44mm), radius=0.15mm, height=1.68mm)
  V1204_AC = cylinder(axis=Z, base_centre=(6.85mm, 36mm, -1.44mm), radius=0.15mm, height=1.68mm)
  V1205_AC = cylinder(axis=Z, base_centre=(42.65mm, 32.4mm, -1.44mm), radius=0.15mm, height=1.68mm)
  V1206_AC = cylinder(axis=Z, base_centre=(24.05mm, 46.4mm, -1.44mm), radius=0.15mm, height=1.68mm)
  V1207_AC = cylinder(axis=Z, base_centre=(9.25mm, 38.4mm, -1.44mm), radius=0.15mm, height=1.68mm)
  V1208_AC = cylinder(axis=Z, base_centre=(12.85mm, 43.2mm, -1.44mm), radius=0.15mm, height=1.68mm)
  V1209_AC = cylinder(axis=Z, base_centre=(41.65mm, 40mm, -1.44mm), radius=0.15mm, height=1.68mm)
  V1210_AC = cylinder(axis=Z, base_centre=(-36.75mm, 44.8mm, -1.44mm), radius=0.15mm, height=1.68mm)
  V1211_AC = cylinder(axis=Z, base_centre=(28.85mm, 40mm, -1.44mm), radius=0.15mm, height=1.68mm)
  V1212_AC = cylinder(axis=Z, base_centre=(-11.15mm, 40mm, -1.44mm), radius=0.15mm, height=1.68mm)
  V1213_AC = cylinder(axis=Z, base_centre=(37.85mm, 34.8mm, -1.44mm), radius=0.15mm, height=1.68mm)
  V1214_AC = cylinder(axis=Z, base_centre=(-23.95mm, 49.6mm, -1.44mm), radius=0.15mm, height=1.68mm)
  V1215_AC = cylinder(axis=Z, base_centre=(8.05mm, 51.2mm, -1.44mm), radius=0.15mm, height=1.68mm)
  V1216_AC = cylinder(axis=Z, base_centre=(11.25mm, 52.8mm, -1.44mm), radius=0.15mm, height=1.68mm)
  V1217_AC = cylinder(axis=Z, base_centre=(33.65mm, 43.2mm, -1.44mm), radius=0.15mm, height=1.68mm)
  V1218_AC = cylinder(axis=Z, base_centre=(-23.95mm, 51.2mm, -1.44mm), radius=0.15mm, height=1.68mm)
  V1219_AC = cylinder(axis=Z, base_centre=(-28.75mm, 46.4mm, -1.44mm), radius=0.15mm, height=1.68mm)
  V1220_AC = cylinder(axis=Z, base_centre=(-35.15mm, 52.8mm, -1.44mm), radius=0.15mm, height=1.68mm)
  V1221_AC = cylinder(axis=Z, base_centre=(40.25mm, 33.6mm, -1.44mm), radius=0.15mm, height=1.68mm)
  V1222_AC = cylinder(axis=Z, base_centre=(-31.95mm, 46.4mm, -1.44mm), radius=0.15mm, height=1.68mm)
  V1223_AC = cylinder(axis=Z, base_centre=(16.05mm, 43.2mm, -1.44mm), radius=0.15mm, height=1.68mm)
  V1224_AC = cylinder(axis=Z, base_centre=(-4.85mm, 32.4mm, -1.44mm), radius=0.15mm, height=1.68mm)
  V1225_AC = cylinder(axis=Z, base_centre=(-38.25mm, 34.8mm, -1.44mm), radius=0.15mm, height=1.68mm)
  V1226_AC = cylinder(axis=Z, base_centre=(-20.75mm, 52.8mm, -1.44mm), radius=0.15mm, height=1.68mm)
  V1227_AC = cylinder(axis=Z, base_centre=(-22.35mm, 52.8mm, -1.44mm), radius=0.15mm, height=1.68mm)
  V1228_AC = cylinder(axis=Z, base_centre=(28.85mm, 44.8mm, -1.44mm), radius=0.15mm, height=1.68mm)
  V1229_AC = cylinder(axis=Z, base_centre=(40.25mm, 36mm, -1.44mm), radius=0.15mm, height=1.68mm)
  V1230_AC = cylinder(axis=Z, base_centre=(16.05mm, 44.8mm, -1.44mm), radius=0.15mm, height=1.68mm)
  V1231_AC = cylinder(axis=Z, base_centre=(38.45mm, 40mm, -1.44mm), radius=0.15mm, height=1.68mm)
  V1232_AC = cylinder(axis=Z, base_centre=(16.05mm, 46.4mm, -1.44mm), radius=0.15mm, height=1.68mm)
  V1233_AC = cylinder(axis=Z, base_centre=(28.85mm, 43.2mm, -1.44mm), radius=0.15mm, height=1.68mm)
  V1234_AC = cylinder(axis=Z, base_centre=(-40.65mm, 33.6mm, -1.44mm), radius=0.15mm, height=1.68mm)
  V1235_AC = cylinder(axis=Z, base_centre=(20.85mm, 41.6mm, -1.44mm), radius=0.15mm, height=1.68mm)
  V1236_AC = cylinder(axis=Z, base_centre=(8.05mm, 48mm, -1.44mm), radius=0.15mm, height=1.68mm)
  V1237_AC = cylinder(axis=Z, base_centre=(-15.95mm, 48mm, -1.44mm), radius=0.15mm, height=1.68mm)
  V1238_AC = cylinder(axis=Z, base_centre=(8.05mm, 44.8mm, -1.44mm), radius=0.15mm, height=1.68mm)
  V1239_AC = cylinder(axis=Z, base_centre=(-5.3259mm, 45.4695mm, -1.44mm), radius=0.2mm, height=1.68mm)
  V1240_AC = cylinder(axis=Z, base_centre=(-5.3259mm, 48.9305mm, -1.44mm), radius=0.2mm, height=1.68mm)
  V1241_AC = cylinder(axis=Z, base_centre=(-4.4mm, 47.2mm, -1.44mm), radius=0.2mm, height=1.68mm)
  V1242_AC = cylinder(axis=Z, base_centre=(-3.2916mm, 42.6695mm, -1.44mm), radius=0.2mm, height=1.68mm)
  V1243_AC = cylinder(axis=Z, base_centre=(-3.2916mm, 51.7305mm, -1.44mm), radius=0.2mm, height=1.68mm)
  V1244_AC = cylinder(axis=Z, base_centre=(-2.2mm, 43.3895mm, -1.44mm), radius=0.2mm, height=1.68mm)
  V1245_AC = cylinder(axis=Z, base_centre=(-2.2mm, 51.0105mm, -1.44mm), radius=0.2mm, height=1.68mm)
  V1246_AC = cylinder(axis=Z, base_centre=(0mm, 41.6mm, -1.44mm), radius=0.2mm, height=1.68mm)
  V1247_AC = cylinder(axis=Z, base_centre=(0mm, 47.2mm, -1.44mm), radius=3.2mm, height=1.68mm)
  V1248_AC = cylinder(axis=Z, base_centre=(0mm, 52.8mm, -1.44mm), radius=0.2mm, height=1.68mm)
  V1249_AC = cylinder(axis=Z, base_centre=(2.2mm, 43.3895mm, -1.44mm), radius=0.2mm, height=1.68mm)
  V1250_AC = cylinder(axis=Z, base_centre=(2.2mm, 51.0105mm, -1.44mm), radius=0.2mm, height=1.68mm)
  V1251_AC = cylinder(axis=Z, base_centre=(3.2916mm, 42.6695mm, -1.44mm), radius=0.2mm, height=1.68mm)
  V1252_AC = cylinder(axis=Z, base_centre=(3.2916mm, 51.7305mm, -1.44mm), radius=0.2mm, height=1.68mm)
  V1253_AC = cylinder(axis=Z, base_centre=(4.4mm, 47.2mm, -1.44mm), radius=0.2mm, height=1.68mm)
  V1254_AC = cylinder(axis=Z, base_centre=(5.3259mm, 45.4695mm, -1.44mm), radius=0.2mm, height=1.68mm)
  V1255_AC = cylinder(axis=Z, base_centre=(5.3259mm, 48.9305mm, -1.44mm), radius=0.2mm, height=1.68mm)
  Q5_3 = box(corner=(15.2mm, 3.1mm, 0.17mm), size=(0.65mm, 3.6mm, 0.105mm))
  Q5_4 = box(corner=(14.35mm, 3.1mm, 0.17mm), size=(0.65mm, 3.6mm, 0.105mm))
  Q5_5 = box(corner=(13.5mm, 3.1mm, 0.17mm), size=(0.65mm, 3.6mm, 0.105mm))
  Q5_6 = box(corner=(12.65mm, 3.1mm, 0.17mm), size=(0.65mm, 3.6mm, 0.105mm))
  Q5_7 = box(corner=(11.347mm, 3.1mm, 0.17mm), size=(1.102mm, 3.6mm, 0.105mm))
  Q3_3 = box(corner=(-32.3mm, 7.4mm, 0.17mm), size=(0.65mm, 3.6mm, 0.105mm))
  Q3_4 = box(corner=(-33.15mm, 7.4mm, 0.17mm), size=(0.65mm, 3.6mm, 0.105mm))
  Q3_5 = box(corner=(-34mm, 7.4mm, 0.17mm), size=(0.65mm, 3.6mm, 0.105mm))
  Q3_6 = box(corner=(-34.85mm, 7.4mm, 0.17mm), size=(0.65mm, 3.6mm, 0.105mm))
  Q3_7 = box(corner=(-36.153mm, 7.4mm, 0.17mm), size=(1.102mm, 3.6mm, 0.105mm))
  Q4_3 = box(corner=(-15.85mm, 7.4mm, 0.17mm), size=(0.65mm, 3.6mm, 0.105mm))
  Q4_4 = box(corner=(-15mm, 7.4mm, 0.17mm), size=(0.65mm, 3.6mm, 0.105mm))
  Q4_5 = box(corner=(-14.15mm, 7.4mm, 0.17mm), size=(0.65mm, 3.6mm, 0.105mm))
  Q4_6 = box(corner=(-13.3mm, 7.4mm, 0.17mm), size=(0.65mm, 3.6mm, 0.105mm))
  Q4_7 = box(corner=(-12.449mm, 7.4mm, 0.17mm), size=(1.102mm, 3.6mm, 0.105mm))
  Q7_3 = box(corner=(15.2mm, 7.4mm, 0.17mm), size=(0.65mm, 3.6mm, 0.105mm))
  Q7_4 = box(corner=(14.35mm, 7.4mm, 0.17mm), size=(0.65mm, 3.6mm, 0.105mm))
  Q7_5 = box(corner=(13.5mm, 7.4mm, 0.17mm), size=(0.65mm, 3.6mm, 0.105mm))
  Q7_6 = box(corner=(12.65mm, 7.4mm, 0.17mm), size=(0.65mm, 3.6mm, 0.105mm))
  Q7_7 = box(corner=(11.347mm, 7.4mm, 0.17mm), size=(1.102mm, 3.6mm, 0.105mm))
  Q6_3 = box(corner=(31.65mm, 3.1mm, 0.17mm), size=(0.65mm, 3.6mm, 0.105mm))
  Q6_4 = box(corner=(32.5mm, 3.1mm, 0.17mm), size=(0.65mm, 3.6mm, 0.105mm))
  Q6_5 = box(corner=(33.35mm, 3.1mm, 0.17mm), size=(0.65mm, 3.6mm, 0.105mm))
  Q6_6 = box(corner=(34.2mm, 3.1mm, 0.17mm), size=(0.65mm, 3.6mm, 0.105mm))
  Q6_7 = box(corner=(35.051mm, 3.1mm, 0.17mm), size=(1.102mm, 3.6mm, 0.105mm))
  Q8_3 = box(corner=(31.65mm, 7.4mm, 0.17mm), size=(0.65mm, 3.6mm, 0.105mm))
  Q8_4 = box(corner=(32.5mm, 7.4mm, 0.17mm), size=(0.65mm, 3.6mm, 0.105mm))
  Q8_5 = box(corner=(33.35mm, 7.4mm, 0.17mm), size=(0.65mm, 3.6mm, 0.105mm))
  Q8_6 = box(corner=(34.2mm, 7.4mm, 0.17mm), size=(0.65mm, 3.6mm, 0.105mm))
  Q8_7 = box(corner=(35.051mm, 7.4mm, 0.17mm), size=(1.102mm, 3.6mm, 0.105mm))
  Q1_3 = box(corner=(-32.3mm, 3.1mm, 0.17mm), size=(0.65mm, 3.6mm, 0.105mm))
  Q1_4 = box(corner=(-33.15mm, 3.1mm, 0.17mm), size=(0.65mm, 3.6mm, 0.105mm))
  Q1_5 = box(corner=(-34mm, 3.1mm, 0.17mm), size=(0.65mm, 3.6mm, 0.105mm))
  Q1_6 = box(corner=(-34.85mm, 3.1mm, 0.17mm), size=(0.65mm, 3.6mm, 0.105mm))
  Q1_7 = box(corner=(-36.153mm, 3.1mm, 0.17mm), size=(1.102mm, 3.6mm, 0.105mm))
  Q2_3 = box(corner=(-15.85mm, 3.1mm, 0.17mm), size=(0.65mm, 3.6mm, 0.105mm))
  Q2_4 = box(corner=(-15mm, 3.1mm, 0.17mm), size=(0.65mm, 3.6mm, 0.105mm))
  Q2_5 = box(corner=(-14.15mm, 3.1mm, 0.17mm), size=(0.65mm, 3.6mm, 0.105mm))
  Q2_6 = box(corner=(-13.3mm, 3.1mm, 0.17mm), size=(0.65mm, 3.6mm, 0.105mm))
  Q2_7 = box(corner=(-12.449mm, 3.1mm, 0.17mm), size=(1.102mm, 3.6mm, 0.105mm))
  C7_1 = box(corner=(-18.975mm, 1.65mm, 0.17mm), size=(1.45mm, 1mm, 0.105mm))
  C7_2 = box(corner=(-18.975mm, -0.25mm, 0.17mm), size=(1.45mm, 1mm, 0.105mm))
  RS1_1 = box(corner=(-43.65mm, 11.2mm, 0.17mm), size=(15mm, 1.2mm, 0.105mm))
  RS1_2 = box(corner=(-43.65mm, 12.9mm, 0.17mm), size=(15mm, 3mm, 0.105mm))
  C71_1 = box(corner=(-23.7mm, -10.05mm, 0.17mm), size=(5.4mm, 1.8mm, 0.105mm))
  C71_2 = box(corner=(-23.7mm, -15.15mm, 0.17mm), size=(5.4mm, 1.8mm, 0.105mm))
  C37_1 = box(corner=(12.725mm, 1.65mm, 0.17mm), size=(1.45mm, 1mm, 0.105mm))
  C37_2 = box(corner=(12.725mm, -0.25mm, 0.17mm), size=(1.45mm, 1mm, 0.105mm))
  C2_1 = box(corner=(-36.375mm, 1.65mm, 0.17mm), size=(1.45mm, 1mm, 0.105mm))
  C2_2 = box(corner=(-36.375mm, -0.25mm, 0.17mm), size=(1.45mm, 1mm, 0.105mm))
  C44_1 = box(corner=(33.325mm, 1.65mm, 0.17mm), size=(1.45mm, 1mm, 0.105mm))
  C44_2 = box(corner=(33.325mm, -0.25mm, 0.17mm), size=(1.45mm, 1mm, 0.105mm))
  C4_1 = box(corner=(-33.175mm, 1.65mm, 0.17mm), size=(1.45mm, 1mm, 0.105mm))
  C4_2 = box(corner=(-33.175mm, -0.25mm, 0.17mm), size=(1.45mm, 1mm, 0.105mm))
  C9_1 = box(corner=(-15.775mm, 1.65mm, 0.17mm), size=(1.45mm, 1mm, 0.105mm))
  C9_2 = box(corner=(-15.775mm, -0.25mm, 0.17mm), size=(1.45mm, 1mm, 0.105mm))
  C1_1 = box(corner=(-37.975mm, 1.65mm, 0.17mm), size=(1.45mm, 1mm, 0.105mm))
  C1_2 = box(corner=(-37.975mm, -0.25mm, 0.17mm), size=(1.45mm, 1mm, 0.105mm))
  C82_1 = box(corner=(12.3mm, -2.85mm, 0.17mm), size=(5.4mm, 1.8mm, 0.105mm))
  C82_2 = box(corner=(12.3mm, -7.95mm, 0.17mm), size=(5.4mm, 1.8mm, 0.105mm))
  C12_1 = box(corner=(-10.975mm, 1.65mm, 0.17mm), size=(1.45mm, 1mm, 0.105mm))
  C12_2 = box(corner=(-10.975mm, -0.25mm, 0.17mm), size=(1.45mm, 1mm, 0.105mm))
  C74_1 = box(corner=(24.3mm, -10.05mm, 0.17mm), size=(5.4mm, 1.8mm, 0.105mm))
  C74_2 = box(corner=(24.3mm, -15.15mm, 0.17mm), size=(5.4mm, 1.8mm, 0.105mm))
  RS4_1 = box(corner=(28.65mm, 11.2mm, 0.17mm), size=(15mm, 1.2mm, 0.105mm))
  RS4_2 = box(corner=(28.65mm, 12.9mm, 0.17mm), size=(15mm, 3mm, 0.105mm))
  C45_1 = box(corner=(34.925mm, 1.65mm, 0.17mm), size=(1.45mm, 1mm, 0.105mm))
  C45_2 = box(corner=(34.925mm, -0.25mm, 0.17mm), size=(1.45mm, 1mm, 0.105mm))
  C43_1 = box(corner=(31.725mm, 1.65mm, 0.17mm), size=(1.45mm, 1mm, 0.105mm))
  C43_2 = box(corner=(31.725mm, -0.25mm, 0.17mm), size=(1.45mm, 1mm, 0.105mm))
  C39_1 = box(corner=(15.925mm, 1.65mm, 0.17mm), size=(1.45mm, 1mm, 0.105mm))
  C39_2 = box(corner=(15.925mm, -0.25mm, 0.17mm), size=(1.45mm, 1mm, 0.105mm))
  C72_1 = box(corner=(18.3mm, -10.05mm, 0.17mm), size=(5.4mm, 1.8mm, 0.105mm))
  C72_2 = box(corner=(18.3mm, -15.15mm, 0.17mm), size=(5.4mm, 1.8mm, 0.105mm))
  C11_1 = box(corner=(-12.575mm, 1.65mm, 0.17mm), size=(1.45mm, 1mm, 0.105mm))
  C11_2 = box(corner=(-12.575mm, -0.25mm, 0.17mm), size=(1.45mm, 1mm, 0.105mm))
  C86_1 = box(corner=(24.3mm, -2.85mm, 0.17mm), size=(5.4mm, 1.8mm, 0.105mm))
  C86_2 = box(corner=(24.3mm, -7.95mm, 0.17mm), size=(5.4mm, 1.8mm, 0.105mm))
  RS3_1 = box(corner=(3.85mm, 11.2mm, 0.17mm), size=(15mm, 1.2mm, 0.105mm))
  RS3_2 = box(corner=(3.85mm, 12.9mm, 0.17mm), size=(15mm, 3mm, 0.105mm))
  C36_1 = box(corner=(11.125mm, 1.65mm, 0.17mm), size=(1.45mm, 1mm, 0.105mm))
  C36_2 = box(corner=(11.125mm, -0.25mm, 0.17mm), size=(1.45mm, 1mm, 0.105mm))
  C38_1 = box(corner=(14.325mm, 1.65mm, 0.17mm), size=(1.45mm, 1mm, 0.105mm))
  C38_2 = box(corner=(14.325mm, -0.25mm, 0.17mm), size=(1.45mm, 1mm, 0.105mm))
  C84_1 = box(corner=(18.3mm, -2.85mm, 0.17mm), size=(5.4mm, 1.8mm, 0.105mm))
  C84_2 = box(corner=(18.3mm, -7.95mm, 0.17mm), size=(5.4mm, 1.8mm, 0.105mm))
  C77_1 = box(corner=(-5.7mm, -2.85mm, 0.17mm), size=(5.4mm, 1.8mm, 0.105mm))
  C77_2 = box(corner=(-5.7mm, -7.95mm, 0.17mm), size=(5.4mm, 1.8mm, 0.105mm))
  C8_1 = box(corner=(-17.375mm, 1.65mm, 0.17mm), size=(1.45mm, 1mm, 0.105mm))
  C8_2 = box(corner=(-17.375mm, -0.25mm, 0.17mm), size=(1.45mm, 1mm, 0.105mm))
  C70_1 = box(corner=(12.3mm, -10.05mm, 0.17mm), size=(5.4mm, 1.8mm, 0.105mm))
  C70_2 = box(corner=(12.3mm, -15.15mm, 0.17mm), size=(5.4mm, 1.8mm, 0.105mm))
  C40_1 = box(corner=(17.525mm, 1.65mm, 0.17mm), size=(1.45mm, 1mm, 0.105mm))
  C40_2 = box(corner=(17.525mm, -0.25mm, 0.17mm), size=(1.45mm, 1mm, 0.105mm))
  C79_1 = box(corner=(-11.7mm, -2.85mm, 0.17mm), size=(5.4mm, 1.8mm, 0.105mm))
  C79_2 = box(corner=(-11.7mm, -7.95mm, 0.17mm), size=(5.4mm, 1.8mm, 0.105mm))
  C80_1 = box(corner=(6.3mm, -2.85mm, 0.17mm), size=(5.4mm, 1.8mm, 0.105mm))
  C80_2 = box(corner=(6.3mm, -7.95mm, 0.17mm), size=(5.4mm, 1.8mm, 0.105mm))
  C42_1 = box(corner=(30.125mm, 1.65mm, 0.17mm), size=(1.45mm, 1mm, 0.105mm))
  C42_2 = box(corner=(30.125mm, -0.25mm, 0.17mm), size=(1.45mm, 1mm, 0.105mm))
  C5_1 = box(corner=(-31.575mm, 1.65mm, 0.17mm), size=(1.45mm, 1mm, 0.105mm))
  C5_2 = box(corner=(-31.575mm, -0.25mm, 0.17mm), size=(1.45mm, 1mm, 0.105mm))
  C3_1 = box(corner=(-34.775mm, 1.65mm, 0.17mm), size=(1.45mm, 1mm, 0.105mm))
  C3_2 = box(corner=(-34.775mm, -0.25mm, 0.17mm), size=(1.45mm, 1mm, 0.105mm))
  C85_1 = box(corner=(-29.7mm, -2.85mm, 0.17mm), size=(5.4mm, 1.8mm, 0.105mm))
  C85_2 = box(corner=(-29.7mm, -7.95mm, 0.17mm), size=(5.4mm, 1.8mm, 0.105mm))
  C10_1 = box(corner=(-14.175mm, 1.65mm, 0.17mm), size=(1.45mm, 1mm, 0.105mm))
  C10_2 = box(corner=(-14.175mm, -0.25mm, 0.17mm), size=(1.45mm, 1mm, 0.105mm))
  J_AC = box(corner=(-6mm, 41.2mm, -1.475mm), size=(12mm, 12mm, 0.105mm))
  C73_1 = box(corner=(-29.7mm, -10.05mm, 0.17mm), size=(5.4mm, 1.8mm, 0.105mm))
  C73_2 = box(corner=(-29.7mm, -15.15mm, 0.17mm), size=(5.4mm, 1.8mm, 0.105mm))
  C69_1 = box(corner=(-17.7mm, -10.05mm, 0.17mm), size=(5.4mm, 1.8mm, 0.105mm))
  C69_2 = box(corner=(-17.7mm, -15.15mm, 0.17mm), size=(5.4mm, 1.8mm, 0.105mm))
  C41_1 = box(corner=(28.525mm, 1.65mm, 0.17mm), size=(1.45mm, 1mm, 0.105mm))
  C41_2 = box(corner=(28.525mm, -0.25mm, 0.17mm), size=(1.45mm, 1mm, 0.105mm))
  RS2_1 = box(corner=(-18.85mm, 11.2mm, 0.17mm), size=(15mm, 1.2mm, 0.105mm))
  RS2_2 = box(corner=(-18.85mm, 12.9mm, 0.17mm), size=(15mm, 3mm, 0.105mm))
  C78_1 = box(corner=(0.3mm, -2.85mm, 0.17mm), size=(5.4mm, 1.8mm, 0.105mm))
  C78_2 = box(corner=(0.3mm, -7.95mm, 0.17mm), size=(5.4mm, 1.8mm, 0.105mm))
  C76_1 = box(corner=(30.3mm, -10.05mm, 0.17mm), size=(5.4mm, 1.8mm, 0.105mm))
  C76_2 = box(corner=(30.3mm, -15.15mm, 0.17mm), size=(5.4mm, 1.8mm, 0.105mm))
  C75_1 = box(corner=(-35.7mm, -10.05mm, 0.17mm), size=(5.4mm, 1.8mm, 0.105mm))
  C75_2 = box(corner=(-35.7mm, -15.15mm, 0.17mm), size=(5.4mm, 1.8mm, 0.105mm))
  C6_1 = box(corner=(-29.975mm, 1.65mm, 0.17mm), size=(1.45mm, 1mm, 0.105mm))
  C6_2 = box(corner=(-29.975mm, -0.25mm, 0.17mm), size=(1.45mm, 1mm, 0.105mm))
  C81_1 = box(corner=(-17.7mm, -2.85mm, 0.17mm), size=(5.4mm, 1.8mm, 0.105mm))
  C81_2 = box(corner=(-17.7mm, -7.95mm, 0.17mm), size=(5.4mm, 1.8mm, 0.105mm))
  C35_1 = box(corner=(9.525mm, 1.65mm, 0.17mm), size=(1.45mm, 1mm, 0.105mm))
  C35_2 = box(corner=(9.525mm, -0.25mm, 0.17mm), size=(1.45mm, 1mm, 0.105mm))
  C83_1 = box(corner=(-23.7mm, -2.85mm, 0.17mm), size=(5.4mm, 1.8mm, 0.105mm))
  C83_2 = box(corner=(-23.7mm, -7.95mm, 0.17mm), size=(5.4mm, 1.8mm, 0.105mm))
  C88_1 = box(corner=(30.3mm, -2.85mm, 0.17mm), size=(5.4mm, 1.8mm, 0.105mm))
  C88_2 = box(corner=(30.3mm, -7.95mm, 0.17mm), size=(5.4mm, 1.8mm, 0.105mm))
  C46_1 = box(corner=(36.525mm, 1.65mm, 0.17mm), size=(1.45mm, 1mm, 0.105mm))
  C46_2 = box(corner=(36.525mm, -0.25mm, 0.17mm), size=(1.45mm, 1mm, 0.105mm))
  C87_1 = box(corner=(-35.7mm, -2.85mm, 0.17mm), size=(5.4mm, 1.8mm, 0.105mm))
  C87_2 = box(corner=(-35.7mm, -7.95mm, 0.17mm), size=(5.4mm, 1.8mm, 0.105mm))
  C27_1 = box(corner=(-34.775mm, -0.25mm, -1.475mm), size=(1.45mm, 1mm, 0.105mm))
  C27_2 = box(corner=(-34.775mm, 1.65mm, -1.475mm), size=(1.45mm, 1mm, 0.105mm))
  C34_1 = box(corner=(-18.975mm, -0.25mm, -1.475mm), size=(1.45mm, 1mm, 0.105mm))
  C34_2 = box(corner=(-18.975mm, 1.65mm, -1.475mm), size=(1.45mm, 1mm, 0.105mm))
  C61_1 = box(corner=(12.725mm, -0.25mm, -1.475mm), size=(1.45mm, 1mm, 0.105mm))
  C61_2 = box(corner=(12.725mm, 1.65mm, -1.475mm), size=(1.45mm, 1mm, 0.105mm))
  C28_1 = box(corner=(-33.175mm, -0.25mm, -1.475mm), size=(1.45mm, 1mm, 0.105mm))
  C28_2 = box(corner=(-33.175mm, 1.65mm, -1.475mm), size=(1.45mm, 1mm, 0.105mm))
  C32_1 = box(corner=(-15.775mm, -0.25mm, -1.475mm), size=(1.45mm, 1mm, 0.105mm))
  C32_2 = box(corner=(-15.775mm, 1.65mm, -1.475mm), size=(1.45mm, 1mm, 0.105mm))
  C63_1 = box(corner=(15.925mm, -0.25mm, -1.475mm), size=(1.45mm, 1mm, 0.105mm))
  C63_2 = box(corner=(15.925mm, 1.65mm, -1.475mm), size=(1.45mm, 1mm, 0.105mm))
  C31_1 = box(corner=(-14.175mm, -0.25mm, -1.475mm), size=(1.45mm, 1mm, 0.105mm))
  C31_2 = box(corner=(-14.175mm, 1.65mm, -1.475mm), size=(1.45mm, 1mm, 0.105mm))
  J_DCP = box(corner=(-9.5mm, -22.3mm, -1.475mm), size=(7mm, 7mm, 0.105mm))
  C65_1 = box(corner=(33.325mm, -0.25mm, -1.475mm), size=(1.45mm, 1mm, 0.105mm))
  C65_2 = box(corner=(33.325mm, 1.65mm, -1.475mm), size=(1.45mm, 1mm, 0.105mm))
  C67_1 = box(corner=(30.125mm, -0.25mm, -1.475mm), size=(1.45mm, 1mm, 0.105mm))
  C67_2 = box(corner=(30.125mm, 1.65mm, -1.475mm), size=(1.45mm, 1mm, 0.105mm))
  C68_1 = box(corner=(28.525mm, -0.25mm, -1.475mm), size=(1.45mm, 1mm, 0.105mm))
  C68_2 = box(corner=(28.525mm, 1.65mm, -1.475mm), size=(1.45mm, 1mm, 0.105mm))
  C29_1 = box(corner=(-31.575mm, -0.25mm, -1.475mm), size=(1.45mm, 1mm, 0.105mm))
  C29_2 = box(corner=(-31.575mm, 1.65mm, -1.475mm), size=(1.45mm, 1mm, 0.105mm))
  C33_1 = box(corner=(-17.375mm, -0.25mm, -1.475mm), size=(1.45mm, 1mm, 0.105mm))
  C33_2 = box(corner=(-17.375mm, 1.65mm, -1.475mm), size=(1.45mm, 1mm, 0.105mm))
  C62_1 = box(corner=(14.325mm, -0.25mm, -1.475mm), size=(1.45mm, 1mm, 0.105mm))
  C62_2 = box(corner=(14.325mm, 1.65mm, -1.475mm), size=(1.45mm, 1mm, 0.105mm))
  C66_1 = box(corner=(31.725mm, -0.25mm, -1.475mm), size=(1.45mm, 1mm, 0.105mm))
  C66_2 = box(corner=(31.725mm, 1.65mm, -1.475mm), size=(1.45mm, 1mm, 0.105mm))
  C64_1 = box(corner=(17.525mm, -0.25mm, -1.475mm), size=(1.45mm, 1mm, 0.105mm))
  C64_2 = box(corner=(17.525mm, 1.65mm, -1.475mm), size=(1.45mm, 1mm, 0.105mm))
  J_DCN = box(corner=(2.5mm, -22.3mm, -1.475mm), size=(7mm, 7mm, 0.105mm))
  C30_1 = box(corner=(-29.975mm, -0.25mm, -1.475mm), size=(1.45mm, 1mm, 0.105mm))
  C30_2 = box(corner=(-29.975mm, 1.65mm, -1.475mm), size=(1.45mm, 1mm, 0.105mm))
  P32_AC_L1.unite(P33_AC_L1, P34_AC_L1, P35_AC_L1, P36_AC_L1, P37_AC_L2, P38_AC_L3, P39_AC_L4, V529_AC, V530_AC, V531_AC, V532_AC, V533_AC, V534_AC, V535_AC, V536_AC, V537_AC, V538_AC, V539_AC, V540_AC, V541_AC, V542_AC, V543_AC, V544_AC, V545_AC, V546_AC, V547_AC, V548_AC, V549_AC, V550_AC, V551_AC, V552_AC, V553_AC, V554_AC, V555_AC, V556_AC, V557_AC, V558_AC, V559_AC, V560_AC, V561_AC, V562_AC, V563_AC, V564_AC, V565_AC, V566_AC, V567_AC, V568_AC, V569_AC, V570_AC, V571_AC, V572_AC, V573_AC, V574_AC, V575_AC, V576_AC, V577_AC, V578_AC, V579_AC, V580_AC, V581_AC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)
  P32_AC_L1.separate_bodies()
  P28_LSRC3_L1.unite(P29_LSRC3_L4, V677_LSRC3, Q7_4, Q7_6, RS3_1)
  P28_LSRC3_L1.separate_bodies()
  P26_LSRC2_L1.unite(P27_LSRC2_L4, V676_LSRC2, Q4_4, Q4_6, RS2_1)
  P26_LSRC2_L1.separate_bodies()
  P24_LSRC1_L1.unite(P25_LSRC1_L4, V675_LSRC1, Q3_4, Q3_6, RS1_1)
  P24_LSRC1_L1.separate_bodies()
  P30_LSRC4_L1.unite(P31_LSRC4_L4, V678_LSRC4, Q8_4, Q8_6, RS4_1)
  P30_LSRC4_L1.separate_bodies()
  P0_DCN_L1.unite(P1_DCN_L1, P2_DCN_L1, P3_DCN_L1, P4_DCN_L1, P5_DCN_L1, P6_DCN_L2, P7_DCN_L4, P8_DCN_L4, P9_DCN_L4, P10_DCN_L4, P11_DCN_L4, V164_DCN, V165_DCN, V166_DCN, V167_DCN, V168_DCN, V169_DCN, V170_DCN, V171_DCN, V172_DCN, V173_DCN, V174_DCN, V175_DCN, V176_DCN, V177_DCN, V178_DCN, V179_DCN, V180_DCN, V181_DCN, V182_DCN, V183_DCN, V184_DCN, V185_DCN, V186_DCN, V187_DCN, V188_DCN, V189_DCN, V190_DCN, V191_DCN, V192_DCN, V193_DCN, V194_DCN, V195_DCN, V196_DCN, V197_DCN, V198_DCN, V199_DCN, V200_DCN, V201_DCN, V202_DCN, V203_DCN, V204_DCN, V205_DCN, V206_DCN, V207_DCN, V208_DCN, V209_DCN, V210_DCN, V211_DCN, V212_DCN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)
  P0_DCN_L1.separate_bodies()
  P12_DCP_L1.unite(P13_DCP_L1, P14_DCP_L1, P15_DCP_L1, P16_DCP_L1, P17_DCP_L1, P18_DCP_L3, P19_DCP_L4, P20_DCP_L4, P21_DCP_L4, P22_DCP_L4, P23_DCP_L4, V0_DCP, V1_DCP, V2_DCP, V3_DCP, V4_DCP, V5_DCP, V6_DCP, V7_DCP, V8_DCP, V9_DCP, V10_DCP, V11_DCP, V12_DCP, V13_DCP, V14_DCP, V15_DCP, V16_DCP, V17_DCP, V18_DCP, V19_DCP, V20_DCP, V21_DCP, V22_DCP, V23_DCP, V24_DCP, V25_DCP, V26_DCP, V27_DCP, V28_DCP, V29_DCP, V30_DCP, V31_DCP, V32_DCP, V33_DCP, V34_DCP, V35_DCP, V36_DCP, V37_DCP, V38_DCP, V39_DCP, V40_DCP, V41_DCP, V42_DCP, V43_DCP, V44_DCP, V45_DCP, V46_DCP, V47_DCP, V48_DCP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)
  P12_DCP_L1.separate_bodies()
boundaries and excitations:
  AC: SignalNet Objects=P32_AC_L1
  LSRC3: SignalNet Objects=P28_LSRC3_L1
  LSRC2: SignalNet Objects=P26_LSRC2_L1
  LSRC1: SignalNet Objects=P24_LSRC1_L1
  LSRC4: SignalNet Objects=P30_LSRC4_L1
  DCN: SignalNet Objects=P0_DCN_L1
  DCP: SignalNet Objects=P12_DCP_L1
  BankN_1: Source Faces=P0_DCN_L1.face(at (-27, -1.95, 0.275), at (-27, -9.15, 0.275), at (-33, -9.15, 0.275), at (-33, -1.95, 0.275)) TerminalType=ConstantVoltage Net=DCN
  BankN_2: Source Faces=P0_DCN_L1.face(at (-21, -9.15, 0.275), at (-9, -1.95, 0.275), at (-15, -9.15, 0.275), at (-15, -1.95, 0.275), at (-21, -1.95, 0.275)) TerminalType=ConstantVoltage Net=DCN
  BankN_3: Source Faces=P0_DCN_L1.face(at (15, -1.95, 0.275), at (21, -9.15, 0.275), at (21, -1.95, 0.275), at (15, -9.15, 0.275), at (9, -1.95, 0.275)) TerminalType=ConstantVoltage Net=DCN
  BankN_4: Source Faces=P0_DCN_L1.face(at (27, -9.15, 0.275), at (27, -1.95, 0.275), at (33, -9.15, 0.275), at (33, -1.95, 0.275)) TerminalType=ConstantVoltage Net=DCN
  BankN_C: Source Faces=P0_DCN_L1.face(at (-3, -1.95, 0.275), at (3, -1.95, 0.275)) TerminalType=ConstantVoltage Net=DCN
  BankP_1: Source Faces=P12_DCP_L1.face(at (-27, -7.05, 0.275), at (-27, -14.25, 0.275), at (-33, -14.25, 0.275), at (-33, -7.05, 0.275)) TerminalType=ConstantVoltage Net=DCP
  BankP_2: Source Faces=P12_DCP_L1.face(at (-21, -14.25, 0.275), at (-9, -7.05, 0.275), at (-15, -14.25, 0.275), at (-15, -7.05, 0.275), at (-21, -7.05, 0.275)) TerminalType=ConstantVoltage Net=DCP
  BankP_3: Source Faces=P12_DCP_L1.face(at (15, -7.05, 0.275), at (21, -14.25, 0.275), at (21, -7.05, 0.275), at (15, -14.25, 0.275), at (9, -7.05, 0.275)) TerminalType=ConstantVoltage Net=DCP
  BankP_4: Source Faces=P12_DCP_L1.face(at (27, -14.25, 0.275), at (27, -7.05, 0.275), at (33, -14.25, 0.275), at (33, -7.05, 0.275)) TerminalType=ConstantVoltage Net=DCP
  BankP_C: Source Faces=P12_DCP_L1.face(at (-3, -7.05, 0.275), at (3, -7.05, 0.275)) TerminalType=ConstantVoltage Net=DCP
  CapN_1: Source Faces=P0_DCN_L1.face(at (-35.65, 0.25, 0.275), at (-32.45, 0.25, 0.275), at (-37.25, 0.25, 0.275), at (-30.85, 0.25, 0.275), at (-34.05, 0.25, 0.275), at (-29.25, 0.25, 0.275)) TerminalType=ConstantVoltage Net=DCN
  CapN_2: Source Faces=P0_DCN_L1.face(at (-18.25, 0.25, 0.275), at (-15.05, 0.25, 0.275), at (-10.25, 0.25, 0.275), at (-11.85, 0.25, 0.275), at (-16.65, 0.25, 0.275), at (-13.45, 0.25, 0.275)) TerminalType=ConstantVoltage Net=DCN
  CapN_3: Source Faces=P0_DCN_L1.face(at (13.45, 0.25, 0.275), at (16.65, 0.25, 0.275), at (11.85, 0.25, 0.275), at (15.05, 0.25, 0.275), at (18.25, 0.25, 0.275), at (10.25, 0.25, 0.275)) TerminalType=ConstantVoltage Net=DCN
  CapN_4: Source Faces=P0_DCN_L1.face(at (34.05, 0.25, 0.275), at (35.65, 0.25, 0.275), at (32.45, 0.25, 0.275), at (30.85, 0.25, 0.275), at (29.25, 0.25, 0.275), at (37.25, 0.25, 0.275)) TerminalType=ConstantVoltage Net=DCN
  CapNb_1: Source Faces=P0_DCN_L1.face(at (-34.05, 0.25, -1.475), at (-32.45, 0.25, -1.475), at (-30.85, 0.25, -1.475), at (-29.25, 0.25, -1.475)) TerminalType=ConstantVoltage Net=DCN
  CapNb_2: Source Faces=P0_DCN_L1.face(at (-18.25, 0.25, -1.475), at (-15.05, 0.25, -1.475), at (-13.45, 0.25, -1.475), at (-16.65, 0.25, -1.475)) TerminalType=ConstantVoltage Net=DCN
  CapNb_3: Source Faces=P0_DCN_L1.face(at (13.45, 0.25, -1.475), at (16.65, 0.25, -1.475), at (15.05, 0.25, -1.475), at (18.25, 0.25, -1.475)) TerminalType=ConstantVoltage Net=DCN
  CapNb_4: Source Faces=P0_DCN_L1.face(at (34.05, 0.25, -1.475), at (30.85, 0.25, -1.475), at (29.25, 0.25, -1.475), at (32.45, 0.25, -1.475)) TerminalType=ConstantVoltage Net=DCN
  CapP_1: Source Faces=P12_DCP_L1.face(at (-35.65, 2.15, 0.275), at (-32.45, 2.15, 0.275), at (-37.25, 2.15, 0.275), at (-30.85, 2.15, 0.275), at (-34.05, 2.15, 0.275), at (-29.25, 2.15, 0.275)) TerminalType=ConstantVoltage Net=DCP
  CapP_2: Source Faces=P12_DCP_L1.face(at (-18.25, 2.15, 0.275), at (-15.05, 2.15, 0.275), at (-10.25, 2.15, 0.275), at (-11.85, 2.15, 0.275), at (-16.65, 2.15, 0.275), at (-13.45, 2.15, 0.275)) TerminalType=ConstantVoltage Net=DCP
  CapP_3: Source Faces=P12_DCP_L1.face(at (13.45, 2.15, 0.275), at (16.65, 2.15, 0.275), at (11.85, 2.15, 0.275), at (15.05, 2.15, 0.275), at (18.25, 2.15, 0.275), at (10.25, 2.15, 0.275)) TerminalType=ConstantVoltage Net=DCP
  CapP_4: Source Faces=P12_DCP_L1.face(at (34.05, 2.15, 0.275), at (35.65, 2.15, 0.275), at (32.45, 2.15, 0.275), at (30.85, 2.15, 0.275), at (29.25, 2.15, 0.275), at (37.25, 2.15, 0.275)) TerminalType=ConstantVoltage Net=DCP
  CapPb_1: Source Faces=P12_DCP_L1.face(at (-34.05, 2.15, -1.475), at (-32.45, 2.15, -1.475), at (-30.85, 2.15, -1.475), at (-29.25, 2.15, -1.475)) TerminalType=ConstantVoltage Net=DCP
  CapPb_2: Source Faces=P12_DCP_L1.face(at (-18.25, 2.15, -1.475), at (-15.05, 2.15, -1.475), at (-13.45, 2.15, -1.475), at (-16.65, 2.15, -1.475)) TerminalType=ConstantVoltage Net=DCP
  CapPb_3: Source Faces=P12_DCP_L1.face(at (13.45, 2.15, -1.475), at (16.65, 2.15, -1.475), at (15.05, 2.15, -1.475), at (18.25, 2.15, -1.475)) TerminalType=ConstantVoltage Net=DCP
  CapPb_4: Source Faces=P12_DCP_L1.face(at (34.05, 2.15, -1.475), at (30.85, 2.15, -1.475), at (29.25, 2.15, -1.475), at (32.45, 2.15, -1.475)) TerminalType=ConstantVoltage Net=DCP
  QH_D_1: Source Faces=P12_DCP_L1.face(at (-31.975, 4.9, 0.275), at (-33.675, 4.9, 0.275), at (-35.602, 4.9, 0.275)) TerminalType=ConstantVoltage Net=DCP
  QH_D_2: Source Faces=P12_DCP_L1.face(at (-15.525, 4.9, 0.275), at (-13.825, 4.9, 0.275), at (-11.898, 4.9, 0.275)) TerminalType=ConstantVoltage Net=DCP
  QH_D_3: Source Faces=P12_DCP_L1.face(at (15.525, 4.9, 0.275), at (13.825, 4.9, 0.275), at (11.898, 4.9, 0.275)) TerminalType=ConstantVoltage Net=DCP
  QH_D_4: Source Faces=P12_DCP_L1.face(at (31.975, 4.9, 0.275), at (33.675, 4.9, 0.275), at (35.602, 4.9, 0.275)) TerminalType=ConstantVoltage Net=DCP
  QH_S_1: Source Faces=P32_AC_L1.face(at (-32.825, 4.9, 0.275), at (-34.525, 4.9, 0.275)) TerminalType=ConstantVoltage Net=AC
  QH_S_2: Source Faces=P32_AC_L1.face(at (-14.675, 4.9, 0.275), at (-12.975, 4.9, 0.275)) TerminalType=ConstantVoltage Net=AC
  QH_S_3: Source Faces=P32_AC_L1.face(at (14.675, 4.9, 0.275), at (12.975, 4.9, 0.275)) TerminalType=ConstantVoltage Net=AC
  QH_S_4: Source Faces=P32_AC_L1.face(at (32.825, 4.9, 0.275), at (34.525, 4.9, 0.275)) TerminalType=ConstantVoltage Net=AC
  QL_D_1: Source Faces=P32_AC_L1.face(at (-31.975, 9.2, 0.275), at (-33.675, 9.2, 0.275), at (-35.602, 9.2, 0.275)) TerminalType=ConstantVoltage Net=AC
  QL_D_2: Source Faces=P32_AC_L1.face(at (-15.525, 9.2, 0.275), at (-13.825, 9.2, 0.275), at (-11.898, 9.2, 0.275)) TerminalType=ConstantVoltage Net=AC
  QL_D_3: Source Faces=P32_AC_L1.face(at (15.525, 9.2, 0.275), at (13.825, 9.2, 0.275), at (11.898, 9.2, 0.275)) TerminalType=ConstantVoltage Net=AC
  QL_D_4: Source Faces=P32_AC_L1.face(at (31.975, 9.2, 0.275), at (33.675, 9.2, 0.275), at (35.602, 9.2, 0.275)) TerminalType=ConstantVoltage Net=AC
  QL_S_1: Source Faces=P24_LSRC1_L1.face(at (-32.825, 9.2, 0.275), at (-34.525, 9.2, 0.275)) TerminalType=ConstantVoltage Net=LSRC1
  QL_S_2: Source Faces=P26_LSRC2_L1.face(at (-14.675, 9.2, 0.275), at (-12.975, 9.2, 0.275)) TerminalType=ConstantVoltage Net=LSRC2
  QL_S_3: Source Faces=P28_LSRC3_L1.face(at (14.675, 9.2, 0.275), at (12.975, 9.2, 0.275)) TerminalType=ConstantVoltage Net=LSRC3
  QL_S_4: Source Faces=P30_LSRC4_L1.face(at (32.825, 9.2, 0.275), at (34.525, 9.2, 0.275)) TerminalType=ConstantVoltage Net=LSRC4
  RSN_1: Source Faces=P0_DCN_L1.face(at (-36.15, 14.4, 0.275)) TerminalType=ConstantVoltage Net=DCN
  RSN_2: Source Faces=P0_DCN_L1.face(at (-11.35, 14.4, 0.275)) TerminalType=ConstantVoltage Net=DCN
  RSN_3: Source Faces=P0_DCN_L1.face(at (11.35, 14.4, 0.275)) TerminalType=ConstantVoltage Net=DCN
  RSN_4: Source Faces=P0_DCN_L1.face(at (36.15, 14.4, 0.275)) TerminalType=ConstantVoltage Net=DCN
  J_AC: Sink Faces=P32_AC_L1.face(at (0, 47.2, -1.475)) TerminalType=ConstantVoltage Net=AC
  J_DCN: Sink Faces=P0_DCN_L1.face(at (6, -18.8, -1.475)) TerminalType=ConstantVoltage Net=DCN
  J_DCP: Sink Faces=P12_DCP_L1.face(at (-6, -18.8, -1.475)) TerminalType=ConstantVoltage Net=DCP
  RSI_1: Sink Faces=P24_LSRC1_L1.face(at (-36.15, 11.8, 0.275)) TerminalType=ConstantVoltage Net=LSRC1
  RSI_2: Sink Faces=P26_LSRC2_L1.face(at (-11.35, 11.8, 0.275)) TerminalType=ConstantVoltage Net=LSRC2
  RSI_3: Sink Faces=P28_LSRC3_L1.face(at (11.35, 11.8, 0.275)) TerminalType=ConstantVoltage Net=LSRC3
  RSI_4: Sink Faces=P30_LSRC4_L1.face(at (36.15, 11.8, 0.275)) TerminalType=ConstantVoltage Net=LSRC4
setups:
  Setup1: Matrix AdaptiveFreq=100MHz Cap{MaxPass=1 MinPass=1 MinConvPass=1 PerError=30 PerRefine=30 AutoIncreaseAccuracy AccuracyLevel=High Solver_Type=Iterative} DC{SolveResOnly Cond{MaxPass=10 MinPass=1 MinConvPass=1 PerError=2 PerRefine=30} Mult{MaxPass=1 MinPass=1 MinConvPass=1 PerError=1 PerRefine=30} AccuracyLevel=Normal} ErrorValue=0.1
source amplitudes:
  AC:QH_S_1..AC:QH_S_4, AC:QL_D_1..AC:QL_D_4, DCN:BankN_2, DCN:BankN_3, DCN:BankN_4, DCN:BankN_C, DCN:CapN_1..DCN:CapN_4, DCN:CapNb_1..DCN:CapNb_4, DCN:RSN_1..DCN:RSN_4, DCP:BankP_1..DCP:BankP_4, DCP:BankP_C, DCP:CapP_1..DCP:CapP_4, DCP:CapPb_1..DCP:CapPb_4, DCP:QH_D_1..DCP:QH_D_4, LSRC1:QL_S_1, LSRC2:QL_S_2, LSRC3:QL_S_3, LSRC4:QL_S_4: AC R/L Fields 0A
  DCN:BankN_1: AC R/L Fields 1A
  AC: CG Fields 1V 0deg
  DCN, DCP, LSRC1..LSRC4: CG Fields 0V 0deg
  AC:QH_S_1..AC:QH_S_4, AC:QL_D_1..AC:QL_D_4, DCN:BankN_2, DCN:BankN_3, DCN:BankN_4, DCN:BankN_C, DCN:CapN_1..DCN:CapN_4, DCN:CapNb_1..DCN:CapNb_4, DCN:RSN_1..DCN:RSN_4, DCP:BankP_1..DCP:BankP_4, DCP:BankP_C, DCP:CapP_1..DCP:CapP_4, DCP:CapPb_1..DCP:CapPb_4, DCP:QH_D_1..DCP:QH_D_4, LSRC1:QL_S_1, LSRC2:QL_S_2, LSRC3:QL_S_3, LSRC4:QL_S_4: DC R/L Fields 0A
  DCN:BankN_1: DC R/L Fields 1A
