# Ansys Electronics Desktop project, version 2024.2
materials:
  vacuum: permittivity=1
  copper: permeability=0.999991 conductivity=58000000

design BB_PL_LOOP_dpt_swv1 (Q3D Extractor, model units mm)
options: SParamCalcMethod=EqTransLine Calculate_Lossy_Dielectrics
geometry:
  P0_DCN_L1 [copper] = polyline(z=0.17mm, xy in mm: (-28.6908, 12.9189) (-28.6689, 16.7592) (-34.5, 16.8) (-34.5, 20.101) (-34.5684, 20.1952) (-43.551, 20.2) (-43.6452, 20.1316) (-43.65, 12.999) (-43.5816, 12.9048) (-28.749, 12.9) (-28.6908, 12.9189), closed, covered)
  P0_DCN_L1.sweep_along_vector((0mm, 0mm, 0.07mm))
  P1_DCN_L1 = polyline(z=0.17mm, xy in mm: (-3.8908, 12.9189) (-3.85, 20.101) (-3.9184, 20.1952) (-12.901, 20.2) (-13, 20.101) (-13, 16.8) (-18.751, 16.8) (-18.8452, 16.7316) (-18.85, 12.999) (-18.7816, 12.9048) (-3.949, 12.9) (-3.8908, 12.9189), closed, covered)
  P1_DCN_L1.sweep_along_vector((0mm, 0mm, 0.07mm))
  P2_DCN_L1 = polyline(z=0.17mm, xy in mm: (18.8092, 12.9189) (18.8311, 16.7592) (13, 16.8) (13, 20.101) (12.9316, 20.1952) (3.949, 20.2) (3.8548, 20.1316) (3.85, 12.999) (3.9184, 12.9048) (18.751, 12.9) (18.8092, 12.9189), closed, covered)
  P2_DCN_L1.sweep_along_vector((0mm, 0mm, 0.07mm))
  P3_DCN_L1 = polyline(z=0.17mm, xy in mm: (43.6092, 12.9189) (43.65, 20.101) (43.5816, 20.1952) (34.599, 20.2) (34.5, 20.101) (34.5, 16.8) (28.749, 16.8) (28.6548, 16.7316) (28.65, 12.999) (28.7184, 12.9048) (43.551, 12.9) (43.6092, 12.9189), closed, covered)
  P3_DCN_L1.sweep_along_vector((0mm, 0mm, 0.07mm))
  P4_DCN_L1 = polyline(z=0.17mm, xy in mm: (39.7092, -4.1811) (39.75, 0.801) (39.651, 0.9) (-39.651, 0.9) (-39.75, 0.801) (-39.75, -4.101) (-39.651, -4.2) (39.651, -4.2) (39.7092, -4.1811), closed, covered)
  P4_DCN_L1.sweep_along_vector((0mm, 0mm, 0.07mm))
  P5_DCN_L2 = polyline(z=0mm, xy in mm: (39.75, 11.9) (43.926, 11.9) (44.0388, 11.9725) (44.0303, 20.543) (43.926, 20.6) (33.557, 20.5748) (33.5, 20.4705) (33.5, 17.6) (28.774, 17.6) (28.6612, 17.5275) (28.65, 11.9) (28.407, 11.8803) (28.35, 11.776) (28.35, 10) (27.3652, 10) (27.1357, 9.9318) (27.0508, 9.828) (27.05, 3.3) (22.3031, 3.3) (21.95, 3.1692) (21.5969, 3.3) (20.45, 3.3) (20.45, 7.5883) (20.3084, 7.711) (19.8831, 7.4903) (19.6169, 7.4903) (19.4015, 7.6468) (19.3192, 7.9) (19.4968, 8.2485) (20.422, 8.5076) (20.45, 9.876) (20.326, 10) (19.15, 10) (19.15, 11.776) (19.0775, 11.8888) (18.85, 11.9) (18.8303, 17.543) (18.726, 17.6) (14, 17.6) (14, 20.4705) (13.9275, 20.5833) (-13.876, 20.5945) (-14, 20.4705) (-14, 17.6) (-18.726, 17.6) (-18.8388, 17.5275) (-18.85, 11.9) (-19.093, 11.8803) (-19.15, 11.776) (-19.15, 10) (-20.1348, 10) (-20.3643, 9.9318) (-20.4492, 9.828) (-20.45, 3.3) (-25.1969, 3.3) (-25.55, 3.1692) (-25.9031, 3.3) (-27.05, 3.3) (-27.05, 7.5883) (-27.1916, 7.711) (-27.6169, 7.4903) (-27.8831, 7.4903) (-28.0985, 7.6468) (-28.1808, 7.9) (-28.0032, 8.2485) (-27.078, 8.5076) (-27.05, 9.876) (-27.174, 10) (-28.35, 10) (-28.35, 11.776) (-28.4225, 11.8888) (-28.65, 11.9) (-28.6697, 17.543) (-28.774, 17.6) (-33.5, 17.6) (-33.5, 20.4705) (-33.624, 20.5945) (-37.8493, 20.6) (-38.19, 20.5444) (-38.5307, 20.6) (-43.926, 20.6) (-44.05, 20.476) (-44.0303, 11.957) (-43.926, 11.9) (-39.75, 11.9) (-39.75, -4.6) (39.75, -4.6) (39.75, 11.9), closed, covered)
  P5_DCN_L2_h0 = polyline(z=0mm, xy in mm: (-37.3503, 11.4144) (-37.6106, 11.6747) (-37.6106, 11.9253) (-37.4633, 12.1281) (-37.0997, 12.1856) (-36.897, 12.0383) (-36.8195, 11.8) (-36.897, 11.5617) (-37.225, 11.3945) (-37.3503, 11.4144), closed, covered)
  P5_DCN_L2_h1 = polyline(z=0mm, xy in mm: (-10.4003, 11.4144) (-10.6606, 11.6747) (-10.6606, 11.9253) (-10.5133, 12.1281) (-10.1497, 12.1856) (-9.9469, 12.0383) (-9.8695, 11.8) (-9.9469, 11.5617) (-10.275, 11.3945) (-10.4003, 11.4144), closed, covered)
  P5_DCN_L2_h2 = polyline(z=0mm, xy in mm: (10.1497, 11.4144) (9.8894, 11.6747) (9.8894, 11.9253) (10.0367, 12.1281) (10.4003, 12.1856) (10.603, 12.0383) (10.6805, 11.8) (10.603, 11.5617) (10.275, 11.3945) (10.1497, 11.4144), closed, covered)
  P5_DCN_L2_h3 = polyline(z=0mm, xy in mm: (37.0997, 11.4144) (36.8394, 11.6747) (36.8394, 11.9253) (36.9867, 12.1281) (37.3503, 12.1856) (37.5531, 12.0383) (37.6305, 11.8) (37.5531, 11.5617) (37.225, 11.3945) (37.0997, 11.4144), closed, covered)
  P5_DCN_L2_h4 = polyline(z=0mm, xy in mm: (-17.5375, 10.3334) (-17.7276, 10.4715) (-17.7816, 10.8125) (-17.6435, 11.0026) (-17.3025, 11.0566) (-17.1124, 10.9185) (-17.0584, 10.5775) (-17.1965, 10.3874) (-17.42, 10.3148) (-17.5375, 10.3334), closed, covered)
  P5_DCN_L2_h5 = polyline(z=0mm, xy in mm: (29.9625, 10.3334) (29.7724, 10.4715) (29.7184, 10.8125) (29.8565, 11.0026) (30.1975, 11.0566) (30.3876, 10.9185) (30.4416, 10.5775) (30.3035, 10.3874) (30.08, 10.3148) (29.9625, 10.3334), closed, covered)
  P5_DCN_L2_h6 = polyline(z=0mm, xy in mm: (-30.1975, 10.0684) (-30.3876, 10.2065) (-30.4416, 10.5475) (-30.3035, 10.7376) (-29.9625, 10.7916) (-29.7724, 10.6535) (-29.7184, 10.3125) (-29.8565, 10.1224) (-30.08, 10.0498) (-30.1975, 10.0684), closed, covered)
  P5_DCN_L2_h7 = polyline(z=0mm, xy in mm: (17.3025, 10.0684) (17.1124, 10.2065) (17.0584, 10.5475) (17.1965, 10.7376) (17.5375, 10.7916) (17.7276, 10.6535) (17.7816, 10.3125) (17.6435, 10.1224) (17.42, 10.0498) (17.3025, 10.0684), closed, covered)
  P5_DCN_L2_h8 = polyline(z=0mm, xy in mm: (-5.4753, 5.4144) (-5.6781, 5.5617) (-5.7555, 5.8) (-5.5956, 6.1486) (-5.7555, 6.55) (-5.5956, 6.8986) (-5.7555, 7.3) (-5.5956, 7.6486) (-5.7555, 8.05) (-5.5956, 8.3986) (-5.7555, 8.8) (-5.5956, 9.1486) (-5.7555, 9.55) (-5.5956, 9.8986) (-5.7356, 10.1747) (-5.7356, 10.4253) (-5.5883, 10.6281) (-5.35, 10.7055) (-5.1117, 10.6281) (-4.8447, 10.3501) (-4.5883, 10.6281) (-4.2247, 10.6856) (-4.022, 10.5383) (-3.9445, 10.3) (-4.1044, 9.9514) (-3.9445, 9.55) (-4.1044, 9.2014) (-3.9445, 8.8) (-4.1044, 8.4514) (-3.9445, 8.05) (-4.1044, 7.7014) (-3.9445, 7.3) (-4.1044, 6.9514) (-3.9445, 6.55) (-4.1044, 6.2014) (-3.9644, 5.9253) (-3.9644, 5.6747) (-4.1117, 5.472) (-4.35, 5.3945) (-4.5883, 5.472) (-4.8553, 5.7499) (-5.1117, 5.472) (-5.35, 5.3945) (-5.4753, 5.4144), closed, covered)
  P5_DCN_L2_h9 = polyline(z=0mm, xy in mm: (4.2247, 5.4144) (4.022, 5.5617) (3.9445, 5.8) (4.1044, 6.1486) (3.9445, 6.55) (4.1044, 6.8986) (3.9445, 7.3) (4.1044, 7.6486) (3.9445, 8.05) (4.1044, 8.3986) (3.9445, 8.8) (4.1044, 9.1486) (3.9445, 9.55) (4.1044, 9.8986) (3.9644, 10.1747) (3.9644, 10.4253) (4.1117, 10.6281) (4.35, 10.7055) (4.5883, 10.6281) (4.8553, 10.3501) (5.1117, 10.6281) (5.4753, 10.6856) (5.6781, 10.5383) (5.7555, 10.3) (5.5956, 9.9514) (5.7555, 9.55) (5.5956, 9.2014) (5.7555, 8.8) (5.5956, 8.4514) (5.7555, 8.05) (5.5956, 7.7014) (5.7555, 7.3) (5.5956, 6.9514) (5.7555, 6.55) (5.5956, 6.2014) (5.7356, 5.9253) (5.7356, 5.6747) (5.5883, 5.472) (5.35, 5.3945) (5.1117, 5.472) (4.8447, 5.7499) (4.5883, 5.472) (4.35, 5.3945) (4.2247, 5.4144), closed, covered)
  P5_DCN_L2_h10 = polyline(z=0mm, xy in mm: (-17.5375, 7.6084) (-17.7276, 7.7465) (-17.7816, 8.0875) (-17.6435, 8.2776) (-17.3025, 8.3316) (-17.1124, 8.1935) (-17.0584, 7.8525) (-17.1965, 7.6624) (-17.42, 7.5898) (-17.5375, 7.6084), closed, covered)
  P5_DCN_L2_h11 = polyline(z=0mm, xy in mm: (29.9625, 7.6084) (29.7724, 7.7465) (29.7184, 8.0875) (29.8565, 8.2776) (30.1975, 8.3316) (30.3876, 8.1935) (30.4416, 7.8525) (30.3035, 7.6624) (30.08, 7.5898) (29.9625, 7.6084), closed, covered)
  P5_DCN_L2_h12 = polyline(z=0mm, xy in mm: (-30.1975, 7.3434) (-30.3876, 7.4815) (-30.4416, 7.8225) (-30.3035, 8.0126) (-29.9625, 8.0666) (-29.7724, 7.9285) (-29.7184, 7.5875) (-29.8565, 7.3974) (-30.08, 7.3248) (-30.1975, 7.3434), closed, covered)
  P5_DCN_L2_h13 = polyline(z=0mm, xy in mm: (17.3025, 7.3434) (17.1124, 7.4815) (17.0584, 7.8225) (17.1965, 8.0126) (17.5375, 8.0666) (17.7276, 7.9285) (17.7816, 7.5875) (17.6435, 7.3974) (17.42, 7.3248) (17.3025, 7.3434), closed, covered)
  P5_DCN_L2_h14 = polyline(z=0mm, xy in mm: (-29.3253, 6.6644) (-29.5856, 6.9247) (-29.5856, 7.1753) (-29.4383, 7.3781) (-29.0747, 7.4356) (-28.8719, 7.2883) (-28.7945, 7.05) (-28.8719, 6.8117) (-29.2, 6.6445) (-29.3253, 6.6644), closed, covered)
  P5_DCN_L2_h15 = polyline(z=0mm, xy in mm: (-18.4253, 6.6644) (-18.6856, 6.9247) (-18.6856, 7.1753) (-18.5383, 7.3781) (-18.1747, 7.4356) (-17.9719, 7.2883) (-17.8945, 7.05) (-17.9719, 6.8117) (-18.3, 6.6445) (-18.4253, 6.6644), closed, covered)
  P5_DCN_L2_h16 = polyline(z=0mm, xy in mm: (18.1747, 6.6644) (17.9144, 6.9247) (17.9144, 7.1753) (18.0617, 7.3781) (18.4253, 7.4356) (18.6281, 7.2883) (18.7055, 7.05) (18.6281, 6.8117) (18.3, 6.6445) (18.1747, 6.6644), closed, covered)
  P5_DCN_L2_h17 = polyline(z=0mm, xy in mm: (29.0747, 6.6644) (28.8144, 6.9247) (28.8144, 7.1753) (28.9617, 7.3781) (29.3253, 7.4356) (29.5281, 7.2883) (29.6055, 7.05) (29.5281, 6.8117) (29.2, 6.6445) (29.0747, 6.6644), closed, covered)
  P5_DCN_L2_h18 = polyline(z=0mm, xy in mm: (-17.5375, 6.0334) (-17.7276, 6.1715) (-17.7816, 6.5125) (-17.6435, 6.7026) (-17.3025, 6.7566) (-17.1124, 6.6185) (-17.0584, 6.2775) (-17.1965, 6.0874) (-17.42, 6.0148) (-17.5375, 6.0334), closed, covered)
  P5_DCN_L2_h19 = polyline(z=0mm, xy in mm: (29.9625, 6.0334) (29.7724, 6.1715) (29.7184, 6.5125) (29.8565, 6.7026) (30.1975, 6.7566) (30.3876, 6.6185) (30.4416, 6.2775) (30.3035, 6.0874) (30.08, 6.0148) (29.9625, 6.0334), closed, covered)
  P5_DCN_L2_h20 = polyline(z=0mm, xy in mm: (-30.1975, 5.7684) (-30.3876, 5.9065) (-30.4416, 6.2475) (-30.3035, 6.4376) (-29.9625, 6.4916) (-29.7724, 6.3535) (-29.7184, 6.0125) (-29.8565, 5.8224) (-30.08, 5.7498) (-30.1975, 5.7684), closed, covered)
  P5_DCN_L2_h21 = polyline(z=0mm, xy in mm: (17.3025, 5.7684) (17.1124, 5.9065) (17.0584, 6.2475) (17.1965, 6.4376) (17.5375, 6.4916) (17.7276, 6.3535) (17.7816, 6.0125) (17.6435, 5.8224) (17.42, 5.7498) (17.3025, 5.7684), closed, covered)
  P5_DCN_L2_h22 = polyline(z=0mm, xy in mm: (-17.5375, 3.3084) (-17.7276, 3.4465) (-17.7816, 3.7875) (-17.6435, 3.9776) (-17.3025, 4.0316) (-17.1124, 3.8935) (-17.0584, 3.5525) (-17.1965, 3.3624) (-17.42, 3.2898) (-17.5375, 3.3084), closed, covered)
  P5_DCN_L2_h23 = polyline(z=0mm, xy in mm: (29.9625, 3.3084) (29.7724, 3.4465) (29.7184, 3.7875) (29.8565, 3.9776) (30.1975, 4.0316) (30.3876, 3.8935) (30.4416, 3.5525) (30.3035, 3.3624) (30.08, 3.2898) (29.9625, 3.3084), closed, covered)
  P5_DCN_L2_h24 = polyline(z=0mm, xy in mm: (-35.6253, 2.1144) (-35.8281, 2.2617) (-35.9055, 2.5) (-35.8281, 2.7383) (-35.5, 2.9055) (-35.0447, 2.6482) (-34.8383, 2.8281) (-34.6, 2.9055) (-34.1447, 2.6482) (-33.9383, 2.8281) (-33.7, 2.9055) (-33.2447, 2.6482) (-33.0383, 2.8281) (-32.8, 2.9055) (-32.3447, 2.6482) (-32.1383, 2.8281) (-31.9, 2.9055) (-31.4447, 2.6482) (-31.1253, 2.8856) (-30.8747, 2.8856) (-30.5447, 2.6482) (-30.2058, 2.9769) (-30.4416, 3.2875) (-30.4416, 3.5225) (-30.3035, 3.7126) (-30.08, 3.7852) (-29.8565, 3.7126) (-29.6998, 3.405) (-29.7724, 3.1815) (-29.9574, 3.0239) (-29.9517, 2.89) (-29.6447, 2.6482) (-29.3253, 2.8856) (-29.0747, 2.8856) (-28.8719, 2.7383) (-28.7945, 2.5) (-28.8719, 2.2617) (-29.2, 2.0945) (-29.6553, 2.3518) (-29.8617, 2.1719) (-30.1, 2.0945) (-30.5553, 2.3518) (-30.7617, 2.1719) (-31, 2.0945) (-31.4553, 2.3518) (-31.6617, 2.1719) (-31.9, 2.0945) (-32.3553, 2.3517) (-32.6747, 2.1144) (-32.9253, 2.1144) (-33.2553, 2.3518) (-33.4617, 2.1719) (-33.7, 2.0945) (-34.1553, 2.3518) (-34.4747, 2.1144) (-34.7253, 2.1144) (-35.0553, 2.3518) (-35.2617, 2.1719) (-35.5, 2.0945) (-35.6253, 2.1144), closed, covered)
  P5_DCN_L2_h25 = polyline(z=0mm, xy in mm: (11.8747, 2.1144) (11.672, 2.2617) (11.5945, 2.5) (11.7617, 2.8281) (12, 2.9055) (12.4553, 2.6482) (12.6617, 2.8281) (12.9, 2.9055) (13.3553, 2.6482) (13.5617, 2.8281) (13.8, 2.9055) (14.2553, 2.6482) (14.4617, 2.8281) (14.7, 2.9055) (15.1553, 2.6482) (15.3617, 2.8281) (15.6, 2.9055) (16.0553, 2.6482) (16.3747, 2.8856) (16.6253, 2.8856) (16.9553, 2.6482) (17.2942, 2.9769) (17.0584, 3.2875) (17.0584, 3.5225) (17.1965, 3.7126) (17.42, 3.7852) (17.6435, 3.7126) (17.8002, 3.405) (17.7276, 3.1815) (17.5426, 3.0239) (17.5483, 2.89) (17.8553, 2.6482) (18.1747, 2.8856) (18.4253, 2.8856) (18.6281, 2.7383) (18.7055, 2.5) (18.6281, 2.2617) (18.3, 2.0945) (17.8447, 2.3518) (17.6383, 2.1719) (17.4, 2.0945) (16.9447, 2.3518) (16.7383, 2.1719) (16.5, 2.0945) (16.0447, 2.3518) (15.8383, 2.1719) (15.6, 2.0945) (15.1447, 2.3518) (14.9383, 2.1719) (14.7, 2.0945) (14.2447, 2.3518) (14.0383, 2.1719) (13.8, 2.0945) (13.3447, 2.3518) (13.0253, 2.1144) (12.7747, 2.1144) (12.4447, 2.3518) (12.2383, 2.1719) (12, 2.0945) (11.8747, 2.1144), closed, covered)
  P5_DCN_L2_h26 = polyline(z=0mm, xy in mm: (-18.4253, 2.1144) (-18.6281, 2.2617) (-18.7055, 2.5) (-18.6281, 2.7383) (-18.3, 2.9055) (-17.8447, 2.6482) (-17.6383, 2.8281) (-17.4, 2.9055) (-16.9447, 2.6482) (-16.7383, 2.8281) (-16.5, 2.9055) (-16.0447, 2.6482) (-15.8383, 2.8281) (-15.6, 2.9055) (-15.1447, 2.6482) (-14.9383, 2.8281) (-14.7, 2.9055) (-14.2447, 2.6482) (-14.0383, 2.8281) (-13.8, 2.9055) (-13.3447, 2.6482) (-13.0253, 2.8856) (-12.7747, 2.8856) (-12.4447, 2.6482) (-12.2383, 2.8281) (-12, 2.9055) (-11.7617, 2.8281) (-11.5945, 2.5) (-11.7617, 2.1719) (-12, 2.0945) (-12.4553, 2.3517) (-12.7747, 2.1144) (-13.0253, 2.1144) (-13.3553, 2.3518) (-13.5617, 2.1719) (-13.8, 2.0945) (-14.2553, 2.3518) (-14.4617, 2.1719) (-14.7, 2.0945) (-15.1553, 2.3518) (-15.3617, 2.1719) (-15.6, 2.0945) (-16.0553, 2.3518) (-16.2617, 2.1719) (-16.5, 2.0945) (-16.9553, 2.3518) (-17.2747, 2.1144) (-17.5253, 2.1144) (-17.8553, 2.3518) (-18.0617, 2.1719) (-18.3, 2.0945) (-18.4253, 2.1144), closed, covered)
  P5_DCN_L2_h27 = polyline(z=0mm, xy in mm: (29.0747, 2.1144) (28.8719, 2.2617) (28.7945, 2.5) (28.8719, 2.7383) (29.2, 2.9055) (29.6553, 2.6482) (29.8617, 2.8281) (30.1, 2.9055) (30.5553, 2.6482) (30.7617, 2.8281) (31, 2.9055) (31.4553, 2.6482) (31.6617, 2.8281) (31.9, 2.9055) (32.3553, 2.6482) (32.5617, 2.8281) (32.8, 2.9055) (33.2553, 2.6482) (33.4617, 2.8281) (33.7, 2.9055) (34.1553, 2.6482) (34.4747, 2.8856) (34.7253, 2.8856) (35.0553, 2.6482) (35.2617, 2.8281) (35.5, 2.9055) (35.7383, 2.8281) (35.9055, 2.5) (35.7383, 2.1719) (35.5, 2.0945) (35.0447, 2.3518) (34.8383, 2.1719) (34.6, 2.0945) (34.1447, 2.3518) (33.9383, 2.1719) (33.7, 2.0945) (33.2447, 2.3518) (33.0383, 2.1719) (32.8, 2.0945) (32.3447, 2.3517) (32.0253, 2.1144) (31.7747, 2.1144) (31.4447, 2.3518) (31.2383, 2.1719) (31, 2.0945) (30.5447, 2.3518) (30.2253, 2.1144) (29.9747, 2.1144) (29.6447, 2.3518) (29.4383, 2.1719) (29.2, 2.0945) (29.0747, 2.1144), closed, covered)
  P5_DCN_L2.subtract(P5_DCN_L2_h0..P5_DCN_L2_h27)
  P5_DCN_L2.sweep_along_vector((0mm, 0mm, 0.07mm))
  P6_DCN_L4 = polyline(z=-1.44mm, xy in mm: (-28.4908, -1.1811) (-28.45, 0.851) (-28.5184, 0.9452) (-37.951, 0.95) (-38.0452, 0.8816) (-38.05, -1.101) (-37.9816, -1.1952) (-28.549, -1.2) (-28.4908, -1.1811), closed, covered)
  P6_DCN_L4.sweep_along_vector((0mm, 0mm, 0.07mm))
  P7_DCN_L4 = polyline(z=-1.44mm, xy in mm: (-9.4908, -1.1811) (-9.45, 0.851) (-9.5184, 0.9452) (-18.951, 0.95) (-19.0452, 0.8816) (-19.05, -1.101) (-18.9816, -1.1952) (-9.549, -1.2) (-9.4908, -1.1811), closed, covered)
  P7_DCN_L4.sweep_along_vector((0mm, 0mm, 0.07mm))
  P8_DCN_L4 = polyline(z=-1.44mm, xy in mm: (19.0092, -1.1811) (19.05, 0.851) (18.9816, 0.9452) (9.549, 0.95) (9.4548, 0.8816) (9.45, -1.101) (9.5184, -1.1952) (18.951, -1.2) (19.0092, -1.1811), closed, covered)
  P8_DCN_L4.sweep_along_vector((0mm, 0mm, 0.07mm))
  P9_DCN_L4 = polyline(z=-1.44mm, xy in mm: (38.0092, -1.1811) (38.05, 0.851) (37.9816, 0.9452) (28.549, 0.95) (28.4548, 0.8816) (28.45, -1.101) (28.5184, -1.1952) (37.951, -1.2) (38.0092, -1.1811), closed, covered)
  P9_DCN_L4.sweep_along_vector((0mm, 0mm, 0.07mm))
  P10_DCP_L1 [copper] = polyline(z=0.17mm, xy in mm: (-28.7908, 1.5189) (-28.7689, 3.2087) (-29.621, 3.2495) (-29.9469, 2.9953) (-30.4106, 2.8995) (-31.5175, 2.9494) (-31.6465, 3.1377) (-31.6495, 4.501) (-31.7179, 4.5952) (-32.2005, 4.6) (-32.2947, 4.5316) (-32.2995, 3.1388) (-32.3736, 2.9736) (-32.5389, 2.8995) (-33.1886, 2.9149) (-33.3351, 3.0614) (-33.3505, 4.501) (-33.4189, 4.5952) (-33.9005, 4.6) (-33.9947, 4.5316) (-33.9995, 3.1388) (-34.0736, 2.9736) (-34.2389, 2.8995) (-34.8886, 2.9149) (-35.0351, 3.0614) (-35.0505, 4.501) (-35.1189, 4.5952) (-37.7092, 4.5811) (-37.75, 2.8602) (-39.2322, 4.6759) (-39.4259, 4.5178) (-37.75, 2.4648) (-37.75, 1.599) (-37.6816, 1.5048) (-28.849, 1.5) (-28.7908, 1.5189), closed, covered)
  P10_DCP_L1.sweep_along_vector((0mm, 0mm, 0.07mm))
  P11_DCP_L1 = polyline(z=0.17mm, xy in mm: (-9.7908, 1.5189) (-9.75, 2.4648) (-8.0741, 4.5178) (-8.2678, 4.6759) (-9.75, 2.8602) (-9.75, 4.501) (-9.8184, 4.5952) (-12.4087, 4.5811) (-12.4495, 3.1388) (-12.5236, 2.9736) (-12.6889, 2.8995) (-13.2612, 2.8995) (-13.4264, 2.9736) (-13.5005, 3.1389) (-13.5194, 4.5592) (-14.1087, 4.5811) (-14.1649, 3.0614) (-14.3114, 2.9149) (-14.9612, 2.8995) (-15.1264, 2.9736) (-15.2005, 3.1389) (-15.2194, 4.5592) (-15.7515, 4.6) (-15.8966, 4.38) (-15.8505, 3.1636) (-15.9825, 2.9494) (-17.0894, 2.8995) (-17.3427, 3.0439) (-17.7478, 2.8659) (-18.6827, 2.8868) (-18.75, 2.793) (-18.75, 1.599) (-18.651, 1.5) (-9.849, 1.5) (-9.7908, 1.5189), closed, covered)
  P11_DCP_L1.sweep_along_vector((0mm, 0mm, 0.07mm))
  P12_DCP_L1 = polyline(z=0.17mm, xy in mm: (18.7092, 1.5189) (18.7311, 3.2087) (17.879, 3.2495) (17.5531, 2.9953) (17.0894, 2.8995) (15.9825, 2.9494) (15.8535, 3.1377) (15.8505, 4.501) (15.7821, 4.5952) (15.2995, 4.6) (15.2053, 4.5316) (15.2005, 3.1388) (15.1264, 2.9736) (14.9611, 2.8995) (14.3114, 2.9149) (14.1649, 3.0614) (14.1495, 4.501) (14.0811, 4.5952) (13.5995, 4.6) (13.5053, 4.5316) (13.5005, 3.1388) (13.4264, 2.9736) (13.2611, 2.8995) (12.6114, 2.9149) (12.4649, 3.0614) (12.4495, 4.501) (12.3811, 4.5952) (9.7908, 4.5811) (9.75, 2.8602) (8.2678, 4.6759) (8.0741, 4.5178) (9.75, 2.4648) (9.75, 1.599) (9.8184, 1.5048) (18.651, 1.5) (18.7092, 1.5189), closed, covered)
  P12_DCP_L1.sweep_along_vector((0mm, 0mm, 0.07mm))
  P13_DCP_L1 = polyline(z=0.17mm, xy in mm: (37.7092, 1.5189) (37.75, 2.4648) (39.4259, 4.5178) (39.2322, 4.6759) (37.75, 2.8602) (37.75, 4.501) (37.6816, 4.5952) (35.0913, 4.5811) (35.0505, 3.1388) (34.9764, 2.9736) (34.8111, 2.8995) (34.2388, 2.8995) (34.0736, 2.9736) (33.9995, 3.1389) (33.9806, 4.5592) (33.3913, 4.5811) (33.3351, 3.0614) (33.1886, 2.9149) (32.5388, 2.8995) (32.3736, 2.9736) (32.2995, 3.1389) (32.2806, 4.5592) (31.7485, 4.6) (31.6034, 4.38) (31.6495, 3.1636) (31.5175, 2.9494) (30.4106, 2.8995) (30.1573, 3.0439) (29.7522, 2.8659) (28.8173, 2.8868) (28.75, 2.793) (28.75, 1.599) (28.849, 1.5) (37.651, 1.5) (37.7092, 1.5189), closed, covered)
  P13_DCP_L1.sweep_along_vector((0mm, 0mm, 0.07mm))
  P14_DCP_L3 = polyline(z=-1.27mm, xy in mm: (39.75, -0.7211) (39.6084, -0.5984) (39.2753, -0.8856) (39.0247, -0.8856) (38.8219, -0.7383) (38.7445, -0.5) (38.8219, -0.2617) (39.0247, -0.1144) (39.2753, -0.1144) (39.6313, -0.4028) (39.75, -0.2789) (39.75, 4.476) (39.626, 4.6) (-39.626, 4.6) (-39.75, 4.476) (-39.75, -0.2789) (-39.6084, -0.4016) (-39.2753, -0.1144) (-39.0247, -0.1144) (-38.822, -0.2617) (-38.7445, -0.5) (-38.822, -0.7383) (-39.0247, -0.8856) (-39.2753, -0.8856) (-39.5635, -0.614) (-39.7409, -0.6745) (-39.75, -4.6) (39.75, -4.6) (39.75, -0.7211), closed, covered)
  P14_DCP_L3_h0 = polyline(z=-1.27mm, xy in mm: (-17.5375, 3.3084) (-17.7276, 3.4465) (-17.7816, 3.7875) (-17.6435, 3.9776) (-17.3025, 4.0316) (-17.1124, 3.8935) (-17.0584, 3.5525) (-17.1965, 3.3624) (-17.42, 3.2898) (-17.5375, 3.3084), closed, covered)
  P14_DCP_L3_h1 = polyline(z=-1.27mm, xy in mm: (29.9625, 3.3084) (29.7724, 3.4465) (29.7184, 3.7875) (29.8565, 3.9776) (30.1975, 4.0316) (30.3876, 3.8935) (30.4416, 3.5525) (30.3035, 3.3624) (30.08, 3.2898) (29.9625, 3.3084), closed, covered)
  P14_DCP_L3_h2 = polyline(z=-1.27mm, xy in mm: (-25.6675, 3.2384) (-25.8576, 3.3765) (-25.9116, 3.7175) (-25.7735, 3.9076) (-25.4325, 3.9616) (-25.2424, 3.8235) (-25.1884, 3.4825) (-25.3265, 3.2924) (-25.55, 3.2198) (-25.6675, 3.2384), closed, covered)
  P14_DCP_L3_h3 = polyline(z=-1.27mm, xy in mm: (21.8325, 3.2384) (21.6424, 3.3765) (21.5884, 3.7175) (21.7265, 3.9076) (22.0675, 3.9616) (22.2576, 3.8235) (22.3116, 3.4825) (22.1735, 3.2924) (21.95, 3.2198) (21.8325, 3.2384), closed, covered)
  P14_DCP_L3_h4 = polyline(z=-1.27mm, xy in mm: (-30.1975, 3.0434) (-30.3876, 3.1815) (-30.4416, 3.5225) (-30.3035, 3.7126) (-29.9625, 3.7666) (-29.7724, 3.6285) (-29.7184, 3.2875) (-29.8565, 3.0974) (-30.08, 3.0248) (-30.1975, 3.0434), closed, covered)
  P14_DCP_L3_h5 = polyline(z=-1.27mm, xy in mm: (17.3025, 3.0434) (17.1124, 3.1815) (17.0584, 3.5225) (17.1965, 3.7126) (17.5375, 3.7666) (17.7276, 3.6285) (17.7816, 3.2875) (17.6435, 3.0974) (17.42, 3.0248) (17.3025, 3.0434), closed, covered)
  P14_DCP_L3_h6 = polyline(z=-1.27mm, xy in mm: (-38.0907, -0.8856) (-38.3022, -0.7211) (-38.351, -0.3747) (-38.2037, -0.1719) (-37.8401, -0.1144) (-37.5797, -0.3747) (-37.5797, -0.6253) (-37.727, -0.8281) (-37.9654, -0.9055) (-38.0907, -0.8856), closed, covered)
  P14_DCP_L3_h7 = polyline(z=-1.27mm, xy in mm: (-36.9061, -0.8856) (-37.1176, -0.7211) (-37.1664, -0.3747) (-37.0191, -0.1719) (-36.6555, -0.1144) (-36.3951, -0.3747) (-36.3951, -0.6253) (-36.5424, -0.8281) (-36.7808, -0.9055) (-36.9061, -0.8856), closed, covered)
  P14_DCP_L3_h8 = polyline(z=-1.27mm, xy in mm: (-35.7215, -0.8856) (-35.933, -0.7211) (-35.9818, -0.3747) (-35.8345, -0.1719) (-35.4708, -0.1144) (-35.2105, -0.3747) (-35.2105, -0.6253) (-35.3578, -0.8281) (-35.5962, -0.9055) (-35.7215, -0.8856), closed, covered)
  P14_DCP_L3_h9 = polyline(z=-1.27mm, xy in mm: (-34.5368, -0.8856) (-34.7484, -0.7211) (-34.7972, -0.3747) (-34.6499, -0.1719) (-34.2862, -0.1144) (-34.0835, -0.2617) (-34.006, -0.5) (-34.1732, -0.8281) (-34.4115, -0.9055) (-34.5368, -0.8856), closed, covered)
  P14_DCP_L3_h10 = polyline(z=-1.27mm, xy in mm: (-33.3522, -0.8856) (-33.5638, -0.7211) (-33.6126, -0.3747) (-33.4653, -0.1719) (-33.1016, -0.1144) (-32.8989, -0.2617) (-32.8214, -0.5) (-32.9886, -0.8281) (-33.2269, -0.9055) (-33.3522, -0.8856), closed, covered)
  P14_DCP_L3_h11 = polyline(z=-1.27mm, xy in mm: (-32.1676, -0.8856) (-32.428, -0.6253) (-32.428, -0.3747) (-32.2806, -0.1719) (-31.917, -0.1144) (-31.7143, -0.2617) (-31.6368, -0.5) (-31.804, -0.8281) (-32.0423, -0.9055) (-32.1676, -0.8856), closed, covered)
  P14_DCP_L3_h12 = polyline(z=-1.27mm, xy in mm: (-30.983, -0.8856) (-31.1945, -0.7211) (-31.2433, -0.3747) (-31.096, -0.1719) (-30.7324, -0.1144) (-30.472, -0.3747) (-30.472, -0.6253) (-30.6193, -0.8281) (-30.8577, -0.9055) (-30.983, -0.8856), closed, covered)
  P14_DCP_L3_h13 = polyline(z=-1.27mm, xy in mm: (-29.7984, -0.8856) (-30.0099, -0.7211) (-30.0587, -0.3747) (-29.9114, -0.1719) (-29.5478, -0.1144) (-29.2874, -0.3747) (-29.2874, -0.6253) (-29.4347, -0.8281) (-29.6731, -0.9055) (-29.7984, -0.8856), closed, covered)
  P14_DCP_L3_h14 = polyline(z=-1.27mm, xy in mm: (-28.6138, -0.8856) (-28.8253, -0.7211) (-28.8741, -0.3747) (-28.7268, -0.1719) (-28.3632, -0.1144) (-28.1028, -0.3747) (-28.1028, -0.6253) (-28.2501, -0.8281) (-28.4885, -0.9055) (-28.6138, -0.8856), closed, covered)
  P14_DCP_L3_h15 = polyline(z=-1.27mm, xy in mm: (-27.4291, -0.8856) (-27.6407, -0.7211) (-27.6895, -0.3747) (-27.5422, -0.1719) (-27.1785, -0.1144) (-26.9182, -0.3747) (-26.9182, -0.6253) (-27.0655, -0.8281) (-27.3038, -0.9055) (-27.4291, -0.8856), closed, covered)
  P14_DCP_L3_h16 = polyline(z=-1.27mm, xy in mm: (-26.2445, -0.8856) (-26.4561, -0.7211) (-26.5049, -0.3747) (-26.3576, -0.1719) (-25.9939, -0.1144) (-25.7912, -0.2617) (-25.7137, -0.5) (-25.8809, -0.8281) (-26.1192, -0.9055) (-26.2445, -0.8856), closed, covered)
  P14_DCP_L3_h17 = polyline(z=-1.27mm, xy in mm: (-25.0599, -0.8856) (-25.3203, -0.6253) (-25.3203, -0.3747) (-25.173, -0.1719) (-24.8093, -0.1144) (-24.6066, -0.2617) (-24.5291, -0.5) (-24.6963, -0.8281) (-24.9346, -0.9055) (-25.0599, -0.8856), closed, covered)
  P14_DCP_L3_h18 = polyline(z=-1.27mm, xy in mm: (-23.8753, -0.8856) (-24.0781, -0.7383) (-24.1356, -0.3747) (-23.9883, -0.1719) (-23.6247, -0.1144) (-23.4219, -0.2617) (-23.3445, -0.5) (-23.4219, -0.7383) (-23.75, -0.9055) (-23.8753, -0.8856), closed, covered)
  P14_DCP_L3_h19 = polyline(z=-1.27mm, xy in mm: (-22.6907, -0.8856) (-22.9022, -0.7211) (-22.951, -0.3747) (-22.8037, -0.1719) (-22.4401, -0.1144) (-22.1797, -0.3747) (-22.1797, -0.6253) (-22.327, -0.8281) (-22.5654, -0.9055) (-22.6907, -0.8856), closed, covered)
  P14_DCP_L3_h20 = polyline(z=-1.27mm, xy in mm: (-21.5061, -0.8856) (-21.7176, -0.7211) (-21.7664, -0.3747) (-21.6191, -0.1719) (-21.2555, -0.1144) (-20.9951, -0.3747) (-20.9951, -0.6253) (-21.1424, -0.8281) (-21.3808, -0.9055) (-21.5061, -0.8856), closed, covered)
  P14_DCP_L3_h21 = polyline(z=-1.27mm, xy in mm: (-20.3215, -0.8856) (-20.533, -0.7211) (-20.5818, -0.3747) (-20.4345, -0.1719) (-20.0708, -0.1144) (-19.8105, -0.3747) (-19.8105, -0.6253) (-19.9578, -0.8281) (-20.1962, -0.9055) (-20.3215, -0.8856), closed, covered)
  P14_DCP_L3_h22 = polyline(z=-1.27mm, xy in mm: (-19.1368, -0.8856) (-19.3484, -0.7211) (-19.3972, -0.3747) (-19.2499, -0.1719) (-18.8862, -0.1144) (-18.6835, -0.2617) (-18.606, -0.5) (-18.7732, -0.8281) (-19.0115, -0.9055) (-19.1368, -0.8856), closed, covered)
  P14_DCP_L3_h23 = polyline(z=-1.27mm, xy in mm: (-17.9522, -0.8856) (-18.1638, -0.7211) (-18.2126, -0.3747) (-18.0653, -0.1719) (-17.7016, -0.1144) (-17.4989, -0.2617) (-17.4214, -0.5) (-17.5886, -0.8281) (-17.8269, -0.9055) (-17.9522, -0.8856), closed, covered)
  P14_DCP_L3_h24 = polyline(z=-1.27mm, xy in mm: (-16.7676, -0.8856) (-17.028, -0.6253) (-17.028, -0.3747) (-16.8806, -0.1719) (-16.517, -0.1144) (-16.3143, -0.2617) (-16.2368, -0.5) (-16.404, -0.8281) (-16.6423, -0.9055) (-16.7676, -0.8856), closed, covered)
  P14_DCP_L3_h25 = polyline(z=-1.27mm, xy in mm: (-15.583, -0.8856) (-15.7945, -0.7211) (-15.8433, -0.3747) (-15.696, -0.1719) (-15.3324, -0.1144) (-15.072, -0.3747) (-15.072, -0.6253) (-15.2193, -0.8281) (-15.4577, -0.9055) (-15.583, -0.8856), closed, covered)
  P14_DCP_L3_h26 = polyline(z=-1.27mm, xy in mm: (-14.3984, -0.8856) (-14.6099, -0.7211) (-14.6587, -0.3747) (-14.5114, -0.1719) (-14.1478, -0.1144) (-13.8874, -0.3747) (-13.8874, -0.6253) (-14.0347, -0.8281) (-14.2731, -0.9055) (-14.3984, -0.8856), closed, covered)
  P14_DCP_L3_h27 = polyline(z=-1.27mm, xy in mm: (-13.2138, -0.8856) (-13.4253, -0.7211) (-13.4741, -0.3747) (-13.3268, -0.1719) (-12.9632, -0.1144) (-12.7028, -0.3747) (-12.7028, -0.6253) (-12.8501, -0.8281) (-13.0885, -0.9055) (-13.2138, -0.8856), closed, covered)
  P14_DCP_L3_h28 = polyline(z=-1.27mm, xy in mm: (-12.0291, -0.8856) (-12.2407, -0.7211) (-12.2895, -0.3747) (-12.1422, -0.1719) (-11.7785, -0.1144) (-11.5182, -0.3747) (-11.5182, -0.6253) (-11.6655, -0.8281) (-11.9038, -0.9055) (-12.0291, -0.8856), closed, covered)
  P14_DCP_L3_h29 = polyline(z=-1.27mm, xy in mm: (-10.8445, -0.8856) (-11.0561, -0.7211) (-11.1049, -0.3747) (-10.9576, -0.1719) (-10.5939, -0.1144) (-10.3912, -0.2617) (-10.3137, -0.5) (-10.4809, -0.8281) (-10.7192, -0.9055) (-10.8445, -0.8856), closed, covered)
  P14_DCP_L3_h30 = polyline(z=-1.27mm, xy in mm: (-9.6599, -0.8856) (-9.9203, -0.6253) (-9.9203, -0.3747) (-9.773, -0.1719) (-9.4093, -0.1144) (-9.2066, -0.2617) (-9.1291, -0.5) (-9.2963, -0.8281) (-9.5346, -0.9055) (-9.6599, -0.8856), closed, covered)
  P14_DCP_L3_h31 = polyline(z=-1.27mm, xy in mm: (-8.4753, -0.8856) (-8.6868, -0.7211) (-8.7356, -0.3747) (-8.5883, -0.1719) (-8.2247, -0.1144) (-8.0219, -0.2617) (-7.9445, -0.5) (-8.0219, -0.7383) (-8.35, -0.9055) (-8.4753, -0.8856), closed, covered)
  P14_DCP_L3_h32 = polyline(z=-1.27mm, xy in mm: (-7.2753, -0.8856) (-7.5356, -0.6253) (-7.5356, -0.3747) (-7.3883, -0.1719) (-7.0247, -0.1144) (-6.8219, -0.2617) (-6.7445, -0.5) (-6.9117, -0.8281) (-7.15, -0.9055) (-7.2753, -0.8856), closed, covered)
  P14_DCP_L3_h33 = polyline(z=-1.27mm, xy in mm: (-6.0753, -0.8856) (-6.3356, -0.6253) (-6.3356, -0.3747) (-6.1883, -0.1719) (-5.8247, -0.1144) (-5.6219, -0.2617) (-5.5445, -0.5) (-5.6219, -0.7383) (-5.95, -0.9055) (-6.0753, -0.8856), closed, covered)
  P14_DCP_L3_h34 = polyline(z=-1.27mm, xy in mm: (-4.8753, -0.8856) (-5.1356, -0.6253) (-5.1356, -0.3747) (-4.9883, -0.1719) (-4.6247, -0.1144) (-4.422, -0.2617) (-4.3445, -0.5) (-4.5117, -0.8281) (-4.75, -0.9055) (-4.8753, -0.8856), closed, covered)
  P14_DCP_L3_h35 = polyline(z=-1.27mm, xy in mm: (-3.6753, -0.8856) (-3.9356, -0.6253) (-3.9356, -0.3747) (-3.7883, -0.1719) (-3.4247, -0.1144) (-3.2219, -0.2617) (-3.1445, -0.5) (-3.2219, -0.7383) (-3.55, -0.9055) (-3.6753, -0.8856), closed, covered)
  P14_DCP_L3_h36 = polyline(z=-1.27mm, xy in mm: (-2.4753, -0.8856) (-2.7356, -0.6253) (-2.7356, -0.3747) (-2.5883, -0.1719) (-2.2247, -0.1144) (-2.0219, -0.2617) (-1.9445, -0.5) (-2.0219, -0.7383) (-2.35, -0.9055) (-2.4753, -0.8856), closed, covered)
  P14_DCP_L3_h37 = polyline(z=-1.27mm, xy in mm: (-1.2753, -0.8856) (-1.5356, -0.6253) (-1.5356, -0.3747) (-1.3883, -0.1719) (-1.0247, -0.1144) (-0.8219, -0.2617) (-0.7445, -0.5) (-0.8219, -0.7383) (-1.15, -0.9055) (-1.2753, -0.8856), closed, covered)
  P14_DCP_L3_h38 = polyline(z=-1.27mm, xy in mm: (-0.0753, -0.8856) (-0.3356, -0.6253) (-0.3356, -0.3747) (-0.1883, -0.1719) (0.1753, -0.1144) (0.3781, -0.2617) (0.4555, -0.5) (0.3781, -0.7383) (0.05, -0.9055) (-0.0753, -0.8856), closed, covered)
  P14_DCP_L3_h39 = polyline(z=-1.27mm, xy in mm: (1.1247, -0.8856) (0.8644, -0.6253) (0.8644, -0.3747) (1.0117, -0.1719) (1.3753, -0.1144) (1.578, -0.2617) (1.6555, -0.5) (1.4883, -0.8281) (1.25, -0.9055) (1.1247, -0.8856), closed, covered)
  P14_DCP_L3_h40 = polyline(z=-1.27mm, xy in mm: (2.3247, -0.8856) (2.0644, -0.6253) (2.0644, -0.3747) (2.2117, -0.1719) (2.5753, -0.1144) (2.7781, -0.2617) (2.8555, -0.5) (2.7781, -0.7383) (2.45, -0.9055) (2.3247, -0.8856), closed, covered)
  P14_DCP_L3_h41 = polyline(z=-1.27mm, xy in mm: (3.5247, -0.8856) (3.2644, -0.6253) (3.2644, -0.3747) (3.4117, -0.1719) (3.7753, -0.1144) (3.978, -0.2617) (4.0555, -0.5) (3.8883, -0.8281) (3.65, -0.9055) (3.5247, -0.8856), closed, covered)
  P14_DCP_L3_h42 = polyline(z=-1.27mm, xy in mm: (4.7247, -0.8856) (4.4644, -0.6253) (4.4644, -0.3747) (4.6117, -0.1719) (4.9753, -0.1144) (5.1781, -0.2617) (5.2555, -0.5) (5.0883, -0.8281) (4.85, -0.9055) (4.7247, -0.8856), closed, covered)
  P14_DCP_L3_h43 = polyline(z=-1.27mm, xy in mm: (5.9247, -0.8856) (5.6644, -0.6253) (5.6644, -0.3747) (5.8117, -0.1719) (6.1753, -0.1144) (6.3781, -0.2617) (6.4555, -0.5) (6.3781, -0.7383) (6.05, -0.9055) (5.9247, -0.8856), closed, covered)
  P14_DCP_L3_h44 = polyline(z=-1.27mm, xy in mm: (8.2247, -0.8856) (8.0132, -0.7211) (7.9644, -0.3747) (8.1117, -0.1719) (8.4753, -0.1144) (8.6781, -0.2617) (8.7555, -0.5) (8.6781, -0.7383) (8.35, -0.9055) (8.2247, -0.8856), closed, covered)
  P14_DCP_L3_h45 = polyline(z=-1.27mm, xy in mm: (9.4093, -0.8856) (9.1978, -0.7211) (9.149, -0.3747) (9.2963, -0.1719) (9.6599, -0.1144) (9.9203, -0.3747) (9.9203, -0.6253) (9.773, -0.8281) (9.5346, -0.9055) (9.4093, -0.8856), closed, covered)
  P14_DCP_L3_h46 = polyline(z=-1.27mm, xy in mm: (10.5939, -0.8856) (10.3824, -0.7211) (10.3336, -0.3747) (10.4809, -0.1719) (10.8445, -0.1144) (11.1049, -0.3747) (11.1049, -0.6253) (10.9576, -0.8281) (10.7192, -0.9055) (10.5939, -0.8856), closed, covered)
  P14_DCP_L3_h47 = polyline(z=-1.27mm, xy in mm: (11.7785, -0.8856) (11.567, -0.7211) (11.5182, -0.3747) (11.6655, -0.1719) (12.0291, -0.1144) (12.2895, -0.3747) (12.2895, -0.6253) (12.1422, -0.8281) (11.9038, -0.9055) (11.7785, -0.8856), closed, covered)
  P14_DCP_L3_h48 = polyline(z=-1.27mm, xy in mm: (12.9632, -0.8856) (12.7516, -0.7211) (12.7028, -0.3747) (12.8501, -0.1719) (13.2138, -0.1144) (13.4165, -0.2617) (13.494, -0.5) (13.3268, -0.8281) (13.0885, -0.9055) (12.9632, -0.8856), closed, covered)
  P14_DCP_L3_h49 = polyline(z=-1.27mm, xy in mm: (14.1478, -0.8856) (13.9362, -0.7211) (13.8874, -0.3747) (14.0347, -0.1719) (14.3984, -0.1144) (14.6011, -0.2617) (14.6786, -0.5) (14.5114, -0.8281) (14.2731, -0.9055) (14.1478, -0.8856), closed, covered)
  P14_DCP_L3_h50 = polyline(z=-1.27mm, xy in mm: (15.3324, -0.8856) (15.072, -0.6253) (15.072, -0.3747) (15.2193, -0.1719) (15.583, -0.1144) (15.7857, -0.2617) (15.8632, -0.5) (15.696, -0.8281) (15.4577, -0.9055) (15.3324, -0.8856), closed, covered)
  P14_DCP_L3_h51 = polyline(z=-1.27mm, xy in mm: (16.517, -0.8856) (16.3055, -0.7211) (16.2567, -0.3747) (16.404, -0.1719) (16.7676, -0.1144) (17.028, -0.3747) (17.028, -0.6253) (16.8806, -0.8281) (16.6423, -0.9055) (16.517, -0.8856), closed, covered)
  P14_DCP_L3_h52 = polyline(z=-1.27mm, xy in mm: (17.7016, -0.8856) (17.4901, -0.7211) (17.4413, -0.3747) (17.5886, -0.1719) (17.9522, -0.1144) (18.2126, -0.3747) (18.2126, -0.6253) (18.0653, -0.8281) (17.8269, -0.9055) (17.7016, -0.8856), closed, covered)
  P14_DCP_L3_h53 = polyline(z=-1.27mm, xy in mm: (18.8862, -0.8856) (18.6747, -0.7211) (18.6259, -0.3747) (18.7732, -0.1719) (19.1368, -0.1144) (19.3972, -0.3747) (19.3972, -0.6253) (19.2499, -0.8281) (19.0115, -0.9055) (18.8862, -0.8856), closed, covered)
  P14_DCP_L3_h54 = polyline(z=-1.27mm, xy in mm: (20.0709, -0.8856) (19.8593, -0.7211) (19.8105, -0.3747) (19.9578, -0.1719) (20.3215, -0.1144) (20.5818, -0.3747) (20.5818, -0.6253) (20.4345, -0.8281) (20.1961, -0.9055) (20.0709, -0.8856), closed, covered)
  P14_DCP_L3_h55 = polyline(z=-1.27mm, xy in mm: (21.2555, -0.8856) (21.0439, -0.7211) (20.9951, -0.3747) (21.1424, -0.1719) (21.5061, -0.1144) (21.7088, -0.2617) (21.7863, -0.5) (21.6191, -0.8281) (21.3808, -0.9055) (21.2555, -0.8856), closed, covered)
  P14_DCP_L3_h56 = polyline(z=-1.27mm, xy in mm: (22.4401, -0.8856) (22.1797, -0.6253) (22.1797, -0.3747) (22.327, -0.1719) (22.6907, -0.1144) (22.8934, -0.2617) (22.9709, -0.5) (22.8037, -0.8281) (22.5654, -0.9055) (22.4401, -0.8856), closed, covered)
  P14_DCP_L3_h57 = polyline(z=-1.27mm, xy in mm: (23.6247, -0.8856) (23.4132, -0.7211) (23.3644, -0.3747) (23.5117, -0.1719) (23.8753, -0.1144) (24.078, -0.2617) (24.1555, -0.5) (23.9883, -0.8281) (23.75, -0.9055) (23.6247, -0.8856), closed, covered)
  P14_DCP_L3_h58 = polyline(z=-1.27mm, xy in mm: (24.8093, -0.8856) (24.5978, -0.7211) (24.549, -0.3747) (24.6963, -0.1719) (25.0599, -0.1144) (25.3203, -0.3747) (25.3203, -0.6253) (25.173, -0.8281) (24.9346, -0.9055) (24.8093, -0.8856), closed, covered)
  P14_DCP_L3_h59 = polyline(z=-1.27mm, xy in mm: (25.9939, -0.8856) (25.7824, -0.7211) (25.7336, -0.3747) (25.8809, -0.1719) (26.2445, -0.1144) (26.5049, -0.3747) (26.5049, -0.6253) (26.3576, -0.8281) (26.1192, -0.9055) (25.9939, -0.8856), closed, covered)
  P14_DCP_L3_h60 = polyline(z=-1.27mm, xy in mm: (27.1785, -0.8856) (26.967, -0.7211) (26.9182, -0.3747) (27.0655, -0.1719) (27.4291, -0.1144) (27.6895, -0.3747) (27.6895, -0.6253) (27.5422, -0.8281) (27.3038, -0.9055) (27.1785, -0.8856), closed, covered)
  P14_DCP_L3_h61 = polyline(z=-1.27mm, xy in mm: (28.3632, -0.8856) (28.1516, -0.7211) (28.1028, -0.3747) (28.2501, -0.1719) (28.6138, -0.1144) (28.8165, -0.2617) (28.894, -0.5) (28.7268, -0.8281) (28.4885, -0.9055) (28.3632, -0.8856), closed, covered)
  P14_DCP_L3_h62 = polyline(z=-1.27mm, xy in mm: (29.5478, -0.8856) (29.3362, -0.7211) (29.2874, -0.3747) (29.4347, -0.1719) (29.7984, -0.1144) (30.0011, -0.2617) (30.0786, -0.5) (29.9114, -0.8281) (29.6731, -0.9055) (29.5478, -0.8856), closed, covered)
  P14_DCP_L3_h63 = polyline(z=-1.27mm, xy in mm: (30.7324, -0.8856) (30.472, -0.6253) (30.472, -0.3747) (30.6193, -0.1719) (30.983, -0.1144) (31.1857, -0.2617) (31.2632, -0.5) (31.096, -0.8281) (30.8577, -0.9055) (30.7324, -0.8856), closed, covered)
  P14_DCP_L3_h64 = polyline(z=-1.27mm, xy in mm: (31.917, -0.8856) (31.7055, -0.7211) (31.6567, -0.3747) (31.804, -0.1719) (32.1676, -0.1144) (32.428, -0.3747) (32.428, -0.6253) (32.2806, -0.8281) (32.0423, -0.9055) (31.917, -0.8856), closed, covered)
  P14_DCP_L3_h65 = polyline(z=-1.27mm, xy in mm: (33.1016, -0.8856) (32.8901, -0.7211) (32.8413, -0.3747) (32.9886, -0.1719) (33.3522, -0.1144) (33.6126, -0.3747) (33.6126, -0.6253) (33.4653, -0.8281) (33.2269, -0.9055) (33.1016, -0.8856), closed, covered)
  P14_DCP_L3_h66 = polyline(z=-1.27mm, xy in mm: (34.2862, -0.8856) (34.0747, -0.7211) (34.0259, -0.3747) (34.1732, -0.1719) (34.5368, -0.1144) (34.7972, -0.3747) (34.7972, -0.6253) (34.6499, -0.8281) (34.4115, -0.9055) (34.2862, -0.8856), closed, covered)
  P14_DCP_L3_h67 = polyline(z=-1.27mm, xy in mm: (35.4709, -0.8856) (35.2593, -0.7211) (35.2105, -0.3747) (35.3578, -0.1719) (35.7215, -0.1144) (35.9818, -0.3747) (35.9818, -0.6253) (35.8345, -0.8281) (35.5961, -0.9055) (35.4709, -0.8856), closed, covered)
  P14_DCP_L3_h68 = polyline(z=-1.27mm, xy in mm: (36.6555, -0.8856) (36.4439, -0.7211) (36.3951, -0.3747) (36.5424, -0.1719) (36.9061, -0.1144) (37.1088, -0.2617) (37.1863, -0.5) (37.0191, -0.8281) (36.7808, -0.9055) (36.6555, -0.8856), closed, covered)
  P14_DCP_L3_h69 = polyline(z=-1.27mm, xy in mm: (37.8401, -0.8856) (37.5797, -0.6253) (37.5797, -0.3747) (37.727, -0.1719) (38.0907, -0.1144) (38.2934, -0.2617) (38.3709, -0.5) (38.2037, -0.8281) (37.9654, -0.9055) (37.8401, -0.8856), closed, covered)
  P14_DCP_L3.subtract(P14_DCP_L3_h0..P14_DCP_L3_h69)
  P14_DCP_L3.sweep_along_vector((0mm, 0mm, 0.07mm))
  P15_DCP_L4 = polyline(z=-1.44mm, xy in mm: (-28.4908, 1.4689) (-28.45, 3.201) (-28.5184, 3.2952) (-29.5953, 3.3) (-29.8268, 3.0565) (-30.08, 2.9742) (-30.3332, 3.0565) (-30.5647, 3.3) (-37.951, 3.3) (-38.0452, 3.2316) (-38.05, 1.549) (-37.9816, 1.4548) (-28.549, 1.45) (-28.4908, 1.4689), closed, covered)
  P15_DCP_L4.sweep_along_vector((0mm, 0mm, 0.07mm))
  P16_DCP_L4 = polyline(z=-1.44mm, xy in mm: (-11.8361, 1.4689) (-11.8843, 2.6203) (-12.3943, 2.7352) (-12.7843, 3.1043) (-12.8973, 3.0768) (-13.0898, 2.8395) (-13.3978, 2.7009) (-14.0522, 2.7009) (-14.5345, 2.9871) (-15.0478, 2.7009) (-15.6316, 2.6945) (-16.0102, 2.8395) (-16.3508, 3.3) (-17.0013, 3.3) (-17.4653, 2.9712) (-17.85, 2.8947) (-18.2347, 2.9712) (-18.6737, 3.2968) (-18.951, 3.3) (-19.0452, 3.2316) (-19.05, 1.549) (-18.9816, 1.4548) (-11.8943, 1.45) (-11.8361, 1.4689), closed, covered)
  P16_DCP_L4.sweep_along_vector((0mm, 0mm, 0.07mm))
  P17_DCP_L4 = polyline(z=-1.44mm, xy in mm: (19.0092, 1.4689) (19.05, 3.201) (18.9816, 3.2952) (17.9047, 3.3) (17.6732, 3.0565) (17.42, 2.9742) (17.1668, 3.0565) (16.9353, 3.3) (9.549, 3.3) (9.4548, 3.2316) (9.45, 1.549) (9.5184, 1.4548) (18.951, 1.45) (19.0092, 1.4689), closed, covered)
  P17_DCP_L4.sweep_along_vector((0mm, 0mm, 0.07mm))
  P18_DCP_L4 = polyline(z=-1.44mm, xy in mm: (35.6639, 1.4689) (35.6157, 2.6203) (35.1057, 2.7352) (34.7157, 3.1043) (34.6027, 3.0768) (34.4102, 2.8395) (34.1022, 2.7009) (33.4478, 2.7009) (32.9655, 2.9871) (32.4522, 2.7009) (31.8684, 2.6945) (31.4898, 2.8395) (31.1492, 3.3) (30.4987, 3.3) (30.0347, 2.9712) (29.65, 2.8947) (29.2653, 2.9712) (28.8263, 3.2968) (28.549, 3.3) (28.4548, 3.2316) (28.45, 1.549) (28.5184, 1.4548) (35.6057, 1.45) (35.6639, 1.4689), closed, covered)
  P18_DCP_L4.sweep_along_vector((0mm, 0mm, 0.07mm))
  P19_LSRC1_L1 [copper] = polyline(z=0.17mm, xy in mm: (-36.3943, 9.5189) (-36.3505, 10.9623) (-36.1153, 11.1975) (-35.1146, 11.2005) (-34.9004, 11.0685) (-34.8505, 9.599) (-34.7515, 9.5) (-34.2995, 9.5) (-34.2053, 9.5684) (-34.2005, 10.9612) (-34.1264, 11.1264) (-33.9611, 11.2005) (-33.3114, 11.1851) (-33.1495, 10.9611) (-33.1306, 9.5408) (-32.5995, 9.5) (-32.5005, 9.599) (-32.5005, 10.9612) (-32.4264, 11.1264) (-32.2611, 11.2005) (-30.4106, 11.2005) (-30.2785, 11.1506) (-30.0687, 10.8591) (-29.6565, 10.9405) (-28.8335, 10.8877) (-28.7512, 10.97) (-28.75, 11.2) (-28.65, 11.299) (-28.6689, 12.3592) (-43.6092, 12.3811) (-43.65, 11.299) (-43.5816, 11.2048) (-37.75, 11.2) (-37.7311, 9.5408) (-36.4525, 9.5) (-36.3943, 9.5189), closed, covered)
  P19_LSRC1_L1.sweep_along_vector((0mm, 0mm, 0.07mm))
  P20_LSRC1_L4 = polyline(z=-1.44mm, xy in mm: (-37.025, 11.875) (-34.675, 11.875) (-34.675, 12.125) (-37.025, 12.125) (-37.025, 18.87) (-38.55, 18.87) (-38.55, 18.47) (-37.425, 18.47) (-37.425, 15.49) (-38.55, 15.49) (-38.55, 15.09) (-37.425, 15.09) (-37.425, 11.6) (-37.025, 11.6) (-37.025, 11.875), closed, covered)
  P20_LSRC1_L4.sweep_along_vector((0mm, 0mm, 0.07mm))
  P21_LSRC2_L1 [copper] = polyline(z=0.17mm, xy in mm: (-14.3913, 9.5189) (-14.3505, 10.9612) (-14.1886, 11.1851) (-13.5389, 11.2005) (-13.3149, 11.0386) (-13.2995, 9.599) (-13.2311, 9.5048) (-12.7485, 9.5) (-12.6543, 9.5684) (-12.6495, 10.9364) (-12.5175, 11.1506) (-11.4106, 11.2005) (-11.2785, 11.1506) (-11.1495, 10.9623) (-11.1276, 9.5408) (-9.849, 9.5) (-9.75, 9.599) (-9.75, 11.2) (-3.949, 11.2) (-3.85, 11.299) (-3.85, 12.301) (-3.949, 12.4) (-18.751, 12.4) (-18.85, 12.301) (-18.85, 11.299) (-18.75, 11.2) (-18.6816, 10.8553) (-17.879, 10.8505) (-17.5531, 11.1047) (-17.0894, 11.2005) (-15.1614, 11.1851) (-14.9995, 10.9611) (-14.9806, 9.5408) (-14.4495, 9.5) (-14.3913, 9.5189), closed, covered)
  P21_LSRC2_L1.sweep_along_vector((0mm, 0mm, 0.07mm))
  P22_LSRC2_L4 = polyline(z=-1.44mm, xy in mm: (-10.075, 13.225) (-10.075, 15.09) (-8.95, 15.09) (-8.95, 15.49) (-10.075, 15.49) (-10.075, 18.47) (-8.95, 18.47) (-8.95, 18.87) (-10.475, 18.87) (-10.475, 11.6) (-10.075, 11.6) (-10.075, 13.225), closed, covered)
  P22_LSRC2_L4.sweep_along_vector((0mm, 0mm, 0.07mm))
  P23_LSRC3_L1 [copper] = polyline(z=0.17mm, xy in mm: (11.1057, 9.5189) (11.1495, 10.9623) (11.3847, 11.1975) (12.3854, 11.2005) (12.5996, 11.0685) (12.6495, 9.599) (12.7485, 9.5) (13.2005, 9.5) (13.2947, 9.5684) (13.2995, 10.9612) (13.3736, 11.1264) (13.5389, 11.2005) (14.1886, 11.1851) (14.3505, 10.9611) (14.3694, 9.5408) (14.9005, 9.5) (14.9995, 9.599) (14.9995, 10.9612) (15.0736, 11.1264) (15.2389, 11.2005) (17.0894, 11.2005) (17.2215, 11.1506) (17.4313, 10.8591) (17.8435, 10.9405) (18.6665, 10.8877) (18.7488, 10.97) (18.75, 11.2) (18.85, 11.299) (18.8311, 12.3592) (3.8908, 12.3811) (3.85, 11.299) (3.9184, 11.2048) (9.75, 11.2) (9.7689, 9.5408) (11.0475, 9.5) (11.1057, 9.5189), closed, covered)
  P23_LSRC3_L1.sweep_along_vector((0mm, 0mm, 0.07mm))
  P24_LSRC3_L4 = polyline(z=-1.44mm, xy in mm: (10.475, 11.875) (12.825, 11.875) (12.825, 12.125) (10.475, 12.125) (10.475, 18.87) (8.95, 18.87) (8.95, 18.47) (10.075, 18.47) (10.075, 15.49) (8.95, 15.49) (8.95, 15.09) (10.075, 15.09) (10.075, 11.6) (10.475, 11.6) (10.475, 11.875), closed, covered)
  P24_LSRC3_L4.sweep_along_vector((0mm, 0mm, 0.07mm))
  P25_LSRC4_L1 [copper] = polyline(z=0.17mm, xy in mm: (33.1087, 9.5189) (33.1495, 10.9612) (33.3114, 11.1851) (33.9611, 11.2005) (34.1851, 11.0386) (34.2005, 9.599) (34.2689, 9.5048) (34.7515, 9.5) (34.8457, 9.5684) (34.8505, 10.9364) (34.9825, 11.1506) (36.0894, 11.2005) (36.2215, 11.1506) (36.3505, 10.9623) (36.3724, 9.5408) (37.651, 9.5) (37.75, 9.599) (37.75, 11.2) (43.551, 11.2) (43.65, 11.299) (43.65, 12.301) (43.551, 12.4) (28.749, 12.4) (28.65, 12.301) (28.65, 11.299) (28.75, 11.2) (28.8184, 10.8553) (29.621, 10.8505) (29.9469, 11.1047) (30.4106, 11.2005) (32.3386, 11.1851) (32.5005, 10.9611) (32.5194, 9.5408) (33.0505, 9.5) (33.1087, 9.5189), closed, covered)
  P25_LSRC4_L1.sweep_along_vector((0mm, 0mm, 0.07mm))
  P26_LSRC4_L4 = polyline(z=-1.44mm, xy in mm: (37.425, 13.225) (37.425, 15.09) (38.55, 15.09) (38.55, 15.49) (37.425, 15.49) (37.425, 18.47) (38.55, 18.47) (38.55, 18.87) (37.025, 18.87) (37.025, 11.6) (37.425, 11.6) (37.425, 13.225), closed, covered)
  P26_LSRC4_L4.sweep_along_vector((0mm, 0mm, 0.07mm))
  P27_AC1_L1 [copper] = polyline(z=0.17mm, xy in mm: (-36.3943, 5.2189) (-36.3505, 6.6623) (-36.1153, 6.8975) (-35.1146, 6.9005) (-34.9004, 6.7685) (-34.8505, 5.299) (-34.7515, 5.2) (-34.2995, 5.2) (-34.2053, 5.2684) (-34.2005, 6.6612) (-34.1264, 6.8264) (-33.9611, 6.9005) (-33.3114, 6.8851) (-33.1495, 6.6611) (-33.1306, 5.2408) (-32.5995, 5.2) (-32.5005, 5.299) (-32.5005, 6.6612) (-32.3386, 6.8851) (-30.4106, 6.9005) (-30.2785, 6.8506) (-30.0687, 6.5591) (-29.6565, 6.6405) (-28.8335, 6.5877) (-28.75, 6.6854) (-28.7689, 7.5087) (-29.621, 7.5495) (-29.9469, 7.2953) (-30.3847, 7.2025) (-31.4113, 7.2025) (-31.6465, 7.4377) (-31.6684, 8.8592) (-32.2005, 8.9) (-32.2995, 8.801) (-32.3149, 7.3614) (-32.5389, 7.1995) (-33.1886, 7.2149) (-33.3505, 7.4389) (-33.3694, 8.8592) (-33.9005, 8.9) (-33.9995, 8.801) (-34.0149, 7.3614) (-34.2389, 7.1995) (-34.8886, 7.2149) (-35.0505, 7.4389) (-35.0505, 8.801) (-35.1189, 8.8952) (-38.05, 8.9) (-38.05, 10.501) (-38.1184, 10.5952) (-43.6092, 10.5811) (-43.6311, 5.6408) (-37.75, 5.6) (-37.75, 5.299) (-37.6816, 5.2048) (-36.4525, 5.2) (-36.3943, 5.2189), closed, covered)
  P27_AC1_L1.sweep_along_vector((0mm, 0mm, 0.07mm))
  P28_AC2_L1 [copper] = polyline(z=0.17mm, xy in mm: (-14.3913, 5.2189) (-14.3505, 6.6612) (-14.2764, 6.8264) (-14.1111, 6.9005) (-13.4614, 6.8851) (-13.3149, 6.7386) (-13.2995, 5.299) (-13.2005, 5.2) (-12.7485, 5.2) (-12.6543, 5.2684) (-12.6465, 6.6623) (-12.5175, 6.8506) (-12.3854, 6.9005) (-11.4106, 6.9005) (-11.1964, 6.7685) (-11.1465, 5.299) (-11.0475, 5.2) (-9.849, 5.2) (-9.7548, 5.2684) (-9.75, 5.6) (-3.8908, 5.6189) (-3.8689, 10.5592) (-9.4092, 10.5811) (-9.45, 8.9) (-12.4087, 8.8811) (-12.4495, 7.4388) (-12.5236, 7.2736) (-12.6889, 7.1995) (-13.3386, 7.2149) (-13.4851, 7.3614) (-13.5005, 8.801) (-13.5995, 8.9) (-14.0505, 8.9) (-14.1447, 8.8316) (-14.1495, 7.4388) (-14.2236, 7.2736) (-14.3889, 7.1995) (-15.0386, 7.2149) (-15.2005, 7.4389) (-15.2194, 8.8592) (-15.8097, 8.8811) (-15.9029, 8.6191) (-15.8505, 7.4636) (-15.9825, 7.2494) (-17.0894, 7.1995) (-17.3427, 7.3439) (-17.7478, 7.1659) (-18.6827, 7.1868) (-18.75, 7.093) (-18.7311, 6.5913) (-17.879, 6.5505) (-17.5531, 6.8047) (-17.0894, 6.9005) (-15.1614, 6.8851) (-14.9995, 6.6611) (-14.9806, 5.2408) (-14.4495, 5.2) (-14.3913, 5.2189), closed, covered)
  P28_AC2_L1.sweep_along_vector((0mm, 0mm, 0.07mm))
  P29_AC3_L1 [copper] = polyline(z=0.17mm, xy in mm: (11.1057, 5.2189) (11.1495, 6.6623) (11.3847, 6.8975) (12.3854, 6.9005) (12.5996, 6.7685) (12.6495, 5.299) (12.7485, 5.2) (13.2005, 5.2) (13.2947, 5.2684) (13.2995, 6.6612) (13.3736, 6.8264) (13.5389, 6.9005) (14.1886, 6.8851) (14.3505, 6.6611) (14.3694, 5.2408) (14.9005, 5.2) (14.9995, 5.299) (14.9995, 6.6612) (15.1614, 6.8851) (17.0894, 6.9005) (17.2215, 6.8506) (17.4313, 6.5591) (17.8435, 6.6405) (18.6665, 6.5877) (18.75, 6.6854) (18.7311, 7.5087) (17.879, 7.5495) (17.5531, 7.2953) (17.1153, 7.2025) (16.0887, 7.2025) (15.8535, 7.4377) (15.8316, 8.8592) (15.2995, 8.9) (15.2005, 8.801) (15.1851, 7.3614) (14.9611, 7.1995) (14.3114, 7.2149) (14.1495, 7.4389) (14.1306, 8.8592) (13.5995, 8.9) (13.5005, 8.801) (13.4851, 7.3614) (13.2611, 7.1995) (12.6114, 7.2149) (12.4495, 7.4389) (12.4495, 8.801) (12.3811, 8.8952) (9.45, 8.9) (9.45, 10.501) (9.3816, 10.5952) (3.8908, 10.5811) (3.8689, 5.6408) (9.75, 5.6) (9.75, 5.299) (9.8184, 5.2048) (11.0475, 5.2) (11.1057, 5.2189), closed, covered)
  P29_AC3_L1.sweep_along_vector((0mm, 0mm, 0.07mm))
  P30_AC4_L1 [copper] = polyline(z=0.17mm, xy in mm: (33.1087, 5.2189) (33.1495, 6.6612) (33.2236, 6.8264) (33.3889, 6.9005) (34.0386, 6.8851) (34.1851, 6.7386) (34.2005, 5.299) (34.2995, 5.2) (34.7515, 5.2) (34.8457, 5.2684) (34.8535, 6.6623) (34.9825, 6.8506) (35.1146, 6.9005) (36.0894, 6.9005) (36.3036, 6.7685) (36.3535, 5.299) (36.4525, 5.2) (37.651, 5.2) (37.7452, 5.2684) (37.75, 5.6) (43.6092, 5.6189) (43.6311, 10.5592) (38.0908, 10.5811) (38.05, 8.9) (35.0913, 8.8811) (35.0505, 7.4388) (34.9764, 7.2736) (34.8111, 7.1995) (34.1614, 7.2149) (34.0149, 7.3614) (33.9995, 8.801) (33.9005, 8.9) (33.4495, 8.9) (33.3553, 8.8316) (33.3505, 7.4388) (33.2764, 7.2736) (33.1111, 7.1995) (32.4614, 7.2149) (32.2995, 7.4389) (32.2806, 8.8592) (31.6903, 8.8811) (31.5971, 8.6191) (31.6495, 7.4636) (31.5175, 7.2494) (30.4106, 7.1995) (30.1573, 7.3439) (29.7522, 7.1659) (28.8173, 7.1868) (28.75, 7.093) (28.7689, 6.5913) (29.621, 6.5505) (29.9469, 6.8047) (30.4106, 6.9005) (32.3386, 6.8851) (32.5005, 6.6611) (32.5194, 5.2408) (33.0505, 5.2) (33.1087, 5.2189), closed, covered)
  P30_AC4_L1.sweep_along_vector((0mm, 0mm, 0.07mm))
  P31_AC1_L3 = polyline(z=-1.27mm, xy in mm: (-29.207, 5.2197) (-29.15, 5.324) (-29.1697, 12.9556) (-29.6553, 13.3499) (-29.9117, 13.072) (-30.15, 12.9945) (-30.3883, 13.072) (-30.6553, 13.3499) (-30.9117, 13.072) (-31.15, 12.9945) (-31.3883, 13.072) (-31.6553, 13.3499) (-31.9117, 13.072) (-32.15, 12.9945) (-32.3883, 13.072) (-32.6553, 13.3499) (-32.9117, 13.072) (-33.15, 12.9945) (-33.3883, 13.072) (-33.6553, 13.3499) (-33.9117, 13.072) (-34.15, 12.9945) (-34.3883, 13.072) (-34.6553, 13.3499) (-34.9117, 13.072) (-35.15, 12.9945) (-35.3883, 13.072) (-35.6553, 13.3499) (-35.9117, 13.072) (-36.15, 12.9945) (-36.3883, 13.072) (-36.5356, 13.2747) (-36.5356, 13.5253) (-36.4206, 13.7236) (-36.5555, 14.1) (-36.4206, 14.4236) (-36.5555, 14.8) (-36.4206, 15.1236) (-36.5555, 15.5) (-36.478, 15.7383) (-36.2753, 15.8856) (-36.0247, 15.8856) (-35.6447, 15.5501) (-35.2753, 15.8856) (-35.0247, 15.8856) (-34.8504, 15.7946) (-34.7003, 15.9069) (-34.7, 18.5842) (-34.8416, 18.707) (-35.0247, 18.6144) (-35.2753, 18.6144) (-35.478, 18.7617) (-35.5555, 19) (-35.3956, 19.3486) (-35.5555, 19.75) (-35.478, 19.9883) (-35.15, 20.1555) (-34.7807, 20.0496) (-34.7003, 20.1569) (-34.7197, 20.4925) (-34.824, 20.5495) (-36.6364, 20.6) (-38.19, 20.5444) (-38.5123, 20.6) (-43.65, 20.6) (-43.6303, 5.257) (-43.526, 5.2) (-29.274, 5.2) (-29.207, 5.2197), closed, covered)
  P31_AC1_L3_h0 = polyline(z=-1.27mm, xy in mm: (-42.2753, 13.0144) (-42.478, 13.1617) (-42.5555, 13.4) (-42.478, 13.6383) (-42.15, 13.8055) (-41.9117, 13.728) (-41.6447, 13.4501) (-41.3883, 13.728) (-41.15, 13.8055) (-40.9117, 13.728) (-40.6447, 13.4501) (-40.3883, 13.728) (-40.15, 13.8055) (-39.9117, 13.728) (-39.6447, 13.4501) (-39.3883, 13.728) (-39.0247, 13.7856) (-38.6447, 13.4501) (-38.3883, 13.728) (-38.15, 13.8055) (-37.9117, 13.728) (-37.7445, 13.4) (-37.822, 13.1617) (-38.15, 12.9945) (-38.3883, 13.072) (-38.6553, 13.3499) (-38.9117, 13.072) (-39.15, 12.9945) (-39.3883, 13.072) (-39.6553, 13.3499) (-39.9117, 13.072) (-40.15, 12.9945) (-40.3883, 13.072) (-40.6553, 13.3499) (-40.9117, 13.072) (-41.2753, 13.0144) (-41.6553, 13.3499) (-41.9117, 13.072) (-42.15, 12.9945) (-42.2753, 13.0144), closed, covered)
  P31_AC1_L3_h1 = polyline(z=-1.27mm, xy in mm: (-37.3503, 11.4144) (-37.6106, 11.6747) (-37.6106, 11.9253) (-37.4633, 12.1281) (-37.0997, 12.1856) (-36.897, 12.0383) (-36.8195, 11.8) (-36.897, 11.5617) (-37.225, 11.3945) (-37.3503, 11.4144), closed, covered)
  P31_AC1_L3_h2 = polyline(z=-1.27mm, xy in mm: (-30.1975, 10.0684) (-30.3876, 10.2065) (-30.4416, 10.5475) (-30.3035, 10.7376) (-29.9625, 10.7916) (-29.7724, 10.6535) (-29.7184, 10.3125) (-29.8565, 10.1224) (-30.08, 10.0498) (-30.1975, 10.0684), closed, covered)
  P31_AC1_L3_h3 = polyline(z=-1.27mm, xy in mm: (-30.1975, 7.3434) (-30.3876, 7.4815) (-30.4416, 7.8225) (-30.3035, 8.0126) (-29.9625, 8.0666) (-29.7724, 7.9285) (-29.7184, 7.5875) (-29.8565, 7.3974) (-30.08, 7.3248) (-30.1975, 7.3434), closed, covered)
  P31_AC1_L3_h4 = polyline(z=-1.27mm, xy in mm: (-30.1975, 5.7684) (-30.3876, 5.9065) (-30.4416, 6.2475) (-30.3035, 6.4376) (-29.9625, 6.4916) (-29.7724, 6.3535) (-29.7184, 6.0125) (-29.8565, 5.8224) (-30.08, 5.7498) (-30.1975, 5.7684), closed, covered)
  P31_AC1_L3.subtract(P31_AC1_L3_h0..P31_AC1_L3_h4)
  P31_AC1_L3.sweep_along_vector((0mm, 0mm, 0.07mm))
  P32_AC2_L3 = polyline(z=-1.27mm, xy in mm: (-3.907, 5.2197) (-3.85, 5.324) (-3.85, 20.6) (-8.4402, 20.5495) (-11.5277, 20.6) (-11.85, 20.5444) (-12.8, 20.6) (-12.7803, 20.0987) (-12.6584, 20.043) (-12.4753, 20.1356) (-12.2247, 20.1356) (-12.022, 19.9883) (-11.9445, 19.75) (-12.1044, 19.4014) (-11.9445, 19) (-12.022, 18.7617) (-12.2247, 18.6144) (-12.4753, 18.6144) (-12.6496, 18.7054) (-12.7997, 18.5931) (-12.8, 15.9158) (-12.6584, 15.793) (-12.4753, 15.8856) (-12.2247, 15.8856) (-11.8447, 15.5501) (-11.4753, 15.8856) (-11.2247, 15.8856) (-11.022, 15.7383) (-10.9445, 15.5) (-11.0744, 15.1067) (-10.9445, 14.8) (-11.0794, 14.4764) (-10.9445, 14.1) (-11.0794, 13.7764) (-10.9644, 13.5253) (-10.9644, 13.2747) (-11.1117, 13.072) (-11.35, 12.9945) (-11.5883, 13.072) (-11.8553, 13.3499) (-12.1117, 13.072) (-12.35, 12.9945) (-12.5883, 13.072) (-12.8553, 13.3499) (-13.1117, 13.072) (-13.35, 12.9945) (-13.5883, 13.072) (-13.8553, 13.3499) (-14.1117, 13.072) (-14.35, 12.9945) (-14.5883, 13.072) (-14.8553, 13.3499) (-15.1117, 13.072) (-15.35, 12.9945) (-15.5883, 13.072) (-15.8553, 13.3499) (-16.1117, 13.072) (-16.35, 12.9945) (-16.5883, 13.072) (-16.8553, 13.3499) (-17.1117, 13.072) (-17.35, 12.9945) (-17.5883, 13.072) (-17.8553, 13.3499) (-18.1117, 13.072) (-18.3085, 12.9811) (-18.3303, 5.257) (-18.226, 5.2) (-3.974, 5.2) (-3.907, 5.2197), closed, covered)
  P32_AC2_L3_h0 = polyline(z=-1.27mm, xy in mm: (-9.4753, 13.0144) (-9.6781, 13.1617) (-9.7555, 13.4) (-9.6781, 13.6383) (-9.35, 13.8055) (-9.1117, 13.728) (-8.8447, 13.4501) (-8.5883, 13.728) (-8.35, 13.8055) (-8.1117, 13.728) (-7.8447, 13.4501) (-7.5883, 13.728) (-7.35, 13.8055) (-7.1117, 13.728) (-6.8447, 13.4501) (-6.4753, 13.7856) (-6.1117, 13.728) (-5.8447, 13.4501) (-5.5883, 13.728) (-5.35, 13.8055) (-5.1117, 13.728) (-4.9445, 13.4) (-5.022, 13.1617) (-5.35, 12.9945) (-5.5883, 13.072) (-5.8553, 13.3499) (-6.1117, 13.072) (-6.35, 12.9945) (-6.5883, 13.072) (-6.8553, 13.3499) (-7.1117, 13.072) (-7.35, 12.9945) (-7.5883, 13.072) (-7.8553, 13.3499) (-8.1117, 13.072) (-8.4753, 13.0144) (-8.8553, 13.3499) (-9.1117, 13.072) (-9.35, 12.9945) (-9.4753, 13.0144), closed, covered)
  P32_AC2_L3_h1 = polyline(z=-1.27mm, xy in mm: (-10.4003, 11.4144) (-10.6606, 11.6747) (-10.6606, 11.9253) (-10.5133, 12.1281) (-10.1497, 12.1856) (-9.9469, 12.0383) (-9.8695, 11.8) (-9.9469, 11.5617) (-10.275, 11.3945) (-10.4003, 11.4144), closed, covered)
  P32_AC2_L3_h2 = polyline(z=-1.27mm, xy in mm: (-17.5375, 10.3334) (-17.7276, 10.4715) (-17.7816, 10.8125) (-17.6435, 11.0026) (-17.3025, 11.0566) (-17.1124, 10.9185) (-17.0584, 10.5775) (-17.1965, 10.3874) (-17.42, 10.3148) (-17.5375, 10.3334), closed, covered)
  P32_AC2_L3_h3 = polyline(z=-1.27mm, xy in mm: (-17.5375, 7.6084) (-17.7276, 7.7465) (-17.7816, 8.0875) (-17.6435, 8.2776) (-17.3025, 8.3316) (-17.1124, 8.1935) (-17.0584, 7.8525) (-17.1965, 7.6624) (-17.42, 7.5898) (-17.5375, 7.6084), closed, covered)
  P32_AC2_L3_h4 = polyline(z=-1.27mm, xy in mm: (-17.5375, 6.0334) (-17.7276, 6.1715) (-17.7816, 6.5125) (-17.6435, 6.7026) (-17.3025, 6.7566) (-17.1124, 6.6185) (-17.0584, 6.2775) (-17.1965, 6.0874) (-17.42, 6.0148) (-17.5375, 6.0334), closed, covered)
  P32_AC2_L3.subtract(P32_AC2_L3_h0..P32_AC2_L3_h4)
  P32_AC2_L3.sweep_along_vector((0mm, 0mm, 0.07mm))
  P33_AC3_L3 = polyline(z=-1.27mm, xy in mm: (18.293, 5.2197) (18.35, 5.324) (18.3303, 12.9556) (17.8447, 13.3499) (17.5883, 13.072) (17.35, 12.9945) (17.1117, 13.072) (16.8447, 13.3499) (16.5883, 13.072) (16.35, 12.9945) (16.1117, 13.072) (15.8447, 13.3499) (15.5883, 13.072) (15.35, 12.9945) (15.1117, 13.072) (14.8447, 13.3499) (14.5883, 13.072) (14.35, 12.9945) (14.1117, 13.072) (13.8447, 13.3499) (13.5883, 13.072) (13.35, 12.9945) (13.1117, 13.072) (12.8447, 13.3499) (12.5883, 13.072) (12.35, 12.9945) (12.1117, 13.072) (11.8447, 13.3499) (11.5883, 13.072) (11.35, 12.9945) (11.1117, 13.072) (10.9644, 13.2747) (10.9644, 13.5253) (11.0794, 13.7236) (10.9445, 14.1) (11.0794, 14.4236) (10.9445, 14.8) (11.0794, 15.1236) (10.9445, 15.5) (11.022, 15.7383) (11.2247, 15.8856) (11.4753, 15.8856) (11.8553, 15.5501) (12.2247, 15.8856) (12.4753, 15.8856) (12.6496, 15.7946) (12.7997, 15.9069) (12.8, 18.5842) (12.6584, 18.707) (12.4753, 18.6144) (12.2247, 18.6144) (12.022, 18.7617) (11.9445, 19) (12.1044, 19.3486) (11.9445, 19.75) (12.022, 19.9883) (12.35, 20.1555) (12.7193, 20.0496) (12.7997, 20.1569) (12.7803, 20.4925) (12.676, 20.5495) (10.8636, 20.6) (9.31, 20.5444) (8.9877, 20.6) (3.85, 20.6) (3.8697, 5.257) (3.974, 5.2) (18.226, 5.2) (18.293, 5.2197), closed, covered)
  P33_AC3_L3_h0 = polyline(z=-1.27mm, xy in mm: (5.2247, 13.0144) (5.022, 13.1617) (4.9445, 13.4) (5.022, 13.6383) (5.35, 13.8055) (5.5883, 13.728) (5.8553, 13.4501) (6.1117, 13.728) (6.35, 13.8055) (6.5883, 13.728) (6.8553, 13.4501) (7.1117, 13.728) (7.35, 13.8055) (7.5883, 13.728) (7.8553, 13.4501) (8.1117, 13.728) (8.4753, 13.7856) (8.8553, 13.4501) (9.1117, 13.728) (9.35, 13.8055) (9.6781, 13.6383) (9.7555, 13.4) (9.6781, 13.1617) (9.35, 12.9945) (9.1117, 13.072) (8.8447, 13.3499) (8.5883, 13.072) (8.35, 12.9945) (8.1117, 13.072) (7.8447, 13.3499) (7.5883, 13.072) (7.35, 12.9945) (7.1117, 13.072) (6.8447, 13.3499) (6.5883, 13.072) (6.2247, 13.0144) (5.8447, 13.3499) (5.5883, 13.072) (5.35, 12.9945) (5.2247, 13.0144), closed, covered)
  P33_AC3_L3_h1 = polyline(z=-1.27mm, xy in mm: (10.1497, 11.4144) (9.8894, 11.6747) (9.8894, 11.9253) (10.0367, 12.1281) (10.4003, 12.1856) (10.603, 12.0383) (10.6805, 11.8) (10.603, 11.5617) (10.275, 11.3945) (10.1497, 11.4144), closed, covered)
  P33_AC3_L3_h2 = polyline(z=-1.27mm, xy in mm: (17.3025, 10.0684) (17.1124, 10.2065) (17.0584, 10.5475) (17.1965, 10.7376) (17.5375, 10.7916) (17.7276, 10.6535) (17.7816, 10.3125) (17.6435, 10.1224) (17.42, 10.0498) (17.3025, 10.0684), closed, covered)
  P33_AC3_L3_h3 = polyline(z=-1.27mm, xy in mm: (17.3025, 7.3434) (17.1124, 7.4815) (17.0584, 7.8225) (17.1965, 8.0126) (17.5375, 8.0666) (17.7276, 7.9285) (17.7816, 7.5875) (17.6435, 7.3974) (17.42, 7.3248) (17.3025, 7.3434), closed, covered)
  P33_AC3_L3_h4 = polyline(z=-1.27mm, xy in mm: (17.3025, 5.7684) (17.1124, 5.9065) (17.0584, 6.2475) (17.1965, 6.4376) (17.5375, 6.4916) (17.7276, 6.3535) (17.7816, 6.0125) (17.6435, 5.8224) (17.42, 5.7498) (17.3025, 5.7684), closed, covered)
  P33_AC3_L3.subtract(P33_AC3_L3_h0..P33_AC3_L3_h4)
  P33_AC3_L3.sweep_along_vector((0mm, 0mm, 0.07mm))
  P34_AC4_L3 = polyline(z=-1.27mm, xy in mm: (43.593, 5.2197) (43.65, 5.324) (43.65, 20.6) (39.0598, 20.5495) (35.9723, 20.6) (35.65, 20.5444) (34.7, 20.6) (34.7197, 20.0987) (34.8416, 20.043) (35.0247, 20.1356) (35.2753, 20.1356) (35.478, 19.9883) (35.5555, 19.75) (35.3956, 19.4014) (35.5555, 19) (35.478, 18.7617) (35.2753, 18.6144) (35.0247, 18.6144) (34.8504, 18.7054) (34.7003, 18.5931) (34.7, 15.9158) (34.8416, 15.793) (35.0247, 15.8856) (35.2753, 15.8856) (35.6553, 15.5501) (36.0247, 15.8856) (36.2753, 15.8856) (36.478, 15.7383) (36.5555, 15.5) (36.4256, 15.1067) (36.5555, 14.8) (36.4206, 14.4764) (36.5555, 14.1) (36.4206, 13.7764) (36.5356, 13.5253) (36.5356, 13.2747) (36.3883, 13.072) (36.15, 12.9945) (35.9117, 13.072) (35.6447, 13.3499) (35.3883, 13.072) (35.15, 12.9945) (34.9117, 13.072) (34.6447, 13.3499) (34.3883, 13.072) (34.15, 12.9945) (33.9117, 13.072) (33.6447, 13.3499) (33.3883, 13.072) (33.15, 12.9945) (32.9117, 13.072) (32.6447, 13.3499) (32.3883, 13.072) (32.15, 12.9945) (31.9117, 13.072) (31.6447, 13.3499) (31.3883, 13.072) (31.15, 12.9945) (30.9117, 13.072) (30.6447, 13.3499) (30.3883, 13.072) (30.15, 12.9945) (29.9117, 13.072) (29.6447, 13.3499) (29.3883, 13.072) (29.1915, 12.9811) (29.1697, 5.257) (29.274, 5.2) (43.526, 5.2) (43.593, 5.2197), closed, covered)
  P34_AC4_L3_h0 = polyline(z=-1.27mm, xy in mm: (38.0247, 13.0144) (37.8219, 13.1617) (37.7445, 13.4) (37.8219, 13.6383) (38.15, 13.8055) (38.3883, 13.728) (38.6553, 13.4501) (38.9117, 13.728) (39.15, 13.8055) (39.3883, 13.728) (39.6553, 13.4501) (39.9117, 13.728) (40.15, 13.8055) (40.3883, 13.728) (40.6553, 13.4501) (40.9117, 13.728) (41.2753, 13.7856) (41.6553, 13.4501) (41.9117, 13.728) (42.15, 13.8055) (42.3883, 13.728) (42.5555, 13.4) (42.478, 13.1617) (42.15, 12.9945) (41.9117, 13.072) (41.6447, 13.3499) (41.3883, 13.072) (41.15, 12.9945) (40.9117, 13.072) (40.6447, 13.3499) (40.3883, 13.072) (40.15, 12.9945) (39.9117, 13.072) (39.6447, 13.3499) (39.3883, 13.072) (39.0247, 13.0144) (38.6447, 13.3499) (38.3883, 13.072) (38.15, 12.9945) (38.0247, 13.0144), closed, covered)
  P34_AC4_L3_h1 = polyline(z=-1.27mm, xy in mm: (37.0997, 11.4144) (36.8394, 11.6747) (36.8394, 11.9253) (36.9867, 12.1281) (37.3503, 12.1856) (37.5531, 12.0383) (37.6305, 11.8) (37.5531, 11.5617) (37.225, 11.3945) (37.0997, 11.4144), closed, covered)
  P34_AC4_L3_h2 = polyline(z=-1.27mm, xy in mm: (29.9625, 10.3334) (29.7724, 10.4715) (29.7184, 10.8125) (29.8565, 11.0026) (30.1975, 11.0566) (30.3876, 10.9185) (30.4416, 10.5775) (30.3035, 10.3874) (30.08, 10.3148) (29.9625, 10.3334), closed, covered)
  P34_AC4_L3_h3 = polyline(z=-1.27mm, xy in mm: (29.9625, 7.6084) (29.7724, 7.7465) (29.7184, 8.0875) (29.8565, 8.2776) (30.1975, 8.3316) (30.3876, 8.1935) (30.4416, 7.8525) (30.3035, 7.6624) (30.08, 7.5898) (29.9625, 7.6084), closed, covered)
  P34_AC4_L3_h4 = polyline(z=-1.27mm, xy in mm: (29.9625, 6.0334) (29.7724, 6.1715) (29.7184, 6.5125) (29.8565, 6.7026) (30.1975, 6.7566) (30.3876, 6.6185) (30.4416, 6.2775) (30.3035, 6.0874) (30.08, 6.0148) (29.9625, 6.0334), closed, covered)
  P34_AC4_L3.subtract(P34_AC4_L3_h0..P34_AC4_L3_h4)
  P34_AC4_L3.sweep_along_vector((0mm, 0mm, 0.07mm))
  P35_AC1_L4 = polyline(z=-1.44mm, xy in mm: (-38.5663, 4.6189) (-38.5226, 5.0147) (-38.3971, 5.2522) (-38.1597, 5.3776) (-37.7245, 5.3805) (-37.6255, 5.4795) (-37.6444, 6.8387) (-38.2879, 6.9272) (-38.5226, 7.2453) (-38.4778, 8.0929) (-38.1293, 8.3305) (-36.1621, 8.2828) (-35.9245, 7.9343) (-35.9274, 7.2453) (-36.0862, 6.8982) (-35.9923, 6.8305) (-35.2121, 6.7828) (-34.9603, 6.4731) (-34.3987, 6.4744) (-34.1003, 6.7906) (-33.5435, 6.8055) (-33.3367, 6.7331) (-33.1745, 6.4365) (-33.1745, 5.8235) (-33.3169, 5.52) (-33.2191, 5.4055) (-32.6809, 5.4055) (-32.5867, 5.4739) (-32.7255, 5.8235) (-32.7255, 6.4365) (-32.5633, 6.7331) (-32.3565, 6.8055) (-31.7997, 6.7906) (-31.5013, 6.4744) (-31.2085, 6.4555) (-30.9782, 6.7679) (-30.7002, 6.9598) (-30.1998, 6.9598) (-29.8252, 6.6279) (-29.6703, 6.2631) (-29.6703, 5.9969) (-29.8268, 5.7815) (-30.3604, 5.6006) (-30.4354, 5.5117) (-30.374, 5.4128) (-30.0226, 5.4055) (-29.8268, 5.2925) (-29.7545, 5.1374) (-29.7356, 4.6408) (-27.0908, 4.6189) (-27.0689, 5.5587) (-28.4924, 5.5995) (-28.7779, 5.6752) (-29.1098, 6.0498) (-29.1505, 6.3851) (-28.9252, 6.82) (-28.6189, 6.9851) (-27.149, 7.0005) (-27.0548, 7.0689) (-27.05, 9.901) (-27.149, 10) (-28.35, 10) (-28.35, 14.901) (-28.4184, 14.9952) (-28.5589, 15) (-28.653, 14.9316) (-28.7587, 14.4585) (-28.6444, 14.1) (-28.7587, 13.7585) (-28.6648, 13.5425) (-28.6648, 13.2575) (-28.9399, 12.94) (-29.3601, 12.94) (-29.6276, 13.158) (-29.9399, 12.94) (-30.222, 12.8995) (-30.6276, 13.158) (-30.9399, 12.94) (-31.222, 12.8995) (-31.6276, 13.158) (-31.9399, 12.94) (-32.3581, 12.9198) (-32.4238, 12.8237) (-32.1966, 12.532) (-32.0559, 12.1523) (-32.139, 11.4408) (-31.7978, 11.3991) (-31.4898, 11.2605) (-31.1461, 10.7562) (-30.3971, 10.7555) (-29.9469, 10.8397) (-29.7315, 10.6832) (-29.6303, 10.3744) (-29.2018, 9.8066) (-28.6539, 9.786) (-28.1391, 9.5109) (-27.864, 8.9961) (-27.9097, 8.3881) (-27.4968, 8.2485) (-27.3403, 8.0331) (-27.3403, 7.7669) (-27.4968, 7.5515) (-27.75, 7.4692) (-28.0032, 7.5515) (-28.2593, 7.9585) (-28.6539, 7.814) (-29.0461, 7.814) (-29.6305, 8.1441) (-29.7545, 8.0484) (-29.6492, 7.705) (-29.7315, 7.4518) (-30.08, 7.2742) (-30.4285, 7.4518) (-30.5193, 7.7723) (-30.623, 7.8251) (-34.5524, 7.8149) (-34.9245, 7.9746) (-35.2035, 8.268) (-35.3441, 8.6477) (-35.3505, 9.0009) (-35.4385, 9.0545) (-38.7255, 9.0545) (-38.8197, 8.9861) (-38.835, 8.5272) (-38.9823, 8.2113) (-39.4222, 7.94) (-41.325, 7.9295) (-41.7437, 8.0873) (-42.015, 8.5272) (-42.0255, 9.28) (-41.9598, 9.5493) (-41.5943, 9.9148) (-40.8663, 9.9994) (-40.8255, 10.7805) (-40.8939, 10.8747) (-41.5943, 10.9452) (-41.9598, 11.3107) (-42.0255, 11.58) (-42.015, 12.3328) (-41.8677, 12.6487) (-41.4763, 12.976) (-41.6276, 13.158) (-41.9399, 12.94) (-42.3601, 12.94) (-42.6352, 13.2575) (-42.5754, 13.6734) (-42.222, 13.9005) (-41.9399, 13.86) (-41.6724, 13.642) (-41.222, 13.9005) (-40.9399, 13.86) (-40.6724, 13.642) (-40.222, 13.9005) (-39.9399, 13.86) (-39.6724, 13.642) (-39.222, 13.9005) (-38.9399, 13.86) (-38.6724, 13.642) (-38.222, 13.9005) (-37.686, 13.7332) (-37.6255, 13.8244) (-37.6255, 14.2899) (-37.7245, 14.3889) (-41.6348, 14.3889) (-42.0046, 14.5779) (-42.1161, 14.8686) (-42.1161, 16.4899) (-41.9827, 16.8) (-40.3038, 16.8) (-40.0042, 16.3934) (-39.4913, 16.2113) (-38.9958, 16.3934) (-38.5014, 17.0058) (-38.9958, 17.6066) (-39.4913, 17.7887) (-40.0042, 17.6066) (-40.3066, 17.2) (-41.9854, 17.2) (-42.1161, 17.5086) (-42.1161, 19.1299) (-42.0252, 19.3946) (-41.8249, 19.5638) (-41.6361, 19.6111) (-37.3651, 19.6111) (-37.1004, 19.5202) (-36.9129, 19.2757) (-36.8195, 18.67) (-36.8245, 15.683) (-36.7561, 15.5888) (-36.6454, 15.6248) (-36.4811, 15.8821) (-36.222, 16.0005) (-35.9399, 15.96) (-35.6724, 15.742) (-35.222, 16.0005) (-34.9399, 15.96) (-34.6724, 15.742) (-34.222, 16.0005) (-33.9399, 15.96) (-33.6724, 15.742) (-33.222, 16.0005) (-32.9399, 15.96) (-32.6724, 15.742) (-32.222, 16.0005) (-31.9399, 15.96) (-31.6724, 15.742) (-31.222, 16.0005) (-30.9399, 15.96) (-30.6724, 15.742) (-30.3601, 15.96) (-30.078, 16.0005) (-29.6115, 15.7472) (-29.15, 16.0929) (-29.15, 17.801) (-29.249, 17.9) (-34.7, 17.9) (-34.7189, 18.5711) (-34.8296, 18.6071) (-35.078, 18.4995) (-35.3601, 18.54) (-35.5754, 18.7266) (-35.6556, 19) (-35.5197, 19.3665) (-35.6556, 19.75) (-35.5754, 20.0234) (-35.222, 20.2505) (-34.7363, 20.1604) (-34.7, 20.4505) (-34.7684, 20.5447) (-43.65, 20.6) (-43.65, 4.699) (-43.551, 4.6) (-38.6245, 4.6) (-38.5663, 4.6189), closed, covered)
  P35_AC1_L4.sweep_along_vector((0mm, 0mm, 0.07mm))
  P36_AC2_L4 = polyline(z=-1.44mm, xy in mm: (-17.9369, 4.6005) (-17.7863, 4.6194) (-17.7455, 4.6995) (-17.7455, 6.0779) (-17.8297, 6.5281) (-17.6732, 6.7435) (-17.42, 6.8258) (-17.1668, 6.7435) (-17.0103, 6.5281) (-17.0945, 6.0779) (-17.0945, 5.1445) (-17.0261, 5.0503) (-11.6745, 5.0455) (-11.5803, 5.1139) (-11.5278, 5.6329) (-11.3379, 5.8228) (-9.3707, 5.8705) (-9.0222, 5.6329) (-8.9975, 4.6705) (-8.9049, 4.6) (-3.8908, 4.6189) (-3.85, 20.6) (-7.9818, 20.6) (-8.1025, 20.3925) (-8.4121, 20.2495) (-10.2675, 20.2559) (-10.5175, 20.3924) (-10.6382, 20.6) (-10.9401, 20.6) (-11.3863, 20.3261) (-11.9941, 20.1883) (-11.8444, 19.75) (-11.9803, 19.3835) (-11.8648, 19.1425) (-11.8648, 18.8575) (-12.1399, 18.54) (-12.422, 18.4995) (-12.7637, 18.5896) (-12.8, 17.9) (-18.3092, 17.8811) (-18.35, 16.0957) (-17.8724, 15.742) (-17.422, 16.0005) (-17.1399, 15.96) (-16.8724, 15.742) (-16.422, 16.0005) (-16.1399, 15.96) (-15.8724, 15.742) (-15.422, 16.0005) (-15.1399, 15.96) (-14.8724, 15.742) (-14.422, 16.0005) (-14.1399, 15.96) (-13.8724, 15.742) (-13.422, 16.0005) (-13.1399, 15.96) (-12.8724, 15.742) (-12.422, 16.0005) (-12.1399, 15.96) (-11.8724, 15.742) (-11.5601, 15.96) (-11.278, 16.0005) (-11.0189, 15.8821) (-10.7632, 15.5846) (-10.6755, 15.683) (-10.6805, 18.67) (-10.578, 19.2978) (-10.4269, 19.4997) (-10.1361, 19.6111) (-5.6972, 19.573) (-5.4953, 19.4219) (-5.3839, 19.1314) (-5.3839, 17.5102) (-5.5173, 17.2) (-7.1962, 17.2) (-7.4958, 17.6066) (-8.0087, 17.7887) (-8.5042, 17.6066) (-8.9986, 16.9942) (-8.5042, 16.3934) (-8.0087, 16.2113) (-7.4958, 16.3934) (-7.1934, 16.8) (-5.5147, 16.8) (-5.3839, 16.4914) (-5.3839, 14.8702) (-5.4747, 14.6056) (-5.8639, 14.3889) (-9.7755, 14.3889) (-9.8697, 14.3204) (-9.8745, 13.8244) (-9.7449, 13.7303) (-9.5601, 13.86) (-9.278, 13.9005) (-8.8724, 13.642) (-8.5601, 13.86) (-8.278, 13.9005) (-7.8724, 13.642) (-7.5601, 13.86) (-7.278, 13.9005) (-6.8724, 13.642) (-6.5601, 13.86) (-6.278, 13.9005) (-5.8724, 13.642) (-5.5601, 13.86) (-5.278, 13.9005) (-4.9246, 13.6734) (-4.8444, 13.4) (-4.9246, 13.1266) (-5.278, 12.8995) (-5.5601, 12.94) (-5.8276, 13.158) (-6.278, 12.8995) (-6.5601, 12.94) (-6.8276, 13.158) (-7.278, 12.8995) (-7.5601, 12.94) (-7.8276, 13.158) (-8.278, 12.8995) (-8.5601, 12.94) (-8.8276, 13.158) (-9.278, 12.8995) (-9.814, 13.0668) (-9.8745, 12.9756) (-9.8745, 12.139) (-9.7898, 11.6575) (-10.0649, 11.34) (-10.347, 11.2995) (-10.6061, 11.4179) (-10.7602, 11.6575) (-10.6755, 12.139) (-10.6755, 13.217) (-10.7439, 13.3112) (-10.8546, 13.2752) (-11.0189, 13.0179) (-11.278, 12.8995) (-11.5601, 12.94) (-11.8276, 13.158) (-12.278, 12.8995) (-12.5601, 12.94) (-12.8276, 13.158) (-13.278, 12.8995) (-13.5601, 12.94) (-13.8276, 13.158) (-14.278, 12.8995) (-14.5601, 12.94) (-14.8276, 13.158) (-15.278, 12.8995) (-15.5601, 12.94) (-15.8276, 13.158) (-16.278, 12.8995) (-16.5601, 12.94) (-16.8276, 13.158) (-17.278, 12.8995) (-17.5601, 12.94) (-17.8276, 13.158) (-18.1399, 12.94) (-18.422, 12.8995) (-18.6811, 13.0179) (-18.8352, 13.2575) (-18.8352, 13.5425) (-18.7413, 13.7415) (-18.8556, 14.1) (-18.7413, 14.4415) (-18.8536, 14.9472) (-19.1092, 14.9811) (-19.15, 10.3255) (-19.0816, 10.2313) (-18.45, 10.4053) (-17.7759, 10.2517) (-17.8297, 10.8281) (-17.6732, 11.0435) (-17.42, 11.1258) (-17.1668, 11.0435) (-17.0103, 10.8281) (-17.0945, 10.3779) (-17.0261, 10.2658) (-16.5517, 10.4005) (-12.8993, 10.4005) (-12.5534, 10.3242) (-12.0966, 9.932) (-11.9284, 9.3823) (-11.8513, 9.3455) (-8.7745, 9.3455) (-8.6803, 9.4139) (-8.665, 9.8728) (-8.5177, 10.1887) (-8.2443, 10.4048) (-7.975, 10.4705) (-6.0722, 10.46) (-5.7563, 10.3127) (-5.485, 9.8728) (-5.485, 9.0172) (-5.6323, 8.7013) (-5.9057, 8.4852) (-6.5755, 8.4195) (-6.6745, 8.3205) (-6.6556, 7.5613) (-5.9057, 7.4548) (-5.5402, 7.0893) (-5.4745, 6.82) (-5.5402, 5.9007) (-5.7563, 5.6273) (-6.0722, 5.48) (-7.975, 5.4695) (-8.3937, 5.6273) (-8.6098, 5.9007) (-8.6843, 6.9203) (-9.3437, 7.1273) (-9.7014, 7.644) (-12.7344, 7.6445) (-13.0898, 7.1395) (-13.3978, 7.0009) (-14.0522, 7.0009) (-14.5345, 7.2871) (-15.0478, 7.0009) (-15.7022, 7.0009) (-16.1305, 7.2598) (-16.2984, 7.6182) (-17.1029, 7.6445) (-17.5531, 7.5603) (-17.7685, 7.7168) (-17.8614, 8.0239) (-18.1692, 8.4208) (-18.6461, 8.414) (-19.0085, 8.5641) (-19.2859, 8.8415) (-19.436, 9.2039) (-19.3576, 9.9696) (-20.4092, 9.9811) (-20.4311, 4.6413) (-17.9452, 4.6) (-17.9369, 4.6005), closed, covered)
  P36_AC2_L4.sweep_along_vector((0mm, 0mm, 0.07mm))
  P37_AC3_L4 = polyline(z=-1.44mm, xy in mm: (8.9337, 4.6189) (8.9774, 5.0147) (9.1028, 5.2522) (9.3403, 5.3776) (9.7755, 5.3805) (9.8745, 5.4795) (9.8556, 6.8387) (9.2121, 6.9272) (8.9774, 7.2453) (9.0222, 8.0929) (9.3707, 8.3305) (11.3379, 8.2828) (11.5755, 7.9343) (11.5726, 7.2453) (11.4138, 6.8982) (11.5077, 6.8305) (12.2879, 6.7828) (12.5397, 6.4731) (13.1013, 6.4744) (13.3997, 6.7906) (13.9565, 6.8055) (14.1633, 6.7331) (14.3255, 6.4365) (14.3255, 5.8235) (14.1831, 5.52) (14.236, 5.4163) (14.8191, 5.4055) (14.9133, 5.4739) (14.7745, 5.8235) (14.7745, 6.4365) (14.9367, 6.7331) (15.1435, 6.8055) (15.7003, 6.7906) (15.9987, 6.4744) (16.1923, 6.4555) (16.5998, 6.7598) (16.9351, 6.8005) (17.6732, 6.4785) (17.8297, 6.2631) (17.7685, 5.8768) (17.2868, 5.5259) (17.3333, 5.4192) (17.533, 5.3906) (17.7062, 5.2453) (17.7455, 4.699) (17.8139, 4.6048) (20.4092, 4.6189) (20.45, 5.3005) (20.3816, 5.3947) (18.6811, 5.4149) (18.2693, 5.6991) (18.1495, 6.1851) (18.2693, 6.5009) (18.6811, 6.7851) (20.351, 6.8005) (20.4452, 6.8689) (20.45, 9.901) (20.351, 10) (19.15, 10) (19.15, 14.901) (19.0816, 14.9952) (18.9411, 15) (18.847, 14.9316) (18.7413, 14.4585) (18.8556, 14.1) (18.7413, 13.7585) (18.8352, 13.5425) (18.8352, 13.2575) (18.5601, 12.94) (18.1399, 12.94) (17.8724, 13.158) (17.5601, 12.94) (17.278, 12.8995) (16.8724, 13.158) (16.5601, 12.94) (16.278, 12.8995) (15.8724, 13.158) (15.5601, 12.94) (15.1419, 12.9198) (15.0762, 12.8237) (15.3034, 12.532) (15.4441, 12.1523) (15.361, 11.4408) (15.7022, 11.3991) (16.0102, 11.2605) (16.3539, 10.7562) (17.1029, 10.7555) (17.5531, 10.8397) (17.7685, 10.6832) (17.8697, 10.3744) (18.2982, 9.8066) (18.8461, 9.786) (19.3609, 9.5109) (19.636, 8.9961) (19.5903, 8.3881) (20.0032, 8.2485) (20.1597, 8.0331) (20.1597, 7.7669) (20.0032, 7.5515) (19.75, 7.4692) (19.4968, 7.5515) (19.2407, 7.9585) (18.8461, 7.814) (18.4539, 7.814) (17.8695, 8.1441) (17.7455, 8.0484) (17.8508, 7.705) (17.7685, 7.4518) (17.42, 7.2742) (17.0715, 7.4518) (16.9807, 7.7723) (16.877, 7.8251) (12.9476, 7.8149) (12.5755, 7.9746) (12.2965, 8.268) (12.1559, 8.6477) (12.1495, 9.0009) (12.0615, 9.0545) (8.7745, 9.0545) (8.6803, 8.9861) (8.665, 8.5272) (8.5177, 8.2113) (8.0778, 7.94) (6.175, 7.9295) (5.7563, 8.0873) (5.485, 8.5272) (5.4745, 9.28) (5.5402, 9.5493) (5.9057, 9.9148) (6.6337, 9.9994) (6.6745, 10.7805) (6.6061, 10.8747) (5.9057, 10.9452) (5.5402, 11.3107) (5.4745, 11.58) (5.485, 12.3328) (5.6323, 12.6487) (6.0237, 12.976) (5.8724, 13.158) (5.5601, 12.94) (5.1399, 12.94) (4.8648, 13.2575) (4.9246, 13.6734) (5.278, 13.9005) (5.5601, 13.86) (5.8276, 13.642) (6.278, 13.9005) (6.5601, 13.86) (6.8276, 13.642) (7.278, 13.9005) (7.5601, 13.86) (7.8276, 13.642) (8.278, 13.9005) (8.5601, 13.86) (8.8276, 13.642) (9.278, 13.9005) (9.814, 13.7332) (9.8745, 13.8244) (9.8745, 14.2899) (9.7755, 14.3889) (5.8652, 14.3889) (5.4954, 14.5779) (5.3839, 14.8686) (5.3839, 16.4899) (5.5173, 16.8) (7.1962, 16.8) (7.4958, 16.3934) (8.0087, 16.2113) (8.5042, 16.3934) (8.9986, 17.0058) (8.5042, 17.6066) (8.0087, 17.7887) (7.4958, 17.6066) (7.1934, 17.2) (5.5146, 17.2) (5.3839, 17.5086) (5.3839, 19.1299) (5.4748, 19.3946) (5.6751, 19.5638) (5.8639, 19.6111) (10.1349, 19.6111) (10.3996, 19.5202) (10.5871, 19.2757) (10.6805, 18.67) (10.6755, 15.683) (10.7439, 15.5888) (10.8546, 15.6248) (11.0189, 15.8821) (11.278, 16.0005) (11.5601, 15.96) (11.8276, 15.742) (12.278, 16.0005) (12.5601, 15.96) (12.8276, 15.742) (13.278, 16.0005) (13.5601, 15.96) (13.8276, 15.742) (14.278, 16.0005) (14.5601, 15.96) (14.8276, 15.742) (15.278, 16.0005) (15.5601, 15.96) (15.8276, 15.742) (16.278, 16.0005) (16.5601, 15.96) (16.8276, 15.742) (17.1399, 15.96) (17.422, 16.0005) (17.8885, 15.7472) (18.35, 16.0929) (18.35, 17.801) (18.251, 17.9) (12.8, 17.9) (12.7811, 18.5711) (12.6704, 18.6071) (12.422, 18.4995) (12.1399, 18.54) (11.9246, 18.7266) (11.8444, 19) (11.9803, 19.3665) (11.8444, 19.75) (11.9246, 20.0234) (12.278, 20.2505) (12.7637, 20.1604) (12.8, 20.4505) (12.7316, 20.5447) (3.85, 20.6) (3.85, 4.699) (3.949, 4.6) (8.8755, 4.6) (8.9337, 4.6189), closed, covered)
  P37_AC3_L4.sweep_along_vector((0mm, 0mm, 0.07mm))
  P38_AC4_L4 = polyline(z=-1.44mm, xy in mm: (29.5631, 4.6005) (29.7137, 4.6194) (29.7545, 4.6995) (29.7545, 6.0779) (29.6703, 6.5281) (29.8268, 6.7435) (30.08, 6.8258) (30.3332, 6.7435) (30.4897, 6.5281) (30.4055, 6.0779) (30.4055, 5.1445) (30.4739, 5.0503) (35.8255, 5.0455) (35.9197, 5.1139) (35.9722, 5.6329) (36.1621, 5.8228) (38.1293, 5.8705) (38.4778, 5.6329) (38.5025, 4.6705) (38.5951, 4.6) (43.6092, 4.6189) (43.65, 20.6) (39.5182, 20.6) (39.3975, 20.3925) (39.0879, 20.2495) (37.2325, 20.2559) (36.9825, 20.3924) (36.8618, 20.6) (36.5599, 20.6) (36.1137, 20.3261) (35.5059, 20.1883) (35.6556, 19.75) (35.5197, 19.3835) (35.6352, 19.1425) (35.6352, 18.8575) (35.3601, 18.54) (35.078, 18.4995) (34.7363, 18.5896) (34.7, 17.9) (29.1908, 17.8811) (29.15, 16.0957) (29.6276, 15.742) (30.078, 16.0005) (30.3601, 15.96) (30.6276, 15.742) (31.078, 16.0005) (31.3601, 15.96) (31.6276, 15.742) (32.078, 16.0005) (32.3601, 15.96) (32.6276, 15.742) (33.078, 16.0005) (33.3601, 15.96) (33.6276, 15.742) (34.078, 16.0005) (34.3601, 15.96) (34.6276, 15.742) (35.078, 16.0005) (35.3601, 15.96) (35.6276, 15.742) (35.9399, 15.96) (36.222, 16.0005) (36.4811, 15.8821) (36.7368, 15.5846) (36.8245, 15.683) (36.8195, 18.67) (36.922, 19.2978) (37.0731, 19.4997) (37.3639, 19.6111) (41.8028, 19.573) (42.0047, 19.4219) (42.1161, 19.1314) (42.1161, 17.5102) (41.9827, 17.2) (40.3038, 17.2) (40.0042, 17.6066) (39.4913, 17.7887) (38.9958, 17.6066) (38.5014, 16.9942) (38.9958, 16.3934) (39.4913, 16.2113) (40.0042, 16.3934) (40.3066, 16.8) (41.9853, 16.8) (42.1161, 16.4914) (42.1161, 14.8702) (42.0253, 14.6056) (41.6361, 14.3889) (37.7245, 14.3889) (37.6303, 14.3204) (37.6255, 13.8244) (37.7551, 13.7303) (37.9399, 13.86) (38.222, 13.9005) (38.6276, 13.642) (38.9399, 13.86) (39.222, 13.9005) (39.6276, 13.642) (39.9399, 13.86) (40.222, 13.9005) (40.6276, 13.642) (40.9399, 13.86) (41.222, 13.9005) (41.6276, 13.642) (41.9399, 13.86) (42.222, 13.9005) (42.5754, 13.6734) (42.6556, 13.4) (42.5754, 13.1266) (42.222, 12.8995) (41.9399, 12.94) (41.6724, 13.158) (41.222, 12.8995) (40.9399, 12.94) (40.6724, 13.158) (40.222, 12.8995) (39.9399, 12.94) (39.6724, 13.158) (39.222, 12.8995) (38.9399, 12.94) (38.6724, 13.158) (38.222, 12.8995) (37.686, 13.0668) (37.6255, 12.9756) (37.6255, 12.139) (37.7102, 11.6575) (37.4351, 11.34) (37.153, 11.2995) (36.8939, 11.4179) (36.7398, 11.6575) (36.8245, 12.139) (36.8245, 13.217) (36.7561, 13.3112) (36.6454, 13.2752) (36.4811, 13.0179) (36.222, 12.8995) (35.9399, 12.94) (35.6724, 13.158) (35.222, 12.8995) (34.9399, 12.94) (34.6724, 13.158) (34.222, 12.8995) (33.9399, 12.94) (33.6724, 13.158) (33.222, 12.8995) (32.9399, 12.94) (32.6724, 13.158) (32.222, 12.8995) (31.9399, 12.94) (31.6724, 13.158) (31.222, 12.8995) (30.9399, 12.94) (30.6724, 13.158) (30.222, 12.8995) (29.9399, 12.94) (29.6724, 13.158) (29.3601, 12.94) (29.078, 12.8995) (28.8189, 13.0179) (28.6648, 13.2575) (28.6648, 13.5425) (28.7587, 13.7415) (28.6444, 14.1) (28.7587, 14.4415) (28.6464, 14.9472) (28.3908, 14.9811) (28.35, 10.3255) (28.4184, 10.2313) (29.05, 10.4053) (29.7241, 10.2517) (29.6703, 10.8281) (29.8268, 11.0435) (30.08, 11.1258) (30.3332, 11.0435) (30.4897, 10.8281) (30.4055, 10.3779) (30.4739, 10.2658) (30.9483, 10.4005) (34.6007, 10.4005) (34.9466, 10.3242) (35.4034, 9.932) (35.5716, 9.3823) (35.6487, 9.3455) (38.7255, 9.3455) (38.8197, 9.4139) (38.835, 9.8728) (38.9823, 10.1887) (39.2557, 10.4048) (39.525, 10.4705) (41.4278, 10.46) (41.7437, 10.3127) (42.015, 9.8728) (42.015, 9.0172) (41.8677, 8.7013) (41.5943, 8.4852) (40.9245, 8.4195) (40.8255, 8.3205) (40.8444, 7.5613) (41.5943, 7.4548) (41.9598, 7.0893) (42.0255, 6.82) (41.9598, 5.9007) (41.7437, 5.6273) (41.4278, 5.48) (39.525, 5.4695) (39.1063, 5.6273) (38.8902, 5.9007) (38.8157, 6.9203) (38.1563, 7.1273) (37.7986, 7.644) (34.7656, 7.6445) (34.4102, 7.1395) (34.1022, 7.0009) (33.4478, 7.0009) (32.9655, 7.2871) (32.4522, 7.0009) (31.7978, 7.0009) (31.3695, 7.2598) (31.2016, 7.6182) (30.3971, 7.6445) (29.9469, 7.5603) (29.7315, 7.7168) (29.6386, 8.0239) (29.3308, 8.4208) (28.8539, 8.414) (28.4915, 8.5641) (28.2141, 8.8415) (28.064, 9.2039) (28.1424, 9.9696) (27.0908, 9.9811) (27.0689, 4.6413) (29.5548, 4.6) (29.5631, 4.6005), closed, covered)
  P38_AC4_L4.sweep_along_vector((0mm, 0mm, 0.07mm))
  V0_DCP = cylinder(axis=Z, base_centre=(-15.6mm, 2.5mm, -1.44mm), radius=0.15mm, height=1.68mm)
  V1_DCP = cylinder(axis=Z, base_centre=(-18.3mm, 2.5mm, -1.44mm), radius=0.15mm, height=1.68mm)
  V2_DCP = cylinder(axis=Z, base_centre=(-12.9mm, 2.5mm, -1.44mm), radius=0.15mm, height=1.68mm)
  V3_DCP = cylinder(axis=Z, base_centre=(32.8mm, 2.5mm, -1.44mm), radius=0.15mm, height=1.68mm)
  V4_DCP = cylinder(axis=Z, base_centre=(29.2mm, 2.5mm, -1.44mm), radius=0.15mm, height=1.68mm)
  V5_DCP = cylinder(axis=Z, base_centre=(12mm, 2.5mm, -1.44mm), radius=0.15mm, height=1.68mm)
  V6_DCP = cylinder(axis=Z, base_centre=(-31.9mm, 2.5mm, -1.44mm), radius=0.15mm, height=1.68mm)
  V7_DCP = cylinder(axis=Z, base_centre=(31.9mm, 2.5mm, -1.44mm), radius=0.15mm, height=1.68mm)
  V8_DCP = cylinder(axis=Z, base_centre=(15.6mm, 2.5mm, -1.44mm), radius=0.15mm, height=1.68mm)
  V9_DCP = cylinder(axis=Z, base_centre=(13.8mm, 2.5mm, -1.44mm), radius=0.15mm, height=1.68mm)
  V10_DCP = cylinder(axis=Z, base_centre=(-12mm, 2.5mm, -1.44mm), radius=0.15mm, height=1.68mm)
  V11_DCP = cylinder(axis=Z, base_centre=(-16.5mm, 2.5mm, -1.44mm), radius=0.15mm, height=1.68mm)
  V12_DCP = cylinder(axis=Z, base_centre=(-29.2mm, 2.5mm, -1.44mm), radius=0.15mm, height=1.68mm)
  V13_DCP = cylinder(axis=Z, base_centre=(-31mm, 2.5mm, -1.44mm), radius=0.15mm, height=1.68mm)
  V14_DCP = cylinder(axis=Z, base_centre=(-32.8mm, 2.5mm, -1.44mm), radius=0.15mm, height=1.68mm)
  V15_DCP = cylinder(axis=Z, base_centre=(31mm, 2.5mm, -1.44mm), radius=0.15mm, height=1.68mm)
  V16_DCP = cylinder(axis=Z, base_centre=(18.3mm, 2.5mm, -1.44mm), radius=0.15mm, height=1.68mm)
  V17_DCP = cylinder(axis=Z, base_centre=(14.7mm, 2.5mm, -1.44mm), radius=0.15mm, height=1.68mm)
  V18_DCP = cylinder(axis=Z, base_centre=(34.6mm, 2.5mm, -1.44mm), radius=0.15mm, height=1.68mm)
  V19_DCP = cylinder(axis=Z, base_centre=(-13.8mm, 2.5mm, -1.44mm), radius=0.15mm, height=1.68mm)
  V20_DCP = cylinder(axis=Z, base_centre=(30.1mm, 2.5mm, -1.44mm), radius=0.15mm, height=1.68mm)
  V21_DCP = cylinder(axis=Z, base_centre=(12.9mm, 2.5mm, -1.44mm), radius=0.15mm, height=1.68mm)
  V22_DCP = cylinder(axis=Z, base_centre=(-14.7mm, 2.5mm, -1.44mm), radius=0.15mm, height=1.68mm)
  V23_DCP = cylinder(axis=Z, base_centre=(-35.5mm, 2.5mm, -1.44mm), radius=0.15mm, height=1.68mm)
  V24_DCP = cylinder(axis=Z, base_centre=(17.4mm, 2.5mm, -1.44mm), radius=0.15mm, height=1.68mm)
  V25_DCP = cylinder(axis=Z, base_centre=(-34.6mm, 2.5mm, -1.44mm), radius=0.15mm, height=1.68mm)
  V26_DCP = cylinder(axis=Z, base_centre=(35.5mm, 2.5mm, -1.44mm), radius=0.15mm, height=1.68mm)
  V27_DCP = cylinder(axis=Z, base_centre=(16.5mm, 2.5mm, -1.44mm), radius=0.15mm, height=1.68mm)
  V28_DCP = cylinder(axis=Z, base_centre=(-30.1mm, 2.5mm, -1.44mm), radius=0.15mm, height=1.68mm)
  V29_DCP = cylinder(axis=Z, base_centre=(-33.7mm, 2.5mm, -1.44mm), radius=0.15mm, height=1.68mm)
  V30_DCP = cylinder(axis=Z, base_centre=(33.7mm, 2.5mm, -1.44mm), radius=0.15mm, height=1.68mm)
  V31_DCP = cylinder(axis=Z, base_centre=(-17.4mm, 2.5mm, -1.44mm), radius=0.15mm, height=1.68mm)
  V32_DCN = cylinder(axis=Z, base_centre=(-15.35mm, 14.1mm, -1.44mm), radius=0.15mm, height=1.68mm)
  V33_DCN = cylinder(axis=Z, base_centre=(33.2269mm, -0.5mm, -1.44mm), radius=0.15mm, height=1.68mm)
  V34_DCN = cylinder(axis=Z, base_centre=(35.15mm, 13.4mm, -1.44mm), radius=0.15mm, height=1.68mm)
  V35_DCN = cylinder(axis=Z, base_centre=(15.35mm, 15.5mm, -1.44mm), radius=0.15mm, height=1.68mm)
  V36_DCN = cylinder(axis=Z, base_centre=(-33.15mm, 15.5mm, -1.44mm), radius=0.15mm, height=1.68mm)
  V37_DCN = cylinder(axis=Z, base_centre=(-32.15mm, 13.4mm, -1.44mm), radius=0.15mm, height=1.68mm)
  V38_DCN = cylinder(axis=Z, base_centre=(39.15mm, 13.4mm, -1.44mm), radius=0.15mm, height=1.68mm)
  V39_DCN = cylinder(axis=Z, base_centre=(-33.2269mm, -0.5mm, -1.44mm), radius=0.15mm, height=1.68mm)
  V40_DCN = cylinder(axis=Z, base_centre=(-31.15mm, 14.1mm, -1.44mm), radius=0.15mm, height=1.68mm)
  V41_DCN = cylinder(axis=Z, base_centre=(-17.35mm, 13.4mm, -1.44mm), radius=0.15mm, height=1.68mm)
  V42_DCN = cylinder(axis=Z, base_centre=(14.35mm, 15.5mm, -1.44mm), radius=0.15mm, height=1.68mm)
  V43_DCN = cylinder(axis=Z, base_centre=(-26.1192mm, -0.5mm, -1.44mm), radius=0.15mm, height=1.68mm)
  V44_DCN = cylinder(axis=Z, base_centre=(-32.15mm, 15.5mm, -1.44mm), radius=0.15mm, height=1.68mm)
  V45_DCN = cylinder(axis=Z, base_centre=(-19.0115mm, -0.5mm, -1.44mm), radius=0.15mm, height=1.68mm)
  V46_DCN = cylinder(axis=Z, base_centre=(-17.8269mm, -0.5mm, -1.44mm), radius=0.15mm, height=1.68mm)
  V47_DCN = cylinder(axis=Z, base_centre=(-34.15mm, 14.8mm, -1.44mm), radius=0.15mm, height=1.68mm)
  V48_DCN = cylinder(axis=Z, base_centre=(-29.6731mm, -0.5mm, -1.44mm), radius=0.15mm, height=1.68mm)
  V49_DCN = cylinder(axis=Z, base_centre=(18.35mm, 15.5mm, -1.44mm), radius=0.15mm, height=1.68mm)
  V50_DCN = cylinder(axis=Z, base_centre=(-37.9654mm, -0.5mm, -1.44mm), radius=0.15mm, height=1.68mm)
  V51_DCN = cylinder(axis=Z, base_centre=(-41.15mm, 13.4mm, -1.44mm), radius=0.15mm, height=1.68mm)
  V52_DCN = cylinder(axis=Z, base_centre=(-15.35mm, 14.8mm, -1.44mm), radius=0.15mm, height=1.68mm)
  V53_DCN = cylinder(axis=Z, base_centre=(7.35mm, 13.4mm, -1.44mm), radius=0.15mm, height=1.68mm)
  V54_DCN = cylinder(axis=Z, base_centre=(31.15mm, 13.4mm, -1.44mm), radius=0.15mm, height=1.68mm)
  V55_DCN = cylinder(axis=Z, base_centre=(-34.15mm, 13.4mm, -1.44mm), radius=0.15mm, height=1.68mm)
  V56_DCN = cylinder(axis=Z, base_centre=(33.15mm, 14.1mm, -1.44mm), radius=0.15mm, height=1.68mm)
  V57_DCN = cylinder(axis=Z, base_centre=(10.7192mm, -0.5mm, -1.44mm), radius=0.15mm, height=1.68mm)
  V58_DCN = cylinder(axis=Z, base_centre=(-8.35mm, 13.4mm, -1.44mm), radius=0.15mm, height=1.68mm)
  V59_DCN = cylinder(axis=Z, base_centre=(16.35mm, 13.4mm, -1.44mm), radius=0.15mm, height=1.68mm)
  V60_DCN = cylinder(axis=Z, base_centre=(-4.75mm, -0.5mm, -1.44mm), radius=0.15mm, height=1.68mm)
  V61_DCN = cylinder(axis=Z, base_centre=(-11.35mm, 13.4mm, -1.44mm), radius=0.15mm, height=1.68mm)
  V62_DCN = cylinder(axis=Z, base_centre=(11.35mm, 13.4mm, -1.44mm), radius=0.15mm, height=1.68mm)
  V63_DCN = cylinder(axis=Z, base_centre=(-34.15mm, 15.5mm, -1.44mm), radius=0.15mm, height=1.68mm)
  V64_DCN = cylinder(axis=Z, base_centre=(34.15mm, 13.4mm, -1.44mm), radius=0.15mm, height=1.68mm)
  V65_DCN = cylinder(axis=Z, base_centre=(28.4885mm, -0.5mm, -1.44mm), radius=0.15mm, height=1.68mm)
  V66_DCN = cylinder(axis=Z, base_centre=(31.15mm, 14.1mm, -1.44mm), radius=0.15mm, height=1.68mm)
  V67_DCN = cylinder(axis=Z, base_centre=(-13.35mm, 13.4mm, -1.44mm), radius=0.15mm, height=1.68mm)
  V68_DCN = cylinder(axis=Z, base_centre=(17.35mm, 15.5mm, -1.44mm), radius=0.15mm, height=1.68mm)
  V69_DCN = cylinder(axis=Z, base_centre=(34.15mm, 14.8mm, -1.44mm), radius=0.15mm, height=1.68mm)
  V70_DCN = cylinder(axis=Z, base_centre=(-29.15mm, 13.4mm, -1.44mm), radius=0.15mm, height=1.68mm)
  V71_DCN = cylinder(axis=Z, base_centre=(1.25mm, -0.5mm, -1.44mm), radius=0.15mm, height=1.68mm)
  V72_DCN = cylinder(axis=Z, base_centre=(-33.15mm, 13.4mm, -1.44mm), radius=0.15mm, height=1.68mm)
  V73_DCN = cylinder(axis=Z, base_centre=(30.15mm, 13.4mm, -1.44mm), radius=0.15mm, height=1.68mm)
  V74_DCN = cylinder(axis=Z, base_centre=(-5.35mm, 13.4mm, -1.44mm), radius=0.15mm, height=1.68mm)
  V75_DCN = cylinder(axis=Z, base_centre=(11.9038mm, -0.5mm, -1.44mm), radius=0.15mm, height=1.68mm)
  V76_DCN = cylinder(axis=Z, base_centre=(18.35mm, 14.8mm, -1.44mm), radius=0.15mm, height=1.68mm)
  V77_DCN = cylinder(axis=Z, base_centre=(29.15mm, 14.8mm, -1.44mm), radius=0.15mm, height=1.68mm)
  V78_DCN = cylinder(axis=Z, base_centre=(19.0115mm, -0.5mm, -1.44mm), radius=0.15mm, height=1.68mm)
  V79_DCN = cylinder(axis=Z, base_centre=(-8.35mm, -0.5mm, -1.44mm), radius=0.15mm, height=1.68mm)
  V80_DCN = cylinder(axis=Z, base_centre=(-11.35mm, 14.1mm, -1.44mm), radius=0.15mm, height=1.68mm)
  V81_DCN = cylinder(axis=Z, base_centre=(12.35mm, 13.4mm, -1.44mm), radius=0.15mm, height=1.68mm)
  V82_DCN = cylinder(axis=Z, base_centre=(12.35mm, 14.1mm, -1.44mm), radius=0.15mm, height=1.68mm)
  V83_DCN = cylinder(axis=Z, base_centre=(-14.35mm, 14.1mm, -1.44mm), radius=0.15mm, height=1.68mm)
  V84_DCN = cylinder(axis=Z, base_centre=(-40.15mm, 13.4mm, -1.44mm), radius=0.15mm, height=1.68mm)
  V85_DCN = cylinder(axis=Z, base_centre=(-6.35mm, 13.4mm, -1.44mm), radius=0.15mm, height=1.68mm)
  V86_DCN = cylinder(axis=Z, base_centre=(-33.15mm, 14.8mm, -1.44mm), radius=0.15mm, height=1.68mm)
  V87_DCN = cylinder(axis=Z, base_centre=(36.15mm, 14.8mm, -1.44mm), radius=0.15mm, height=1.68mm)
  V88_DCN = cylinder(axis=Z, base_centre=(22.5654mm, -0.5mm, -1.44mm), radius=0.15mm, height=1.68mm)
  V89_DCN = cylinder(axis=Z, base_centre=(20.1962mm, -0.5mm, -1.44mm), radius=0.15mm, height=1.68mm)
  V90_DCN = cylinder(axis=Z, base_centre=(8.35mm, -0.5mm, -1.44mm), radius=0.15mm, height=1.68mm)
  V91_DCN = cylinder(axis=Z, base_centre=(14.35mm, 14.1mm, -1.44mm), radius=0.15mm, height=1.68mm)
  V92_DCN = cylinder(axis=Z, base_centre=(-30.15mm, 15.5mm, -1.44mm), radius=0.15mm, height=1.68mm)
  V93_DCN = cylinder(axis=Z, base_centre=(39.15mm, -0.5mm, -1.44mm), radius=0.15mm, height=1.68mm)
  V94_DCN = cylinder(axis=Z, base_centre=(6.35mm, 13.4mm, -1.44mm), radius=0.15mm, height=1.68mm)
  V95_DCN = cylinder(axis=Z, base_centre=(-14.2731mm, -0.5mm, -1.44mm), radius=0.15mm, height=1.68mm)
  V96_DCN = cylinder(axis=Z, base_centre=(30.8577mm, -0.5mm, -1.44mm), radius=0.15mm, height=1.68mm)
  V97_DCN = cylinder(axis=Z, base_centre=(29.15mm, 13.4mm, -1.44mm), radius=0.15mm, height=1.68mm)
  V98_DCN = cylinder(axis=Z, base_centre=(-10.7192mm, -0.5mm, -1.44mm), radius=0.15mm, height=1.68mm)
  V99_DCN = cylinder(axis=Z, base_centre=(32.0423mm, -0.5mm, -1.44mm), radius=0.15mm, height=1.68mm)
  V100_DCN = cylinder(axis=Z, base_centre=(30.15mm, 14.1mm, -1.44mm), radius=0.15mm, height=1.68mm)
  V101_DCN = cylinder(axis=Z, base_centre=(-12.35mm, 13.4mm, -1.44mm), radius=0.15mm, height=1.68mm)
  V102_DCN = cylinder(axis=Z, base_centre=(13.0885mm, -0.5mm, -1.44mm), radius=0.15mm, height=1.68mm)
  V103_DCN = cylinder(axis=Z, base_centre=(12.35mm, 19.75mm, -1.44mm), radius=0.15mm, height=1.68mm)
  V104_DCN = cylinder(axis=Z, base_centre=(6.05mm, -0.5mm, -1.44mm), radius=0.15mm, height=1.68mm)
  V105_DCN = cylinder(axis=Z, base_centre=(17.8269mm, -0.5mm, -1.44mm), radius=0.15mm, height=1.68mm)
  V106_DCN = cylinder(axis=Z, base_centre=(35.5962mm, -0.5mm, -1.44mm), radius=0.15mm, height=1.68mm)
  V107_DCN = cylinder(axis=Z, base_centre=(-31.15mm, 15.5mm, -1.44mm), radius=0.15mm, height=1.68mm)
  V108_DCN = cylinder(axis=Z, base_centre=(-13.35mm, 14.8mm, -1.44mm), radius=0.15mm, height=1.68mm)
  V109_DCN = cylinder(axis=Z, base_centre=(29.6731mm, -0.5mm, -1.44mm), radius=0.15mm, height=1.68mm)
  V110_DCN = cylinder(axis=Z, base_centre=(13.35mm, 15.5mm, -1.44mm), radius=0.15mm, height=1.68mm)
  V111_DCN = cylinder(axis=Z, base_centre=(-16.35mm, 13.4mm, -1.44mm), radius=0.15mm, height=1.68mm)
  V112_DCN = cylinder(axis=Z, base_centre=(-16.6423mm, -0.5mm, -1.44mm), radius=0.15mm, height=1.68mm)
  V113_DCN = cylinder(axis=Z, base_centre=(-9.5346mm, -0.5mm, -1.44mm), radius=0.15mm, height=1.68mm)
  V114_DCN = cylinder(axis=Z, base_centre=(-22.5654mm, -0.5mm, -1.44mm), radius=0.15mm, height=1.68mm)
  V115_DCN = cylinder(axis=Z, base_centre=(-35.15mm, 14.8mm, -1.44mm), radius=0.15mm, height=1.68mm)
  V116_DCN = cylinder(axis=Z, base_centre=(-29.15mm, 15.5mm, -1.44mm), radius=0.15mm, height=1.68mm)
  V117_DCN = cylinder(axis=Z, base_centre=(23.75mm, -0.5mm, -1.44mm), radius=0.15mm, height=1.68mm)
  V118_DCN = cylinder(axis=Z, base_centre=(-23.75mm, -0.5mm, -1.44mm), radius=0.15mm, height=1.68mm)
  V119_DCN = cylinder(axis=Z, base_centre=(31.15mm, 15.5mm, -1.44mm), radius=0.15mm, height=1.68mm)
  V120_DCN = cylinder(axis=Z, base_centre=(35.15mm, 14.8mm, -1.44mm), radius=0.15mm, height=1.68mm)
  V121_DCN = cylinder(axis=Z, base_centre=(5.35mm, 13.4mm, -1.44mm), radius=0.15mm, height=1.68mm)
  V122_DCN = cylinder(axis=Z, base_centre=(-18.35mm, 14.8mm, -1.44mm), radius=0.15mm, height=1.68mm)
  V123_DCN = cylinder(axis=Z, base_centre=(-7.15mm, -0.5mm, -1.44mm), radius=0.15mm, height=1.68mm)
  V124_DCN = cylinder(axis=Z, base_centre=(-35.15mm, 14.1mm, -1.44mm), radius=0.15mm, height=1.68mm)
  V125_DCN = cylinder(axis=Z, base_centre=(-17.35mm, 15.5mm, -1.44mm), radius=0.15mm, height=1.68mm)
  V126_DCN = cylinder(axis=Z, base_centre=(13.35mm, 14.8mm, -1.44mm), radius=0.15mm, height=1.68mm)
  V127_DCN = cylinder(axis=Z, base_centre=(-11.35mm, 14.8mm, -1.44mm), radius=0.15mm, height=1.68mm)
  V128_DCN = cylinder(axis=Z, base_centre=(32.15mm, 15.5mm, -1.44mm), radius=0.15mm, height=1.68mm)
  V129_DCN = cylinder(axis=Z, base_centre=(15.35mm, 14.8mm, -1.44mm), radius=0.15mm, height=1.68mm)
  V130_DCN = cylinder(axis=Z, base_centre=(-35.15mm, 13.4mm, -1.44mm), radius=0.15mm, height=1.68mm)
  V131_DCN = cylinder(axis=Z, base_centre=(-39.15mm, 13.4mm, -1.44mm), radius=0.15mm, height=1.68mm)
  V132_DCN = cylinder(axis=Z, base_centre=(0.05mm, -0.5mm, -1.44mm), radius=0.15mm, height=1.68mm)
  V133_DCN = cylinder(axis=Z, base_centre=(-36.15mm, 14.1mm, -1.44mm), radius=0.15mm, height=1.68mm)
  V134_DCN = cylinder(axis=Z, base_centre=(-18.35mm, 13.4mm, -1.44mm), radius=0.15mm, height=1.68mm)
  V135_DCN = cylinder(axis=Z, base_centre=(-18.35mm, 14.1mm, -1.44mm), radius=0.15mm, height=1.68mm)
  V136_DCN = cylinder(axis=Z, base_centre=(16.35mm, 14.1mm, -1.44mm), radius=0.15mm, height=1.68mm)
  V137_DCN = cylinder(axis=Z, base_centre=(24.9346mm, -0.5mm, -1.44mm), radius=0.15mm, height=1.68mm)
  V138_DCN = cylinder(axis=Z, base_centre=(-18.35mm, 15.5mm, -1.44mm), radius=0.15mm, height=1.68mm)
  V139_DCN = cylinder(axis=Z, base_centre=(-12.35mm, 19mm, -1.44mm), radius=0.15mm, height=1.68mm)
  V140_DCN = cylinder(axis=Z, base_centre=(9.35mm, 13.4mm, -1.44mm), radius=0.15mm, height=1.68mm)
  V141_DCN = cylinder(axis=Z, base_centre=(12.35mm, 15.5mm, -1.44mm), radius=0.15mm, height=1.68mm)
  V142_DCN = cylinder(axis=Z, base_centre=(17.35mm, 14.1mm, -1.44mm), radius=0.15mm, height=1.68mm)
  V143_DCN = cylinder(axis=Z, base_centre=(-24.9346mm, -0.5mm, -1.44mm), radius=0.15mm, height=1.68mm)
  V144_DCN = cylinder(axis=Z, base_centre=(33.15mm, 14.8mm, -1.44mm), radius=0.15mm, height=1.68mm)
  V145_DCN = cylinder(axis=Z, base_centre=(37.9654mm, -0.5mm, -1.44mm), radius=0.15mm, height=1.68mm)
  V146_DCN = cylinder(axis=Z, base_centre=(9.5346mm, -0.5mm, -1.44mm), radius=0.15mm, height=1.68mm)
  V147_DCN = cylinder(axis=Z, base_centre=(-14.35mm, 13.4mm, -1.44mm), radius=0.15mm, height=1.68mm)
  V148_DCN = cylinder(axis=Z, base_centre=(-36.7808mm, -0.5mm, -1.44mm), radius=0.15mm, height=1.68mm)
  V149_DCN = cylinder(axis=Z, base_centre=(3.65mm, -0.5mm, -1.44mm), radius=0.15mm, height=1.68mm)
  V150_DCN = cylinder(axis=Z, base_centre=(29.15mm, 15.5mm, -1.44mm), radius=0.15mm, height=1.68mm)
  V151_DCN = cylinder(axis=Z, base_centre=(34.15mm, 14.1mm, -1.44mm), radius=0.15mm, height=1.68mm)
  V152_DCN = cylinder(axis=Z, base_centre=(12.35mm, 14.8mm, -1.44mm), radius=0.15mm, height=1.68mm)
  V153_DCN = cylinder(axis=Z, base_centre=(33.15mm, 13.4mm, -1.44mm), radius=0.15mm, height=1.68mm)
  V154_DCN = cylinder(axis=Z, base_centre=(-30.15mm, 14.8mm, -1.44mm), radius=0.15mm, height=1.68mm)
  V155_DCN = cylinder(axis=Z, base_centre=(-35.15mm, 19mm, -1.44mm), radius=0.15mm, height=1.68mm)
  V156_DCN = cylinder(axis=Z, base_centre=(-1.15mm, -0.5mm, -1.44mm), radius=0.15mm, height=1.68mm)
  V157_DCN = cylinder(axis=Z, base_centre=(-13.35mm, 14.1mm, -1.44mm), radius=0.15mm, height=1.68mm)
  V158_DCN = cylinder(axis=Z, base_centre=(29.15mm, 14.1mm, -1.44mm), radius=0.15mm, height=1.68mm)
  V159_DCN = cylinder(axis=Z, base_centre=(-32.15mm, 14.1mm, -1.44mm), radius=0.15mm, height=1.68mm)
  V160_DCN = cylinder(axis=Z, base_centre=(-36.15mm, 14.8mm, -1.44mm), radius=0.15mm, height=1.68mm)
  V161_DCN = cylinder(axis=Z, base_centre=(-35.5962mm, -0.5mm, -1.44mm), radius=0.15mm, height=1.68mm)
  V162_DCN = cylinder(axis=Z, base_centre=(18.35mm, 14.1mm, -1.44mm), radius=0.15mm, height=1.68mm)
  V163_DCN = cylinder(axis=Z, base_centre=(-27.3038mm, -0.5mm, -1.44mm), radius=0.15mm, height=1.68mm)
  V164_DCN = cylinder(axis=Z, base_centre=(-34.4115mm, -0.5mm, -1.44mm), radius=0.15mm, height=1.68mm)
  V165_DCN = cylinder(axis=Z, base_centre=(-39.15mm, -0.5mm, -1.44mm), radius=0.15mm, height=1.68mm)
  V166_DCN = cylinder(axis=Z, base_centre=(15.35mm, 14.1mm, -1.44mm), radius=0.15mm, height=1.68mm)
  V167_DCN = cylinder(axis=Z, base_centre=(-14.35mm, 14.8mm, -1.44mm), radius=0.15mm, height=1.68mm)
  V168_DCN = cylinder(axis=Z, base_centre=(15.35mm, 13.4mm, -1.44mm), radius=0.15mm, height=1.68mm)
  V169_DCN = cylinder(axis=Z, base_centre=(-16.35mm, 15.5mm, -1.44mm), radius=0.15mm, height=1.68mm)
  V170_DCN = cylinder(axis=Z, base_centre=(-12.35mm, 15.5mm, -1.44mm), radius=0.15mm, height=1.68mm)
  V171_DCN = cylinder(axis=Z, base_centre=(-16.35mm, 14.8mm, -1.44mm), radius=0.15mm, height=1.68mm)
  V172_DCN = cylinder(axis=Z, base_centre=(14.2731mm, -0.5mm, -1.44mm), radius=0.15mm, height=1.68mm)
  V173_DCN = cylinder(axis=Z, base_centre=(33.15mm, 15.5mm, -1.44mm), radius=0.15mm, height=1.68mm)
  V174_DCN = cylinder(axis=Z, base_centre=(8.35mm, 13.4mm, -1.44mm), radius=0.15mm, height=1.68mm)
  V175_DCN = cylinder(axis=Z, base_centre=(11.35mm, 14.8mm, -1.44mm), radius=0.15mm, height=1.68mm)
  V176_DCN = cylinder(axis=Z, base_centre=(36.15mm, 14.1mm, -1.44mm), radius=0.15mm, height=1.68mm)
  V177_DCN = cylinder(axis=Z, base_centre=(27.3038mm, -0.5mm, -1.44mm), radius=0.15mm, height=1.68mm)
  V178_DCN = cylinder(axis=Z, base_centre=(18.35mm, 13.4mm, -1.44mm), radius=0.15mm, height=1.68mm)
  V179_DCN = cylinder(axis=Z, base_centre=(41.15mm, 13.4mm, -1.44mm), radius=0.15mm, height=1.68mm)
  V180_DCN = cylinder(axis=Z, base_centre=(21.3808mm, -0.5mm, -1.44mm), radius=0.15mm, height=1.68mm)
  V181_DCN = cylinder(axis=Z, base_centre=(-36.15mm, 13.4mm, -1.44mm), radius=0.15mm, height=1.68mm)
  V182_DCN = cylinder(axis=Z, base_centre=(-16.35mm, 14.1mm, -1.44mm), radius=0.15mm, height=1.68mm)
  V183_DCN = cylinder(axis=Z, base_centre=(-12.35mm, 14.8mm, -1.44mm), radius=0.15mm, height=1.68mm)
  V184_DCN = cylinder(axis=Z, base_centre=(2.45mm, -0.5mm, -1.44mm), radius=0.15mm, height=1.68mm)
  V185_DCN = cylinder(axis=Z, base_centre=(-32.0423mm, -0.5mm, -1.44mm), radius=0.15mm, height=1.68mm)
  V186_DCN = cylinder(axis=Z, base_centre=(-15.4577mm, -0.5mm, -1.44mm), radius=0.15mm, height=1.68mm)
  V187_DCN = cylinder(axis=Z, base_centre=(35.15mm, 15.5mm, -1.44mm), radius=0.15mm, height=1.68mm)
  V188_DCN = cylinder(axis=Z, base_centre=(14.35mm, 14.8mm, -1.44mm), radius=0.15mm, height=1.68mm)
  V189_DCN = cylinder(axis=Z, base_centre=(17.35mm, 14.8mm, -1.44mm), radius=0.15mm, height=1.68mm)
  V190_DCN = cylinder(axis=Z, base_centre=(-2.35mm, -0.5mm, -1.44mm), radius=0.15mm, height=1.68mm)
  V191_DCN = cylinder(axis=Z, base_centre=(-29.15mm, 14.1mm, -1.44mm), radius=0.15mm, height=1.68mm)
  V192_DCN = cylinder(axis=Z, base_centre=(-35.15mm, 19.75mm, -1.44mm), radius=0.15mm, height=1.68mm)
  V193_DCN = cylinder(axis=Z, base_centre=(-20.1962mm, -0.5mm, -1.44mm), radius=0.15mm, height=1.68mm)
  V194_DCN = cylinder(axis=Z, base_centre=(-17.35mm, 14.8mm, -1.44mm), radius=0.15mm, height=1.68mm)
  V195_DCN = cylinder(axis=Z, base_centre=(-13.35mm, 15.5mm, -1.44mm), radius=0.15mm, height=1.68mm)
  V196_DCN = cylinder(axis=Z, base_centre=(-13.0885mm, -0.5mm, -1.44mm), radius=0.15mm, height=1.68mm)
  V197_DCN = cylinder(axis=Z, base_centre=(-42.15mm, 13.4mm, -1.44mm), radius=0.15mm, height=1.68mm)
  V198_DCN = cylinder(axis=Z, base_centre=(16.35mm, 14.8mm, -1.44mm), radius=0.15mm, height=1.68mm)
  V199_DCN = cylinder(axis=Z, base_centre=(42.15mm, 13.4mm, -1.44mm), radius=0.15mm, height=1.68mm)
  V200_DCN = cylinder(axis=Z, base_centre=(16.35mm, 15.5mm, -1.44mm), radius=0.15mm, height=1.68mm)
  V201_DCN = cylinder(axis=Z, base_centre=(11.35mm, 14.1mm, -1.44mm), radius=0.15mm, height=1.68mm)
  V202_DCN = cylinder(axis=Z, base_centre=(36.7808mm, -0.5mm, -1.44mm), radius=0.15mm, height=1.68mm)
  V203_DCN = cylinder(axis=Z, base_centre=(-38.15mm, 13.4mm, -1.44mm), radius=0.15mm, height=1.68mm)
  V204_DCN = cylinder(axis=Z, base_centre=(-30.15mm, 13.4mm, -1.44mm), radius=0.15mm, height=1.68mm)
  V205_DCN = cylinder(axis=Z, base_centre=(-14.35mm, 15.5mm, -1.44mm), radius=0.15mm, height=1.68mm)
  V206_DCN = cylinder(axis=Z, base_centre=(31.15mm, 14.8mm, -1.44mm), radius=0.15mm, height=1.68mm)
  V207_DCN = cylinder(axis=Z, base_centre=(-17.35mm, 14.1mm, -1.44mm), radius=0.15mm, height=1.68mm)
  V208_DCN = cylinder(axis=Z, base_centre=(-15.35mm, 13.4mm, -1.44mm), radius=0.15mm, height=1.68mm)
  V209_DCN = cylinder(axis=Z, base_centre=(-28.4885mm, -0.5mm, -1.44mm), radius=0.15mm, height=1.68mm)
  V210_DCN = cylinder(axis=Z, base_centre=(38.15mm, 13.4mm, -1.44mm), radius=0.15mm, height=1.68mm)
  V211_DCN = cylinder(axis=Z, base_centre=(-7.35mm, 13.4mm, -1.44mm), radius=0.15mm, height=1.68mm)
  V212_DCN = cylinder(axis=Z, base_centre=(-21.3808mm, -0.5mm, -1.44mm), radius=0.15mm, height=1.68mm)
  V213_DCN = cylinder(axis=Z, base_centre=(36.15mm, 15.5mm, -1.44mm), radius=0.15mm, height=1.68mm)
  V214_DCN = cylinder(axis=Z, base_centre=(15.4577mm, -0.5mm, -1.44mm), radius=0.15mm, height=1.68mm)
  V215_DCN = cylinder(axis=Z, base_centre=(-29.15mm, 14.8mm, -1.44mm), radius=0.15mm, height=1.68mm)
  V216_DCN = cylinder(axis=Z, base_centre=(34.15mm, 15.5mm, -1.44mm), radius=0.15mm, height=1.68mm)
  V217_DCN = cylinder(axis=Z, base_centre=(-35.15mm, 15.5mm, -1.44mm), radius=0.15mm, height=1.68mm)
  V218_DCN = cylinder(axis=Z, base_centre=(32.15mm, 14.8mm, -1.44mm), radius=0.15mm, height=1.68mm)
  V219_DCN = cylinder(axis=Z, base_centre=(-31.15mm, 14.8mm, -1.44mm), radius=0.15mm, height=1.68mm)
  V220_DCN = cylinder(axis=Z, base_centre=(-15.35mm, 15.5mm, -1.44mm), radius=0.15mm, height=1.68mm)
  V221_DCN = cylinder(axis=Z, base_centre=(26.1192mm, -0.5mm, -1.44mm), radius=0.15mm, height=1.68mm)
  V222_DCN = cylinder(axis=Z, base_centre=(-11.9038mm, -0.5mm, -1.44mm), radius=0.15mm, height=1.68mm)
  V223_DCN = cylinder(axis=Z, base_centre=(13.35mm, 13.4mm, -1.44mm), radius=0.15mm, height=1.68mm)
  V224_DCN = cylinder(axis=Z, base_centre=(32.15mm, 14.1mm, -1.44mm), radius=0.15mm, height=1.68mm)
  V225_DCN = cylinder(axis=Z, base_centre=(13.35mm, 14.1mm, -1.44mm), radius=0.15mm, height=1.68mm)
  V226_DCN = cylinder(axis=Z, base_centre=(-34.15mm, 14.1mm, -1.44mm), radius=0.15mm, height=1.68mm)
  V227_DCN = cylinder(axis=Z, base_centre=(12.35mm, 19mm, -1.44mm), radius=0.15mm, height=1.68mm)
  V228_DCN = cylinder(axis=Z, base_centre=(30.15mm, 14.8mm, -1.44mm), radius=0.15mm, height=1.68mm)
  V229_DCN = cylinder(axis=Z, base_centre=(-9.35mm, 13.4mm, -1.44mm), radius=0.15mm, height=1.68mm)
  V230_DCN = cylinder(axis=Z, base_centre=(34.4115mm, -0.5mm, -1.44mm), radius=0.15mm, height=1.68mm)
  V231_DCN = cylinder(axis=Z, base_centre=(-5.95mm, -0.5mm, -1.44mm), radius=0.15mm, height=1.68mm)
  V232_DCN = cylinder(axis=Z, base_centre=(36.15mm, 13.4mm, -1.44mm), radius=0.15mm, height=1.68mm)
  V233_DCN = cylinder(axis=Z, base_centre=(-33.15mm, 14.1mm, -1.44mm), radius=0.15mm, height=1.68mm)
  V234_DCN = cylinder(axis=Z, base_centre=(-30.8577mm, -0.5mm, -1.44mm), radius=0.15mm, height=1.68mm)
  V235_DCN = cylinder(axis=Z, base_centre=(-3.55mm, -0.5mm, -1.44mm), radius=0.15mm, height=1.68mm)
  V236_DCN = cylinder(axis=Z, base_centre=(-30.15mm, 14.1mm, -1.44mm), radius=0.15mm, height=1.68mm)
  V237_DCN = cylinder(axis=Z, base_centre=(32.15mm, 13.4mm, -1.44mm), radius=0.15mm, height=1.68mm)
  V238_DCN = cylinder(axis=Z, base_centre=(40.15mm, 13.4mm, -1.44mm), radius=0.15mm, height=1.68mm)
  V239_DCN = cylinder(axis=Z, base_centre=(35.15mm, 19mm, -1.44mm), radius=0.15mm, height=1.68mm)
  V240_DCN = cylinder(axis=Z, base_centre=(16.6423mm, -0.5mm, -1.44mm), radius=0.15mm, height=1.68mm)
  V241_DCN = cylinder(axis=Z, base_centre=(17.35mm, 13.4mm, -1.44mm), radius=0.15mm, height=1.68mm)
  V242_DCN = cylinder(axis=Z, base_centre=(35.15mm, 19.75mm, -1.44mm), radius=0.15mm, height=1.68mm)
  V243_DCN = cylinder(axis=Z, base_centre=(-11.35mm, 15.5mm, -1.44mm), radius=0.15mm, height=1.68mm)
  V244_DCN = cylinder(axis=Z, base_centre=(-12.35mm, 14.1mm, -1.44mm), radius=0.15mm, height=1.68mm)
  V245_DCN = cylinder(axis=Z, base_centre=(4.85mm, -0.5mm, -1.44mm), radius=0.15mm, height=1.68mm)
  V246_DCN = cylinder(axis=Z, base_centre=(14.35mm, 13.4mm, -1.44mm), radius=0.15mm, height=1.68mm)
  V247_DCN = cylinder(axis=Z, base_centre=(30.15mm, 15.5mm, -1.44mm), radius=0.15mm, height=1.68mm)
  V248_DCN = cylinder(axis=Z, base_centre=(-36.15mm, 15.5mm, -1.44mm), radius=0.15mm, height=1.68mm)
  V249_DCN = cylinder(axis=Z, base_centre=(-12.35mm, 19.75mm, -1.44mm), radius=0.15mm, height=1.68mm)
  V250_DCN = cylinder(axis=Z, base_centre=(11.35mm, 15.5mm, -1.44mm), radius=0.15mm, height=1.68mm)
  V251_DCN = cylinder(axis=Z, base_centre=(35.15mm, 14.1mm, -1.44mm), radius=0.15mm, height=1.68mm)
  V252_DCN = cylinder(axis=Z, base_centre=(-32.15mm, 14.8mm, -1.44mm), radius=0.15mm, height=1.68mm)
  V253_DCN = cylinder(axis=Z, base_centre=(-31.15mm, 13.4mm, -1.44mm), radius=0.15mm, height=1.68mm)
  V254_AC4 = cylinder(axis=Z, base_centre=(42.15mm, 10.3mm, -1.44mm), radius=0.15mm, height=1.68mm)
  V255_AC4 = cylinder(axis=Z, base_centre=(43.15mm, 8.05mm, -1.44mm), radius=0.15mm, height=1.68mm)
  V256_AC1 = cylinder(axis=Z, base_centre=(-42.15mm, 7.3mm, -1.44mm), radius=0.15mm, height=1.68mm)
  V257_AC1 = cylinder(axis=Z, base_centre=(-42.15mm, 9.55mm, -1.44mm), radius=0.15mm, height=1.68mm)
  V258_AC3 = cylinder(axis=Z, base_centre=(4.35mm, 10.3mm, -1.44mm), radius=0.15mm, height=1.68mm)
  V259_AC4 = cylinder(axis=Z, base_centre=(42.15mm, 5.8mm, -1.44mm), radius=0.15mm, height=1.68mm)
  V260_AC1 = cylinder(axis=Z, base_centre=(-29.2mm, 7.05mm, -1.44mm), radius=0.15mm, height=1.68mm)
  V261_AC4 = cylinder(axis=Z, base_centre=(43.15mm, 7.3mm, -1.44mm), radius=0.15mm, height=1.68mm)
  V262_AC2 = cylinder(axis=Z, base_centre=(-5.35mm, 8.8mm, -1.44mm), radius=0.15mm, height=1.68mm)
  V263_AC1 = cylinder(axis=Z, base_centre=(-42.15mm, 8.05mm, -1.44mm), radius=0.15mm, height=1.68mm)
  V264_AC2 = cylinder(axis=Z, base_centre=(-4.35mm, 5.8mm, -1.44mm), radius=0.15mm, height=1.68mm)
  V265_AC2 = cylinder(axis=Z, base_centre=(-4.35mm, 8.05mm, -1.44mm), radius=0.15mm, height=1.68mm)
  V266_AC4 = cylinder(axis=Z, base_centre=(42.15mm, 8.8mm, -1.44mm), radius=0.15mm, height=1.68mm)
  V267_AC2 = cylinder(axis=Z, base_centre=(-5.35mm, 5.8mm, -1.44mm), radius=0.15mm, height=1.68mm)
  V268_AC3 = cylinder(axis=Z, base_centre=(5.35mm, 5.8mm, -1.44mm), radius=0.15mm, height=1.68mm)
  V269_AC1 = cylinder(axis=Z, base_centre=(-42.15mm, 5.8mm, -1.44mm), radius=0.15mm, height=1.68mm)
  V270_AC4 = cylinder(axis=Z, base_centre=(43.15mm, 9.55mm, -1.44mm), radius=0.15mm, height=1.68mm)
  V271_AC2 = cylinder(axis=Z, base_centre=(-5.35mm, 9.55mm, -1.44mm), radius=0.15mm, height=1.68mm)
  V272_AC4 = cylinder(axis=Z, base_centre=(43.15mm, 8.8mm, -1.44mm), radius=0.15mm, height=1.68mm)
  V273_AC1 = cylinder(axis=Z, base_centre=(-43.15mm, 8.05mm, -1.44mm), radius=0.15mm, height=1.68mm)
  V274_AC3 = cylinder(axis=Z, base_centre=(4.35mm, 5.8mm, -1.44mm), radius=0.15mm, height=1.68mm)
  V275_AC1 = cylinder(axis=Z, base_centre=(-42.15mm, 8.8mm, -1.44mm), radius=0.15mm, height=1.68mm)
  V276_AC2 = cylinder(axis=Z, base_centre=(-4.35mm, 8.8mm, -1.44mm), radius=0.15mm, height=1.68mm)
  V277_AC3 = cylinder(axis=Z, base_centre=(4.35mm, 9.55mm, -1.44mm), radius=0.15mm, height=1.68mm)
  V278_AC3 = cylinder(axis=Z, base_centre=(5.35mm, 6.55mm, -1.44mm), radius=0.15mm, height=1.68mm)
  V279_AC4 = cylinder(axis=Z, base_centre=(42.15mm, 9.55mm, -1.44mm), radius=0.15mm, height=1.68mm)
  V280_AC3 = cylinder(axis=Z, base_centre=(5.35mm, 8.8mm, -1.44mm), radius=0.15mm, height=1.68mm)
  V281_AC2 = cylinder(axis=Z, base_centre=(-18.3mm, 7.05mm, -1.44mm), radius=0.15mm, height=1.68mm)
  V282_AC2 = cylinder(axis=Z, base_centre=(-4.35mm, 10.3mm, -1.44mm), radius=0.15mm, height=1.68mm)
  V283_AC2 = cylinder(axis=Z, base_centre=(-4.35mm, 6.55mm, -1.44mm), radius=0.15mm, height=1.68mm)
  V284_AC3 = cylinder(axis=Z, base_centre=(4.35mm, 6.55mm, -1.44mm), radius=0.15mm, height=1.68mm)
  V285_AC4 = cylinder(axis=Z, base_centre=(29.2mm, 7.05mm, -1.44mm), radius=0.15mm, height=1.68mm)
  V286_AC2 = cylinder(axis=Z, base_centre=(-5.35mm, 6.55mm, -1.44mm), radius=0.15mm, height=1.68mm)
  V287_AC1 = cylinder(axis=Z, base_centre=(-42.15mm, 6.55mm, -1.44mm), radius=0.15mm, height=1.68mm)
  V288_AC3 = cylinder(axis=Z, base_centre=(4.35mm, 7.3mm, -1.44mm), radius=0.15mm, height=1.68mm)
  V289_AC3 = cylinder(axis=Z, base_centre=(5.35mm, 10.3mm, -1.44mm), radius=0.15mm, height=1.68mm)
  V290_AC4 = cylinder(axis=Z, base_centre=(42.15mm, 6.55mm, -1.44mm), radius=0.15mm, height=1.68mm)
  V291_AC2 = cylinder(axis=Z, base_centre=(-4.35mm, 7.3mm, -1.44mm), radius=0.15mm, height=1.68mm)
  V292_AC2 = cylinder(axis=Z, base_centre=(-5.35mm, 10.3mm, -1.44mm), radius=0.15mm, height=1.68mm)
  V293_AC1 = cylinder(axis=Z, base_centre=(-42.15mm, 10.3mm, -1.44mm), radius=0.15mm, height=1.68mm)
  V294_AC4 = cylinder(axis=Z, base_centre=(42.15mm, 7.3mm, -1.44mm), radius=0.15mm, height=1.68mm)
  V295_AC3 = cylinder(axis=Z, base_centre=(4.35mm, 8.8mm, -1.44mm), radius=0.15mm, height=1.68mm)
  V296_AC4 = cylinder(axis=Z, base_centre=(43.15mm, 6.55mm, -1.44mm), radius=0.15mm, height=1.68mm)
  V297_AC3 = cylinder(axis=Z, base_centre=(5.35mm, 7.3mm, -1.44mm), radius=0.15mm, height=1.68mm)
  V298_AC4 = cylinder(axis=Z, base_centre=(43.15mm, 10.3mm, -1.44mm), radius=0.15mm, height=1.68mm)
  V299_AC3 = cylinder(axis=Z, base_centre=(5.35mm, 8.05mm, -1.44mm), radius=0.15mm, height=1.68mm)
  V300_AC1 = cylinder(axis=Z, base_centre=(-43.15mm, 5.8mm, -1.44mm), radius=0.15mm, height=1.68mm)
  V301_AC2 = cylinder(axis=Z, base_centre=(-5.35mm, 7.3mm, -1.44mm), radius=0.15mm, height=1.68mm)
  V302_AC1 = cylinder(axis=Z, base_centre=(-43.15mm, 7.3mm, -1.44mm), radius=0.15mm, height=1.68mm)
  V303_AC2 = cylinder(axis=Z, base_centre=(-5.35mm, 8.05mm, -1.44mm), radius=0.15mm, height=1.68mm)
  V304_AC1 = cylinder(axis=Z, base_centre=(-43.15mm, 6.55mm, -1.44mm), radius=0.15mm, height=1.68mm)
  V305_AC4 = cylinder(axis=Z, base_centre=(43.15mm, 5.8mm, -1.44mm), radius=0.15mm, height=1.68mm)
  V306_AC1 = cylinder(axis=Z, base_centre=(-43.15mm, 8.8mm, -1.44mm), radius=0.15mm, height=1.68mm)
  V307_AC1 = cylinder(axis=Z, base_centre=(-43.15mm, 10.3mm, -1.44mm), radius=0.15mm, height=1.68mm)
  V308_AC4 = cylinder(axis=Z, base_centre=(42.15mm, 8.05mm, -1.44mm), radius=0.15mm, height=1.68mm)
  V309_AC3 = cylinder(axis=Z, base_centre=(18.3mm, 7.05mm, -1.44mm), radius=0.15mm, height=1.68mm)
  V310_AC2 = cylinder(axis=Z, base_centre=(-4.35mm, 9.55mm, -1.44mm), radius=0.15mm, height=1.68mm)
  V311_AC1 = cylinder(axis=Z, base_centre=(-43.15mm, 9.55mm, -1.44mm), radius=0.15mm, height=1.68mm)
  V312_AC3 = cylinder(axis=Z, base_centre=(4.35mm, 8.05mm, -1.44mm), radius=0.15mm, height=1.68mm)
  V313_AC3 = cylinder(axis=Z, base_centre=(5.35mm, 9.55mm, -1.44mm), radius=0.15mm, height=1.68mm)
  V314_LSRC1 = cylinder(axis=Z, base_centre=(-37.225mm, 11.8mm, -1.44mm), radius=0.15mm, height=1.68mm)
  V315_LSRC2 = cylinder(axis=Z, base_centre=(-10.275mm, 11.8mm, -1.44mm), radius=0.15mm, height=1.68mm)
  V316_LSRC3 = cylinder(axis=Z, base_centre=(10.275mm, 11.8mm, -1.44mm), radius=0.15mm, height=1.68mm)
  V317_LSRC4 = cylinder(axis=Z, base_centre=(37.225mm, 11.8mm, -1.44mm), radius=0.15mm, height=1.68mm)
  Q4_3 = box(corner=(-15.85mm, 7.4mm, 0.17mm), size=(0.65mm, 3.6mm, 0.105mm))
  Q4_4 = box(corner=(-15mm, 7.4mm, 0.17mm), size=(0.65mm, 3.6mm, 0.105mm))
  Q4_5 = box(corner=(-14.15mm, 7.4mm, 0.17mm), size=(0.65mm, 3.6mm, 0.105mm))
  Q4_6 = box(corner=(-13.3mm, 7.4mm, 0.17mm), size=(0.65mm, 3.6mm, 0.105mm))
  Q4_7 = box(corner=(-12.449mm, 7.4mm, 0.17mm), size=(1.102mm, 3.6mm, 0.105mm))
  Q5_3 = box(corner=(15.2mm, 3.1mm, 0.17mm), size=(0.65mm, 3.6mm, 0.105mm))
  Q5_4 = box(corner=(14.35mm, 3.1mm, 0.17mm), size=(0.65mm, 3.6mm, 0.105mm))
  Q5_5 = box(corner=(13.5mm, 3.1mm, 0.17mm), size=(0.65mm, 3.6mm, 0.105mm))
  Q5_6 = box(corner=(12.65mm, 3.1mm, 0.17mm), size=(0.65mm, 3.6mm, 0.105mm))
  Q5_7 = box(corner=(11.347mm, 3.1mm, 0.17mm), size=(1.102mm, 3.6mm, 0.105mm))
  Q2_3 = box(corner=(-15.85mm, 3.1mm, 0.17mm), size=(0.65mm, 3.6mm, 0.105mm))
  Q2_4 = box(corner=(-15mm, 3.1mm, 0.17mm), size=(0.65mm, 3.6mm, 0.105mm))
  Q2_5 = box(corner=(-14.15mm, 3.1mm, 0.17mm), size=(0.65mm, 3.6mm, 0.105mm))
  Q2_6 = box(corner=(-13.3mm, 3.1mm, 0.17mm), size=(0.65mm, 3.6mm, 0.105mm))
  Q2_7 = box(corner=(-12.449mm, 3.1mm, 0.17mm), size=(1.102mm, 3.6mm, 0.105mm))
  Q3_3 = box(corner=(-32.3mm, 7.4mm, 0.17mm), size=(0.65mm, 3.6mm, 0.105mm))
  Q3_4 = box(corner=(-33.15mm, 7.4mm, 0.17mm), size=(0.65mm, 3.6mm, 0.105mm))
  Q3_5 = box(corner=(-34mm, 7.4mm, 0.17mm), size=(0.65mm, 3.6mm, 0.105mm))
  Q3_6 = box(corner=(-34.85mm, 7.4mm, 0.17mm), size=(0.65mm, 3.6mm, 0.105mm))
  Q3_7 = box(corner=(-36.153mm, 7.4mm, 0.17mm), size=(1.102mm, 3.6mm, 0.105mm))
  Q1_3 = box(corner=(-32.3mm, 3.1mm, 0.17mm), size=(0.65mm, 3.6mm, 0.105mm))
  Q1_4 = box(corner=(-33.15mm, 3.1mm, 0.17mm), size=(0.65mm, 3.6mm, 0.105mm))
  Q1_5 = box(corner=(-34mm, 3.1mm, 0.17mm), size=(0.65mm, 3.6mm, 0.105mm))
  Q1_6 = box(corner=(-34.85mm, 3.1mm, 0.17mm), size=(0.65mm, 3.6mm, 0.105mm))
  Q1_7 = box(corner=(-36.153mm, 3.1mm, 0.17mm), size=(1.102mm, 3.6mm, 0.105mm))
  Q7_3 = box(corner=(15.2mm, 7.4mm, 0.17mm), size=(0.65mm, 3.6mm, 0.105mm))
  Q7_4 = box(corner=(14.35mm, 7.4mm, 0.17mm), size=(0.65mm, 3.6mm, 0.105mm))
  Q7_5 = box(corner=(13.5mm, 7.4mm, 0.17mm), size=(0.65mm, 3.6mm, 0.105mm))
  Q7_6 = box(corner=(12.65mm, 7.4mm, 0.17mm), size=(0.65mm, 3.6mm, 0.105mm))
  Q7_7 = box(corner=(11.347mm, 7.4mm, 0.17mm), size=(1.102mm, 3.6mm, 0.105mm))
  Q6_3 = box(corner=(31.65mm, 3.1mm, 0.17mm), size=(0.65mm, 3.6mm, 0.105mm))
  Q6_4 = box(corner=(32.5mm, 3.1mm, 0.17mm), size=(0.65mm, 3.6mm, 0.105mm))
  Q6_5 = box(corner=(33.35mm, 3.1mm, 0.17mm), size=(0.65mm, 3.6mm, 0.105mm))
  Q6_6 = box(corner=(34.2mm, 3.1mm, 0.17mm), size=(0.65mm, 3.6mm, 0.105mm))
  Q6_7 = box(corner=(35.051mm, 3.1mm, 0.17mm), size=(1.102mm, 3.6mm, 0.105mm))
  Q8_3 = box(corner=(31.65mm, 7.4mm, 0.17mm), size=(0.65mm, 3.6mm, 0.105mm))
  Q8_4 = box(corner=(32.5mm, 7.4mm, 0.17mm), size=(0.65mm, 3.6mm, 0.105mm))
  Q8_5 = box(corner=(33.35mm, 7.4mm, 0.17mm), size=(0.65mm, 3.6mm, 0.105mm))
  Q8_6 = box(corner=(34.2mm, 7.4mm, 0.17mm), size=(0.65mm, 3.6mm, 0.105mm))
  Q8_7 = box(corner=(35.051mm, 7.4mm, 0.17mm), size=(1.102mm, 3.6mm, 0.105mm))
  C35_1 = box(corner=(11.125mm, 1.55mm, 0.17mm), size=(1.45mm, 1mm, 0.105mm))
  C35_2 = box(corner=(11.125mm, -0.35mm, 0.17mm), size=(1.45mm, 1mm, 0.105mm))
  C43_1 = box(corner=(33.325mm, 1.55mm, 0.17mm), size=(1.45mm, 1mm, 0.105mm))
  C43_2 = box(corner=(33.325mm, -0.35mm, 0.17mm), size=(1.45mm, 1mm, 0.105mm))
  C42_1 = box(corner=(31.725mm, 1.55mm, 0.17mm), size=(1.45mm, 1mm, 0.105mm))
  C42_2 = box(corner=(31.725mm, -0.35mm, 0.17mm), size=(1.45mm, 1mm, 0.105mm))
  C41_1 = box(corner=(30.125mm, 1.55mm, 0.17mm), size=(1.45mm, 1mm, 0.105mm))
  C41_2 = box(corner=(30.125mm, -0.35mm, 0.17mm), size=(1.45mm, 1mm, 0.105mm))
  RS4_1 = box(corner=(28.65mm, 11.2mm, 0.17mm), size=(15mm, 1.2mm, 0.105mm))
  RS4_2 = box(corner=(28.65mm, 12.9mm, 0.17mm), size=(15mm, 3mm, 0.105mm))
  C3_1 = box(corner=(-34.775mm, 1.55mm, 0.17mm), size=(1.45mm, 1mm, 0.105mm))
  C3_2 = box(corner=(-34.775mm, -0.35mm, 0.17mm), size=(1.45mm, 1mm, 0.105mm))
  C1_1 = box(corner=(-37.975mm, 1.55mm, 0.17mm), size=(1.45mm, 1mm, 0.105mm))
  C1_2 = box(corner=(-37.975mm, -0.35mm, 0.17mm), size=(1.45mm, 1mm, 0.105mm))
  C34_1 = box(corner=(9.525mm, 1.55mm, 0.17mm), size=(1.45mm, 1mm, 0.105mm))
  C34_2 = box(corner=(9.525mm, -0.35mm, 0.17mm), size=(1.45mm, 1mm, 0.105mm))
  C12_1 = box(corner=(-10.975mm, 1.55mm, 0.17mm), size=(1.45mm, 1mm, 0.105mm))
  C12_2 = box(corner=(-10.975mm, -0.35mm, 0.17mm), size=(1.45mm, 1mm, 0.105mm))
  C6_1 = box(corner=(-29.975mm, 1.55mm, 0.17mm), size=(1.45mm, 1mm, 0.105mm))
  C6_2 = box(corner=(-29.975mm, -0.35mm, 0.17mm), size=(1.45mm, 1mm, 0.105mm))
  C11_1 = box(corner=(-12.575mm, 1.55mm, 0.17mm), size=(1.45mm, 1mm, 0.105mm))
  C11_2 = box(corner=(-12.575mm, -0.35mm, 0.17mm), size=(1.45mm, 1mm, 0.105mm))
  C44_1 = box(corner=(34.925mm, 1.55mm, 0.17mm), size=(1.45mm, 1mm, 0.105mm))
  C44_2 = box(corner=(34.925mm, -0.35mm, 0.17mm), size=(1.45mm, 1mm, 0.105mm))
  C40_1 = box(corner=(28.525mm, 1.55mm, 0.17mm), size=(1.45mm, 1mm, 0.105mm))
  C40_2 = box(corner=(28.525mm, -0.35mm, 0.17mm), size=(1.45mm, 1mm, 0.105mm))
  C4_1 = box(corner=(-33.175mm, 1.55mm, 0.17mm), size=(1.45mm, 1mm, 0.105mm))
  C4_2 = box(corner=(-33.175mm, -0.35mm, 0.17mm), size=(1.45mm, 1mm, 0.105mm))
  C10_1 = box(corner=(-14.175mm, 1.55mm, 0.17mm), size=(1.45mm, 1mm, 0.105mm))
  C10_2 = box(corner=(-14.175mm, -0.35mm, 0.17mm), size=(1.45mm, 1mm, 0.105mm))
  C37_1 = box(corner=(14.325mm, 1.55mm, 0.17mm), size=(1.45mm, 1mm, 0.105mm))
  C37_2 = box(corner=(14.325mm, -0.35mm, 0.17mm), size=(1.45mm, 1mm, 0.105mm))
  C39_1 = box(corner=(17.525mm, 1.55mm, 0.17mm), size=(1.45mm, 1mm, 0.105mm))
  C39_2 = box(corner=(17.525mm, -0.35mm, 0.17mm), size=(1.45mm, 1mm, 0.105mm))
  C5_1 = box(corner=(-31.575mm, 1.55mm, 0.17mm), size=(1.45mm, 1mm, 0.105mm))
  C5_2 = box(corner=(-31.575mm, -0.35mm, 0.17mm), size=(1.45mm, 1mm, 0.105mm))
  C36_1 = box(corner=(12.725mm, 1.55mm, 0.17mm), size=(1.45mm, 1mm, 0.105mm))
  C36_2 = box(corner=(12.725mm, -0.35mm, 0.17mm), size=(1.45mm, 1mm, 0.105mm))
  RS3_1 = box(corner=(3.85mm, 11.2mm, 0.17mm), size=(15mm, 1.2mm, 0.105mm))
  RS3_2 = box(corner=(3.85mm, 12.9mm, 0.17mm), size=(15mm, 3mm, 0.105mm))
  C38_1 = box(corner=(15.925mm, 1.55mm, 0.17mm), size=(1.45mm, 1mm, 0.105mm))
  C38_2 = box(corner=(15.925mm, -0.35mm, 0.17mm), size=(1.45mm, 1mm, 0.105mm))
  C45_1 = box(corner=(36.525mm, 1.55mm, 0.17mm), size=(1.45mm, 1mm, 0.105mm))
  C45_2 = box(corner=(36.525mm, -0.35mm, 0.17mm), size=(1.45mm, 1mm, 0.105mm))
  C8_1 = box(corner=(-17.375mm, 1.55mm, 0.17mm), size=(1.45mm, 1mm, 0.105mm))
  C8_2 = box(corner=(-17.375mm, -0.35mm, 0.17mm), size=(1.45mm, 1mm, 0.105mm))
  C9_1 = box(corner=(-15.775mm, 1.55mm, 0.17mm), size=(1.45mm, 1mm, 0.105mm))
  C9_2 = box(corner=(-15.775mm, -0.35mm, 0.17mm), size=(1.45mm, 1mm, 0.105mm))
  C7_1 = box(corner=(-18.975mm, 1.55mm, 0.17mm), size=(1.45mm, 1mm, 0.105mm))
  C7_2 = box(corner=(-18.975mm, -0.35mm, 0.17mm), size=(1.45mm, 1mm, 0.105mm))
  RS2_1 = box(corner=(-18.85mm, 11.2mm, 0.17mm), size=(15mm, 1.2mm, 0.105mm))
  RS2_2 = box(corner=(-18.85mm, 12.9mm, 0.17mm), size=(15mm, 3mm, 0.105mm))
  RS1_1 = box(corner=(-43.65mm, 11.2mm, 0.17mm), size=(15mm, 1.2mm, 0.105mm))
  RS1_2 = box(corner=(-43.65mm, 12.9mm, 0.17mm), size=(15mm, 3mm, 0.105mm))
  C2_1 = box(corner=(-36.375mm, 1.55mm, 0.17mm), size=(1.45mm, 1mm, 0.105mm))
  C2_2 = box(corner=(-36.375mm, -0.35mm, 0.17mm), size=(1.45mm, 1mm, 0.105mm))
  C27_1 = box(corner=(-33.175mm, -0.25mm, -1.475mm), size=(1.45mm, 1mm, 0.105mm))
  C27_2 = box(corner=(-33.175mm, 1.65mm, -1.475mm), size=(1.45mm, 1mm, 0.105mm))
  C61_1 = box(corner=(15.925mm, -0.25mm, -1.475mm), size=(1.45mm, 1mm, 0.105mm))
  C61_2 = box(corner=(15.925mm, 1.65mm, -1.475mm), size=(1.45mm, 1mm, 0.105mm))
  C31_1 = box(corner=(-15.775mm, -0.25mm, -1.475mm), size=(1.45mm, 1mm, 0.105mm))
  C31_2 = box(corner=(-15.775mm, 1.65mm, -1.475mm), size=(1.45mm, 1mm, 0.105mm))
  C62_1 = box(corner=(17.525mm, -0.25mm, -1.475mm), size=(1.45mm, 1mm, 0.105mm))
  C62_2 = box(corner=(17.525mm, 1.65mm, -1.475mm), size=(1.45mm, 1mm, 0.105mm))
  C64_1 = box(corner=(31.725mm, -0.25mm, -1.475mm), size=(1.45mm, 1mm, 0.105mm))
  C64_2 = box(corner=(31.725mm, 1.65mm, -1.475mm), size=(1.45mm, 1mm, 0.105mm))
  C26_1 = box(corner=(-34.775mm, -0.25mm, -1.475mm), size=(1.45mm, 1mm, 0.105mm))
  C26_2 = box(corner=(-34.775mm, 1.65mm, -1.475mm), size=(1.45mm, 1mm, 0.105mm))
  C65_1 = box(corner=(30.125mm, -0.25mm, -1.475mm), size=(1.45mm, 1mm, 0.105mm))
  C65_2 = box(corner=(30.125mm, 1.65mm, -1.475mm), size=(1.45mm, 1mm, 0.105mm))
  C30_1 = box(corner=(-14.175mm, -0.25mm, -1.475mm), size=(1.45mm, 1mm, 0.105mm))
  C30_2 = box(corner=(-14.175mm, 1.65mm, -1.475mm), size=(1.45mm, 1mm, 0.105mm))
  C33_1 = box(corner=(-18.975mm, -0.25mm, -1.475mm), size=(1.45mm, 1mm, 0.105mm))
  C33_2 = box(corner=(-18.975mm, 1.65mm, -1.475mm), size=(1.45mm, 1mm, 0.105mm))
  C66_1 = box(corner=(28.525mm, -0.25mm, -1.475mm), size=(1.45mm, 1mm, 0.105mm))
  C66_2 = box(corner=(28.525mm, 1.65mm, -1.475mm), size=(1.45mm, 1mm, 0.105mm))
  C59_1 = box(corner=(12.725mm, -0.25mm, -1.475mm), size=(1.45mm, 1mm, 0.105mm))
  C59_2 = box(corner=(12.725mm, 1.65mm, -1.475mm), size=(1.45mm, 1mm, 0.105mm))
  C29_1 = box(corner=(-29.975mm, -0.25mm, -1.475mm), size=(1.45mm, 1mm, 0.105mm))
  C29_2 = box(corner=(-29.975mm, 1.65mm, -1.475mm), size=(1.45mm, 1mm, 0.105mm))
  C28_1 = box(corner=(-31.575mm, -0.25mm, -1.475mm), size=(1.45mm, 1mm, 0.105mm))
  C28_2 = box(corner=(-31.575mm, 1.65mm, -1.475mm), size=(1.45mm, 1mm, 0.105mm))
  C32_1 = box(corner=(-17.375mm, -0.25mm, -1.475mm), size=(1.45mm, 1mm, 0.105mm))
  C32_2 = box(corner=(-17.375mm, 1.65mm, -1.475mm), size=(1.45mm, 1mm, 0.105mm))
  C63_1 = box(corner=(33.325mm, -0.25mm, -1.475mm), size=(1.45mm, 1mm, 0.105mm))
  C63_2 = box(corner=(33.325mm, 1.65mm, -1.475mm), size=(1.45mm, 1mm, 0.105mm))
  C60_1 = box(corner=(14.325mm, -0.25mm, -1.475mm), size=(1.45mm, 1mm, 0.105mm))
  C60_2 = box(corner=(14.325mm, 1.65mm, -1.475mm), size=(1.45mm, 1mm, 0.105mm))
  P27_AC1_L1.unite(P31_AC1_L3, P35_AC1_L4, V256_AC1, V257_AC1, V260_AC1, V263_AC1, V269_AC1, V273_AC1, V275_AC1, V287_AC1, V293_AC1, V300_AC1, V302_AC1, V304_AC1, V306_AC1, V307_AC1, V311_AC1, Q3_3, Q3_5, Q3_7, Q1_4, Q1_6)
  P27_AC1_L1.separate_bodies()
  P28_AC2_L1.unite(P32_AC2_L3, P36_AC2_L4, V262_AC2, V264_AC2, V265_AC2, V267_AC2, V271_AC2, V276_AC2, V281_AC2, V282_AC2, V283_AC2, V286_AC2, V291_AC2, V292_AC2, V301_AC2, V303_AC2, V310_AC2, Q4_3, Q4_5, Q4_7, Q2_4, Q2_6)
  P28_AC2_L1.separate_bodies()
  P29_AC3_L1.unite(P33_AC3_L3, P37_AC3_L4, V258_AC3, V268_AC3, V274_AC3, V277_AC3, V278_AC3, V280_AC3, V284_AC3, V288_AC3, V289_AC3, V295_AC3, V297_AC3, V299_AC3, V309_AC3, V312_AC3, V313_AC3, Q5_4, Q5_6, Q7_3, Q7_5, Q7_7)
  P29_AC3_L1.separate_bodies()
  P23_LSRC3_L1.unite(P24_LSRC3_L4, V316_LSRC3, Q7_4, Q7_6, RS3_1)
  P23_LSRC3_L1.separate_bodies()
  P21_LSRC2_L1.unite(P22_LSRC2_L4, V315_LSRC2, Q4_4, Q4_6, RS2_1)
  P21_LSRC2_L1.separate_bodies()
  P19_LSRC1_L1.unite(P20_LSRC1_L4, V314_LSRC1, Q3_4, Q3_6, RS1_1)
  P19_LSRC1_L1.separate_bodies()
  P25_LSRC4_L1.unite(P26_LSRC4_L4, V317_LSRC4, Q8_4, Q8_6, RS4_1)
  P25_LSRC4_L1.separate_bodies()
  P0_DCN_L1.unite(P1_DCN_L1, P2_DCN_L1, P3_DCN_L1, P4_DCN_L1, P5_DCN_L2, P6_DCN_L4, P7_DCN_L4, P8_DCN_L4, P9_DCN_L4, V32_DCN, V33_DCN, V34_DCN, V35_DCN, V36_DCN, V37_DCN, V38_DCN, V39_DCN, V40_DCN, V41_DCN, V42_DCN, V43_DCN, V44_DCN, V45_DCN, V46_DCN, V47_DCN, V48_DCN, V49_DCN, V50_DCN, V51_DCN, V52_DCN, V53_DCN, V54_DCN, V55_DCN, V56_DCN, V57_DCN, V58_DCN, V59_DCN, V60_DCN, V61_DCN, V62_DCN, V63_DCN, V64_DCN, V65_DCN, V66_DCN, V67_DCN, V68_DCN, V69_DCN, V70_DCN, V71_DCN, V72_DCN, V73_DCN, V74_DCN, V75_DCN, V76_DCN, V77_DCN, V78_DCN, V79_DCN, V80_DCN, V81_DCN, V82_DCN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)
  P0_DCN_L1.separate_bodies()
  P30_AC4_L1.unite(P34_AC4_L3, P38_AC4_L4, V254_AC4, V255_AC4, V259_AC4, V261_AC4, V266_AC4, V270_AC4, V272_AC4, V279_AC4, V285_AC4, V290_AC4, V294_AC4, V296_AC4, V298_AC4, V305_AC4, V308_AC4, Q6_4, Q6_6, Q8_3, Q8_5, Q8_7)
  P30_AC4_L1.separate_bodies()
  P10_DCP_L1.unite(P11_DCP_L1, P12_DCP_L1, P13_DCP_L1, P14_DCP_L3, P15_DCP_L4, P16_DCP_L4, P17_DCP_L4, P18_DCP_L4, V0_DCP, V1_DCP, V2_DCP, V3_DCP, V4_DCP, V5_DCP, V6_DCP, V7_DCP, V8_DCP, V9_DCP, V10_DCP, V11_DCP, V12_DCP, V13_DCP, V14_DCP, V15_DCP, V16_DCP, V17_DCP, V18_DCP, V19_DCP, V20_DCP, V21_DCP, V22_DCP, V23_DCP, V24_DCP, V25_DCP, V26_DCP, V27_DCP, V28_DCP, V29_DCP, V30_DCP, V31_DCP, Q5_3, Q5_5, Q5_7, Q2_3, Q2_5, Q2_7, Q1_3, Q1_5, Q1_7, Q6_3, Q6_5, Q6_7, C35_1, C43_1, C42_1, C41_1, C3_1, C1_1, C34_1, C12_1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)
  P10_DCP_L1.separate_bodies()
boundaries and excitations:
  AC1: SignalNet Objects=P27_AC1_L1
  AC2: SignalNet Objects=P28_AC2_L1
  AC3: SignalNet Objects=P29_AC3_L1
  LSRC3: SignalNet Objects=P23_LSRC3_L1
  LSRC2: SignalNet Objects=P21_LSRC2_L1
  LSRC1: SignalNet Objects=P19_LSRC1_L1
  LSRC4: SignalNet Objects=P25_LSRC4_L1
  DCN: SignalNet Objects=P0_DCN_L1
  AC4: SignalNet Objects=P30_AC4_L1
  DCP: SignalNet Objects=P10_DCP_L1
  CapN_2: Source Faces=P0_DCN_L1.face(at (-10.25, 0.15, 0.275), at (-11.85, 0.15, 0.275), at (-13.45, 0.15, 0.275), at (-16.65, 0.15, 0.275), at (-15.05, 0.15, 0.275), at (-18.25, 0.15, 0.275)) TerminalType=ConstantVoltage Net=DCN
  CapN_3: Source Faces=P0_DCN_L1.face(at (11.85, 0.15, 0.275), at (10.25, 0.15, 0.275), at (15.05, 0.15, 0.275), at (18.25, 0.15, 0.275), at (13.45, 0.15, 0.275), at (16.65, 0.15, 0.275)) TerminalType=ConstantVoltage Net=DCN
  CapN_4: Source Faces=P0_DCN_L1.face(at (34.05, 0.15, 0.275), at (32.45, 0.15, 0.275), at (30.85, 0.15, 0.275), at (35.65, 0.15, 0.275), at (29.25, 0.15, 0.275), at (37.25, 0.15, 0.275)) TerminalType=ConstantVoltage Net=DCN
  CapNb_1: Source Faces=P0_DCN_L1.face(at (-32.45, 0.25, -1.475), at (-34.05, 0.25, -1.475), at (-29.25, 0.25, -1.475), at (-30.85, 0.25, -1.475)) TerminalType=ConstantVoltage Net=DCN
  CapNb_2: Source Faces=P0_DCN_L1.face(at (-15.05, 0.25, -1.475), at (-13.45, 0.25, -1.475), at (-18.25, 0.25, -1.475), at (-16.65, 0.25, -1.475)) TerminalType=ConstantVoltage Net=DCN
  CapNb_3: Source Faces=P0_DCN_L1.face(at (16.65, 0.25, -1.475), at (18.25, 0.25, -1.475), at (13.45, 0.25, -1.475), at (15.05, 0.25, -1.475)) TerminalType=ConstantVoltage Net=DCN
  CapNb_4: Source Faces=P0_DCN_L1.face(at (32.45, 0.25, -1.475), at (30.85, 0.25, -1.475), at (29.25, 0.25, -1.475), at (34.05, 0.25, -1.475)) TerminalType=ConstantVoltage Net=DCN
  CapP_2: Source Faces=P10_DCP_L1.face(at (-10.25, 2.05, 0.275), at (-11.85, 2.05, 0.275), at (-13.45, 2.05, 0.275), at (-16.65, 2.05, 0.275), at (-15.05, 2.05, 0.275), at (-18.25, 2.05, 0.275)) TerminalType=ConstantVoltage Net=DCP
  CapP_3: Source Faces=P10_DCP_L1.face(at (11.85, 2.05, 0.275), at (10.25, 2.05, 0.275), at (15.05, 2.05, 0.275), at (18.25, 2.05, 0.275), at (13.45, 2.05, 0.275), at (16.65, 2.05, 0.275)) TerminalType=ConstantVoltage Net=DCP
  CapP_4: Source Faces=P10_DCP_L1.face(at (34.05, 2.05, 0.275), at (32.45, 2.05, 0.275), at (30.85, 2.05, 0.275), at (35.65, 2.05, 0.275), at (29.25, 2.05, 0.275), at (37.25, 2.05, 0.275)) TerminalType=ConstantVoltage Net=DCP
  CapPb_1: Source Faces=P10_DCP_L1.face(at (-32.45, 2.15, -1.475), at (-34.05, 2.15, -1.475), at (-29.25, 2.15, -1.475), at (-30.85, 2.15, -1.475)) TerminalType=ConstantVoltage Net=DCP
  CapPb_2: Source Faces=P10_DCP_L1.face(at (-15.05, 2.15, -1.475), at (-13.45, 2.15, -1.475), at (-18.25, 2.15, -1.475), at (-16.65, 2.15, -1.475)) TerminalType=ConstantVoltage Net=DCP
  CapPb_3: Source Faces=P10_DCP_L1.face(at (16.65, 2.15, -1.475), at (18.25, 2.15, -1.475), at (13.45, 2.15, -1.475), at (15.05, 2.15, -1.475)) TerminalType=ConstantVoltage Net=DCP
  CapPb_4: Source Faces=P10_DCP_L1.face(at (32.45, 2.15, -1.475), at (30.85, 2.15, -1.475), at (29.25, 2.15, -1.475), at (34.05, 2.15, -1.475)) TerminalType=ConstantVoltage Net=DCP
  QH_D_1: Source Faces=P10_DCP_L1.face(at (-31.975, 4.9, 0.275), at (-33.675, 4.9, 0.275), at (-35.602, 4.9, 0.275)) TerminalType=ConstantVoltage Net=DCP
  QH_D_2: Source Faces=P10_DCP_L1.face(at (-15.525, 4.9, 0.275), at (-13.825, 4.9, 0.275), at (-11.898, 4.9, 0.275)) TerminalType=ConstantVoltage Net=DCP
  QH_D_3: Source Faces=P10_DCP_L1.face(at (15.525, 4.9, 0.275), at (13.825, 4.9, 0.275), at (11.898, 4.9, 0.275)) TerminalType=ConstantVoltage Net=DCP
  QH_D_4: Source Faces=P10_DCP_L1.face(at (31.975, 4.9, 0.275), at (33.675, 4.9, 0.275), at (35.602, 4.9, 0.275)) TerminalType=ConstantVoltage Net=DCP
  QL_D_1: Source Faces=P27_AC1_L1.face(at (-31.975, 9.2, 0.275), at (-33.675, 9.2, 0.275), at (-35.602, 9.2, 0.275)) TerminalType=ConstantVoltage Net=AC1
  QL_D_2: Source Faces=P28_AC2_L1.face(at (-15.525, 9.2, 0.275), at (-13.825, 9.2, 0.275), at (-11.898, 9.2, 0.275)) TerminalType=ConstantVoltage Net=AC2
  QL_D_3: Source Faces=P29_AC3_L1.face(at (15.525, 9.2, 0.275), at (13.825, 9.2, 0.275), at (11.898, 9.2, 0.275)) TerminalType=ConstantVoltage Net=AC3
  QL_D_4: Source Faces=P30_AC4_L1.face(at (31.975, 9.2, 0.275), at (33.675, 9.2, 0.275), at (35.602, 9.2, 0.275)) TerminalType=ConstantVoltage Net=AC4
  QL_S_1: Source Faces=P19_LSRC1_L1.face(at (-32.825, 9.2, 0.275), at (-34.525, 9.2, 0.275)) TerminalType=ConstantVoltage Net=LSRC1
  QL_S_2: Source Faces=P21_LSRC2_L1.face(at (-14.675, 9.2, 0.275), at (-12.975, 9.2, 0.275)) TerminalType=ConstantVoltage Net=LSRC2
  QL_S_3: Source Faces=P23_LSRC3_L1.face(at (14.675, 9.2, 0.275), at (12.975, 9.2, 0.275)) TerminalType=ConstantVoltage Net=LSRC3
  QL_S_4: Source Faces=P25_LSRC4_L1.face(at (32.825, 9.2, 0.275), at (34.525, 9.2, 0.275)) TerminalType=ConstantVoltage Net=LSRC4
  RSN_1: Source Faces=P0_DCN_L1.face(at (-36.15, 14.4, 0.275)) TerminalType=ConstantVoltage Net=DCN
  RSN_2: Source Faces=P0_DCN_L1.face(at (-11.35, 14.4, 0.275)) TerminalType=ConstantVoltage Net=DCN
  RSN_3: Source Faces=P0_DCN_L1.face(at (11.35, 14.4, 0.275)) TerminalType=ConstantVoltage Net=DCN
  RSN_4: Source Faces=P0_DCN_L1.face(at (36.15, 14.4, 0.275)) TerminalType=ConstantVoltage Net=DCN
  CapN_1: Sink Faces=P0_DCN_L1.face(at (-34.05, 0.15, 0.275), at (-37.25, 0.15, 0.275), at (-29.25, 0.15, 0.275), at (-32.45, 0.15, 0.275), at (-30.85, 0.15, 0.275), at (-35.65, 0.15, 0.275)) TerminalType=ConstantVoltage Net=DCN
  CapP_1: Sink Faces=P10_DCP_L1.face(at (-34.05, 2.05, 0.275), at (-37.25, 2.05, 0.275), at (-29.25, 2.05, 0.275), at (-32.45, 2.05, 0.275), at (-30.85, 2.05, 0.275), at (-35.65, 2.05, 0.275)) TerminalType=ConstantVoltage Net=DCP
  QH_S_1: Sink Faces=P27_AC1_L1.face(at (-32.825, 4.9, 0.275), at (-34.525, 4.9, 0.275)) TerminalType=ConstantVoltage Net=AC1
  QH_S_2: Sink Faces=P28_AC2_L1.face(at (-14.675, 4.9, 0.275), at (-12.975, 4.9, 0.275)) TerminalType=ConstantVoltage Net=AC2
  QH_S_3: Sink Faces=P29_AC3_L1.face(at (14.675, 4.9, 0.275), at (12.975, 4.9, 0.275)) TerminalType=ConstantVoltage Net=AC3
  QH_S_4: Sink Faces=P30_AC4_L1.face(at (32.825, 4.9, 0.275), at (34.525, 4.9, 0.275)) TerminalType=ConstantVoltage Net=AC4
  RSI_1: Sink Faces=P19_LSRC1_L1.face(at (-36.15, 11.8, 0.275)) TerminalType=ConstantVoltage Net=LSRC1
  RSI_2: Sink Faces=P21_LSRC2_L1.face(at (-11.35, 11.8, 0.275)) TerminalType=ConstantVoltage Net=LSRC2
  RSI_3: Sink Faces=P23_LSRC3_L1.face(at (11.35, 11.8, 0.275)) TerminalType=ConstantVoltage Net=LSRC3
  RSI_4: Sink Faces=P25_LSRC4_L1.face(at (36.15, 11.8, 0.275)) TerminalType=ConstantVoltage Net=LSRC4
setups:
  Setup1: Matrix AdaptiveFreq=100MHz Cap{MaxPass=1 MinPass=1 MinConvPass=1 PerError=30 PerRefine=30 AutoIncreaseAccuracy AccuracyLevel=High Solver_Type=Iterative} DC{SolveResOnly Cond{MaxPass=3 MinPass=1 MinConvPass=1 PerError=5 PerRefine=30} Mult{MaxPass=1 MinPass=1 MinConvPass=1 PerError=1 PerRefine=30} AccuracyLevel=Normal} AC{MaxPass=8 MinPass=2 MinConvPass=1 PerError=2 PerRefine=30 ACRLSolverType=ACA} ErrorValue=0.1
source amplitudes:
  AC1:QL_D_1, AC2:QL_D_2, AC3:QL_D_3, AC4:QL_D_4, DCN:CapN_3, DCN:CapN_4, DCN:CapNb_1..DCN:CapNb_4, DCN:RSN_1..DCN:RSN_4, DCP:CapP_2, DCP:CapP_3, DCP:CapP_4, DCP:CapPb_1..DCP:CapPb_4, DCP:QH_D_1..DCP:QH_D_4, LSRC1:QL_S_1, LSRC2:QL_S_2, LSRC3:QL_S_3, LSRC4:QL_S_4: AC R/L Fields 0A
  DCN:CapN_2: AC R/L Fields 1A
  AC1: CG Fields 1V 0deg
  AC2, AC3, AC4, DCN, DCP, LSRC1..LSRC4: CG Fields 0V 0deg
  AC1:QL_D_1, AC2:QL_D_2, AC3:QL_D_3, AC4:QL_D_4, DCN:CapN_3, DCN:CapN_4, DCN:CapNb_1..DCN:CapNb_4, DCN:RSN_1..DCN:RSN_4, DCP:CapP_2, DCP:CapP_3, DCP:CapP_4, DCP:CapPb_1..DCP:CapPb_4, DCP:QH_D_1..DCP:QH_D_4, LSRC1:QL_S_1, LSRC2:QL_S_2, LSRC3:QL_S_3, LSRC4:QL_S_4: DC R/L Fields 0A
  DCN:CapN_2: DC R/L Fields 1A
