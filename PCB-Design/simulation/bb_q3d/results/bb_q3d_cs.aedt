# Ansys Electronics Desktop project, version 2024.2
materials:
  vacuum: permittivity=1
  copper: permeability=0.999991 conductivity=58000000

design BB_CS (Q3D Extractor, model units mm)
options: SParamCalcMethod=EqTransLine Calculate_Lossy_Dielectrics
variables:
  h_diel = 0.1mm
  h_23 = 1.2mm
  h_34 = 0.1mm
  t_L1 = 0.07mm
  t_L2 = 0.07mm
  t_L3 = 0.07mm
  t_L4 = 0.07mm
  t_pad = 0.035mm
  via_r = 0.15mm
  r_anti = 0.35mm
  z_L1 = t_L2+h_diel
  z_top = z_L1+t_L1
  z_L3t = -h_23
  z_L3b = -h_23-t_L3
  z_L4t = z_L3b-h_34
  z_L4b = z_L4t-t_L4
geometry:
  P1 [copper] = box(corner=(-15mm, -13.4mm, z_L1), size=(30mm, 2.4mm, (z_top)-(z_L1)))
  N1 [copper] = box(corner=(-15mm, -10.4mm, z_L1), size=(30mm, 3.4mm, (z_top)-(z_L1)))
  P2 = box(corner=(-15mm, -6.4mm, z_L1), size=(30mm, 3.4mm, (z_top)-(z_L1)))
  N2 = box(corner=(-15mm, -2.4mm, z_L1), size=(30mm, 3.3mm, (z_top)-(z_L1)))
  B1P_u1 = box(corner=(-5.75mm, -12.4mm, z_top), size=(2mm, 0.8mm, (z_top+t_pad)-(z_top)))
  B1N_l1 = box(corner=(-5.75mm, -9.8mm, z_top), size=(2mm, 0.8mm, (z_top+t_pad)-(z_top)))
  B1P_u2 = box(corner=(-8.75mm, -12.4mm, z_top), size=(2mm, 0.8mm, (z_top+t_pad)-(z_top)))
  B1N_l2 = box(corner=(-8.75mm, -9.8mm, z_top), size=(2mm, 0.8mm, (z_top+t_pad)-(z_top)))
  B1P_u3 = box(corner=(-11.75mm, -12.4mm, z_top), size=(2mm, 0.8mm, (z_top+t_pad)-(z_top)))
  B1N_l3 = box(corner=(-11.75mm, -9.8mm, z_top), size=(2mm, 0.8mm, (z_top+t_pad)-(z_top)))
  B1P_u4 = box(corner=(-14.75mm, -12.4mm, z_top), size=(2mm, 0.8mm, (z_top+t_pad)-(z_top)))
  B1N_l4 = box(corner=(-14.75mm, -9.8mm, z_top), size=(2mm, 0.8mm, (z_top+t_pad)-(z_top)))
  B1P_u5 = box(corner=(3.75mm, -12.4mm, z_top), size=(2mm, 0.8mm, (z_top+t_pad)-(z_top)))
  B1N_l5 = box(corner=(3.75mm, -9.8mm, z_top), size=(2mm, 0.8mm, (z_top+t_pad)-(z_top)))
  B1P_u6 = box(corner=(6.75mm, -12.4mm, z_top), size=(2mm, 0.8mm, (z_top+t_pad)-(z_top)))
  B1N_l6 = box(corner=(6.75mm, -9.8mm, z_top), size=(2mm, 0.8mm, (z_top+t_pad)-(z_top)))
  B1P_u7 = box(corner=(9.75mm, -12.4mm, z_top), size=(2mm, 0.8mm, (z_top+t_pad)-(z_top)))
  B1N_l7 = box(corner=(9.75mm, -9.8mm, z_top), size=(2mm, 0.8mm, (z_top+t_pad)-(z_top)))
  B1P_u8 = box(corner=(12.75mm, -12.4mm, z_top), size=(2mm, 0.8mm, (z_top+t_pad)-(z_top)))
  B1N_l8 = box(corner=(12.75mm, -9.8mm, z_top), size=(2mm, 0.8mm, (z_top+t_pad)-(z_top)))
  B2N_u1 = box(corner=(-5.75mm, -8.4mm, z_top), size=(2mm, 0.8mm, (z_top+t_pad)-(z_top)))
  B2P_l1 = box(corner=(-5.75mm, -5.8mm, z_top), size=(2mm, 0.8mm, (z_top+t_pad)-(z_top)))
  B2N_u2 = box(corner=(-8.75mm, -8.4mm, z_top), size=(2mm, 0.8mm, (z_top+t_pad)-(z_top)))
  B2P_l2 = box(corner=(-8.75mm, -5.8mm, z_top), size=(2mm, 0.8mm, (z_top+t_pad)-(z_top)))
  B2N_u3 = box(corner=(-11.75mm, -8.4mm, z_top), size=(2mm, 0.8mm, (z_top+t_pad)-(z_top)))
  B2P_l3 = box(corner=(-11.75mm, -5.8mm, z_top), size=(2mm, 0.8mm, (z_top+t_pad)-(z_top)))
  B2N_u4 = box(corner=(-14.75mm, -8.4mm, z_top), size=(2mm, 0.8mm, (z_top+t_pad)-(z_top)))
  B2P_l4 = box(corner=(-14.75mm, -5.8mm, z_top), size=(2mm, 0.8mm, (z_top+t_pad)-(z_top)))
  B2N_u5 = box(corner=(3.75mm, -8.4mm, z_top), size=(2mm, 0.8mm, (z_top+t_pad)-(z_top)))
  B2P_l5 = box(corner=(3.75mm, -5.8mm, z_top), size=(2mm, 0.8mm, (z_top+t_pad)-(z_top)))
  B2N_u6 = box(corner=(6.75mm, -8.4mm, z_top), size=(2mm, 0.8mm, (z_top+t_pad)-(z_top)))
  B2P_l6 = box(corner=(6.75mm, -5.8mm, z_top), size=(2mm, 0.8mm, (z_top+t_pad)-(z_top)))
  B2N_u7 = box(corner=(9.75mm, -8.4mm, z_top), size=(2mm, 0.8mm, (z_top+t_pad)-(z_top)))
  B2P_l7 = box(corner=(9.75mm, -5.8mm, z_top), size=(2mm, 0.8mm, (z_top+t_pad)-(z_top)))
  B2N_u8 = box(corner=(12.75mm, -8.4mm, z_top), size=(2mm, 0.8mm, (z_top+t_pad)-(z_top)))
  B2P_l8 = box(corner=(12.75mm, -5.8mm, z_top), size=(2mm, 0.8mm, (z_top+t_pad)-(z_top)))
  B3P_u1 = box(corner=(-5.75mm, -4.4mm, z_top), size=(2mm, 0.8mm, (z_top+t_pad)-(z_top)))
  B3N_l1 = box(corner=(-5.75mm, -1.8mm, z_top), size=(2mm, 0.8mm, (z_top+t_pad)-(z_top)))
  B3P_u2 = box(corner=(-8.75mm, -4.4mm, z_top), size=(2mm, 0.8mm, (z_top+t_pad)-(z_top)))
  B3N_l2 = box(corner=(-8.75mm, -1.8mm, z_top), size=(2mm, 0.8mm, (z_top+t_pad)-(z_top)))
  B3P_u3 = box(corner=(-11.75mm, -4.4mm, z_top), size=(2mm, 0.8mm, (z_top+t_pad)-(z_top)))
  B3N_l3 = box(corner=(-11.75mm, -1.8mm, z_top), size=(2mm, 0.8mm, (z_top+t_pad)-(z_top)))
  B3P_u4 = box(corner=(-14.75mm, -4.4mm, z_top), size=(2mm, 0.8mm, (z_top+t_pad)-(z_top)))
  B3N_l4 = box(corner=(-14.75mm, -1.8mm, z_top), size=(2mm, 0.8mm, (z_top+t_pad)-(z_top)))
  B3P_u5 = box(corner=(3.75mm, -4.4mm, z_top), size=(2mm, 0.8mm, (z_top+t_pad)-(z_top)))
  B3N_l5 = box(corner=(3.75mm, -1.8mm, z_top), size=(2mm, 0.8mm, (z_top+t_pad)-(z_top)))
  B3P_u6 = box(corner=(6.75mm, -4.4mm, z_top), size=(2mm, 0.8mm, (z_top+t_pad)-(z_top)))
  B3N_l6 = box(corner=(6.75mm, -1.8mm, z_top), size=(2mm, 0.8mm, (z_top+t_pad)-(z_top)))
  B3P_u7 = box(corner=(9.75mm, -4.4mm, z_top), size=(2mm, 0.8mm, (z_top+t_pad)-(z_top)))
  B3N_l7 = box(corner=(9.75mm, -1.8mm, z_top), size=(2mm, 0.8mm, (z_top+t_pad)-(z_top)))
  B3P_u8 = box(corner=(12.75mm, -4.4mm, z_top), size=(2mm, 0.8mm, (z_top+t_pad)-(z_top)))
  B3N_l8 = box(corner=(12.75mm, -1.8mm, z_top), size=(2mm, 0.8mm, (z_top+t_pad)-(z_top)))
  CapNL0 = box(corner=(-11.625mm, 0.2mm, z_top), size=(1.25mm, 0.5mm, (z_top+t_pad)-(z_top)))
  CapPL0 = box(corner=(-11.625mm, 1.7mm, z_top), size=(1.25mm, 0.5mm, (z_top+t_pad)-(z_top)))
  CapNL1 = box(corner=(-10.225mm, 0.2mm, z_top), size=(1.25mm, 0.5mm, (z_top+t_pad)-(z_top)))
  CapPL1 = box(corner=(-10.225mm, 1.7mm, z_top), size=(1.25mm, 0.5mm, (z_top+t_pad)-(z_top)))
  CapNL2 = box(corner=(-8.825mm, 0.2mm, z_top), size=(1.25mm, 0.5mm, (z_top+t_pad)-(z_top)))
  CapPL2 = box(corner=(-8.825mm, 1.7mm, z_top), size=(1.25mm, 0.5mm, (z_top+t_pad)-(z_top)))
  CapNL3 = box(corner=(-7.425mm, 0.2mm, z_top), size=(1.25mm, 0.5mm, (z_top+t_pad)-(z_top)))
  CapPL3 = box(corner=(-7.425mm, 1.7mm, z_top), size=(1.25mm, 0.5mm, (z_top+t_pad)-(z_top)))
  CapNL4 = box(corner=(-6.025mm, 0.2mm, z_top), size=(1.25mm, 0.5mm, (z_top+t_pad)-(z_top)))
  CapPL4 = box(corner=(-6.025mm, 1.7mm, z_top), size=(1.25mm, 0.5mm, (z_top+t_pad)-(z_top)))
  CapNL5 = box(corner=(-4.625mm, 0.2mm, z_top), size=(1.25mm, 0.5mm, (z_top+t_pad)-(z_top)))
  CapPL5 = box(corner=(-4.625mm, 1.7mm, z_top), size=(1.25mm, 0.5mm, (z_top+t_pad)-(z_top)))
  DCP_L = box(corner=(-12mm, 1.5mm, z_L1), size=(9mm, 3.1mm, (z_top)-(z_L1)))
  AC_L [copper] = box(corner=(-12mm, 5.2mm, z_L1), size=(9mm, 3.7mm, (z_top)-(z_L1)))
  SRC_L = box(corner=(-12mm, 9.5mm, z_L1), size=(9mm, 2mm, (z_top)-(z_L1)))
  QH_D_L = box(corner=(-10mm, 3.4mm, z_top), size=(5mm, 1mm, (z_top+t_pad)-(z_top)))
  QH_S_L = box(corner=(-10mm, 5.4mm, z_top), size=(5mm, 1mm, (z_top+t_pad)-(z_top)))
  QL_D_L = box(corner=(-10mm, 7.7mm, z_top), size=(5mm, 1mm, (z_top+t_pad)-(z_top)))
  QL_S_L = box(corner=(-10mm, 9.7mm, z_top), size=(5mm, 1mm, (z_top+t_pad)-(z_top)))
  CapNR0 = box(corner=(3.375mm, 0.2mm, z_top), size=(1.25mm, 0.5mm, (z_top+t_pad)-(z_top)))
  CapPR0 = box(corner=(3.375mm, 1.7mm, z_top), size=(1.25mm, 0.5mm, (z_top+t_pad)-(z_top)))
  CapNR1 = box(corner=(4.775mm, 0.2mm, z_top), size=(1.25mm, 0.5mm, (z_top+t_pad)-(z_top)))
  CapPR1 = box(corner=(4.775mm, 1.7mm, z_top), size=(1.25mm, 0.5mm, (z_top+t_pad)-(z_top)))
  CapNR2 = box(corner=(6.175mm, 0.2mm, z_top), size=(1.25mm, 0.5mm, (z_top+t_pad)-(z_top)))
  CapPR2 = box(corner=(6.175mm, 1.7mm, z_top), size=(1.25mm, 0.5mm, (z_top+t_pad)-(z_top)))
  CapNR3 = box(corner=(7.575mm, 0.2mm, z_top), size=(1.25mm, 0.5mm, (z_top+t_pad)-(z_top)))
  CapPR3 = box(corner=(7.575mm, 1.7mm, z_top), size=(1.25mm, 0.5mm, (z_top+t_pad)-(z_top)))
  CapNR4 = box(corner=(8.975mm, 0.2mm, z_top), size=(1.25mm, 0.5mm, (z_top+t_pad)-(z_top)))
  CapPR4 = box(corner=(8.975mm, 1.7mm, z_top), size=(1.25mm, 0.5mm, (z_top+t_pad)-(z_top)))
  CapNR5 = box(corner=(10.375mm, 0.2mm, z_top), size=(1.25mm, 0.5mm, (z_top+t_pad)-(z_top)))
  CapPR5 = box(corner=(10.375mm, 1.7mm, z_top), size=(1.25mm, 0.5mm, (z_top+t_pad)-(z_top)))
  DCP_R = box(corner=(3mm, 1.5mm, z_L1), size=(9mm, 3.1mm, (z_top)-(z_L1)))
  AC_R = box(corner=(3mm, 5.2mm, z_L1), size=(9mm, 3.7mm, (z_top)-(z_L1)))
  SRC_R = box(corner=(3mm, 9.5mm, z_L1), size=(9mm, 2mm, (z_top)-(z_L1)))
  QH_D_R = box(corner=(5mm, 3.4mm, z_top), size=(5mm, 1mm, (z_top+t_pad)-(z_top)))
  QH_S_R = box(corner=(5mm, 5.4mm, z_top), size=(5mm, 1mm, (z_top+t_pad)-(z_top)))
  QL_D_R = box(corner=(5mm, 7.7mm, z_top), size=(5mm, 1mm, (z_top+t_pad)-(z_top)))
  QL_S_R = box(corner=(5mm, 9.7mm, z_top), size=(5mm, 1mm, (z_top+t_pad)-(z_top)))
  L2_DCN = box(corner=(-15mm, -10.4mm, 0mm), size=(30mm, 22.3mm, (t_L2)-(0mm)))
  L3_DCP = box(corner=(-15mm, -13.4mm, z_L3b), size=(30mm, 18mm, (z_L3t)-(z_L3b)))
  L4_AC = box(corner=(-12mm, 4.6mm, z_L4b), size=(24mm, 10.4mm, (z_L4t)-(z_L4b)))
  T_DCP = box(corner=(-3mm, -13.4mm, z_top), size=(6mm, 0.8mm, (z_top+t_pad)-(z_top)))
  T_DCN = box(corner=(-3mm, -9.6mm, z_top), size=(6mm, 1.8mm, (z_top+t_pad)-(z_top)))
  T_AC = box(corner=(-4mm, 13.6mm, z_L4b-t_pad), size=(8mm, 1.2mm, (z_L4b)-(z_L4b-t_pad)))
  via1 = cylinder(axis=Z, base_centre=(-14.4mm, -12.9mm, z_L3b), radius=via_r, height=z_top-(z_L3b))
  via2 = cylinder(axis=Z, base_centre=(-13.2mm, -12.9mm, z_L3b), radius=via_r, height=z_top-(z_L3b))
  via3 = cylinder(axis=Z, base_centre=(-12mm, -12.9mm, z_L3b), radius=via_r, height=z_top-(z_L3b))
  via4 = cylinder(axis=Z, base_centre=(-10.8mm, -12.9mm, z_L3b), radius=via_r, height=z_top-(z_L3b))
  via5 = cylinder(axis=Z, base_centre=(-9.6mm, -12.9mm, z_L3b), radius=via_r, height=z_top-(z_L3b))
  via6 = cylinder(axis=Z, base_centre=(-8.4mm, -12.9mm, z_L3b), radius=via_r, height=z_top-(z_L3b))
  via7 = cylinder(axis=Z, base_centre=(-7.2mm, -12.9mm, z_L3b), radius=via_r, height=z_top-(z_L3b))
  via8 = cylinder(axis=Z, base_centre=(-6mm, -12.9mm, z_L3b), radius=via_r, height=z_top-(z_L3b))
  via9 = cylinder(axis=Z, base_centre=(-4.8mm, -12.9mm, z_L3b), radius=via_r, height=z_top-(z_L3b))
  via10 = cylinder(axis=Z, base_centre=(-3.6mm, -12.9mm, z_L3b), radius=via_r, height=z_top-(z_L3b))
  via11 = cylinder(axis=Z, base_centre=(-2.4mm, -12.9mm, z_L3b), radius=via_r, height=z_top-(z_L3b))
  via12 = cylinder(axis=Z, base_centre=(-1.2mm, -12.9mm, z_L3b), radius=via_r, height=z_top-(z_L3b))
  via13 = cylinder(axis=Z, base_centre=(0mm, -12.9mm, z_L3b), radius=via_r, height=z_top-(z_L3b))
  via14 = cylinder(axis=Z, base_centre=(1.2mm, -12.9mm, z_L3b), radius=via_r, height=z_top-(z_L3b))
  via15 = cylinder(axis=Z, base_centre=(2.4mm, -12.9mm, z_L3b), radius=via_r, height=z_top-(z_L3b))
  via16 = cylinder(axis=Z, base_centre=(3.6mm, -12.9mm, z_L3b), radius=via_r, height=z_top-(z_L3b))
  via17 = cylinder(axis=Z, base_centre=(4.8mm, -12.9mm, z_L3b), radius=via_r, height=z_top-(z_L3b))
  via18 = cylinder(axis=Z, base_centre=(6mm, -12.9mm, z_L3b), radius=via_r, height=z_top-(z_L3b))
  via19 = cylinder(axis=Z, base_centre=(7.2mm, -12.9mm, z_L3b), radius=via_r, height=z_top-(z_L3b))
  via20 = cylinder(axis=Z, base_centre=(8.4mm, -12.9mm, z_L3b), radius=via_r, height=z_top-(z_L3b))
  via21 = cylinder(axis=Z, base_centre=(9.6mm, -12.9mm, z_L3b), radius=via_r, height=z_top-(z_L3b))
  via22 = cylinder(axis=Z, base_centre=(10.8mm, -12.9mm, z_L3b), radius=via_r, height=z_top-(z_L3b))
  via23 = cylinder(axis=Z, base_centre=(12mm, -12.9mm, z_L3b), radius=via_r, height=z_top-(z_L3b))
  via24 = cylinder(axis=Z, base_centre=(13.2mm, -12.9mm, z_L3b), radius=via_r, height=z_top-(z_L3b))
  via25 = cylinder(axis=Z, base_centre=(14.4mm, -12.9mm, z_L3b), radius=via_r, height=z_top-(z_L3b))
  via26 = cylinder(axis=Z, base_centre=(-14.4mm, -8.7mm, 0mm), radius=via_r, height=z_top-(0mm))
  via27 = cylinder(axis=Z, base_centre=(-13.2mm, -8.7mm, 0mm), radius=via_r, height=z_top-(0mm))
  via28 = cylinder(axis=Z, base_centre=(-12mm, -8.7mm, 0mm), radius=via_r, height=z_top-(0mm))
  via29 = cylinder(axis=Z, base_centre=(-10.8mm, -8.7mm, 0mm), radius=via_r, height=z_top-(0mm))
  via30 = cylinder(axis=Z, base_centre=(-9.6mm, -8.7mm, 0mm), radius=via_r, height=z_top-(0mm))
  via31 = cylinder(axis=Z, base_centre=(-8.4mm, -8.7mm, 0mm), radius=via_r, height=z_top-(0mm))
  via32 = cylinder(axis=Z, base_centre=(-7.2mm, -8.7mm, 0mm), radius=via_r, height=z_top-(0mm))
  via33 = cylinder(axis=Z, base_centre=(-6mm, -8.7mm, 0mm), radius=via_r, height=z_top-(0mm))
  via34 = cylinder(axis=Z, base_centre=(-4.8mm, -8.7mm, 0mm), radius=via_r, height=z_top-(0mm))
  via35 = cylinder(axis=Z, base_centre=(-3.6mm, -8.7mm, 0mm), radius=via_r, height=z_top-(0mm))
  via36 = cylinder(axis=Z, base_centre=(-2.4mm, -8.7mm, 0mm), radius=via_r, height=z_top-(0mm))
  via37 = cylinder(axis=Z, base_centre=(-1.2mm, -8.7mm, 0mm), radius=via_r, height=z_top-(0mm))
  via38 = cylinder(axis=Z, base_centre=(0mm, -8.7mm, 0mm), radius=via_r, height=z_top-(0mm))
  via39 = cylinder(axis=Z, base_centre=(1.2mm, -8.7mm, 0mm), radius=via_r, height=z_top-(0mm))
  via40 = cylinder(axis=Z, base_centre=(2.4mm, -8.7mm, 0mm), radius=via_r, height=z_top-(0mm))
  via41 = cylinder(axis=Z, base_centre=(3.6mm, -8.7mm, 0mm), radius=via_r, height=z_top-(0mm))
  via42 = cylinder(axis=Z, base_centre=(4.8mm, -8.7mm, 0mm), radius=via_r, height=z_top-(0mm))
  via43 = cylinder(axis=Z, base_centre=(6mm, -8.7mm, 0mm), radius=via_r, height=z_top-(0mm))
  via44 = cylinder(axis=Z, base_centre=(7.2mm, -8.7mm, 0mm), radius=via_r, height=z_top-(0mm))
  via45 = cylinder(axis=Z, base_centre=(8.4mm, -8.7mm, 0mm), radius=via_r, height=z_top-(0mm))
  via46 = cylinder(axis=Z, base_centre=(9.6mm, -8.7mm, 0mm), radius=via_r, height=z_top-(0mm))
  via47 = cylinder(axis=Z, base_centre=(10.8mm, -8.7mm, 0mm), radius=via_r, height=z_top-(0mm))
  via48 = cylinder(axis=Z, base_centre=(12mm, -8.7mm, 0mm), radius=via_r, height=z_top-(0mm))
  via49 = cylinder(axis=Z, base_centre=(13.2mm, -8.7mm, 0mm), radius=via_r, height=z_top-(0mm))
  via50 = cylinder(axis=Z, base_centre=(14.4mm, -8.7mm, 0mm), radius=via_r, height=z_top-(0mm))
  via51 = cylinder(axis=Z, base_centre=(-14.4mm, -4.7mm, z_L3b), radius=via_r, height=z_top-(z_L3b))
  via52 = cylinder(axis=Z, base_centre=(-13.2mm, -4.7mm, z_L3b), radius=via_r, height=z_top-(z_L3b))
  via53 = cylinder(axis=Z, base_centre=(-12mm, -4.7mm, z_L3b), radius=via_r, height=z_top-(z_L3b))
  via54 = cylinder(axis=Z, base_centre=(-10.8mm, -4.7mm, z_L3b), radius=via_r, height=z_top-(z_L3b))
  via55 = cylinder(axis=Z, base_centre=(-9.6mm, -4.7mm, z_L3b), radius=via_r, height=z_top-(z_L3b))
  via56 = cylinder(axis=Z, base_centre=(-8.4mm, -4.7mm, z_L3b), radius=via_r, height=z_top-(z_L3b))
  via57 = cylinder(axis=Z, base_centre=(-7.2mm, -4.7mm, z_L3b), radius=via_r, height=z_top-(z_L3b))
  via58 = cylinder(axis=Z, base_centre=(-6mm, -4.7mm, z_L3b), radius=via_r, height=z_top-(z_L3b))
  via59 = cylinder(axis=Z, base_centre=(-4.8mm, -4.7mm, z_L3b), radius=via_r, height=z_top-(z_L3b))
  via60 = cylinder(axis=Z, base_centre=(-3.6mm, -4.7mm, z_L3b), radius=via_r, height=z_top-(z_L3b))
  via61 = cylinder(axis=Z, base_centre=(-2.4mm, -4.7mm, z_L3b), radius=via_r, height=z_top-(z_L3b))
  via62 = cylinder(axis=Z, base_centre=(-1.2mm, -4.7mm, z_L3b), radius=via_r, height=z_top-(z_L3b))
  via63 = cylinder(axis=Z, base_centre=(0mm, -4.7mm, z_L3b), radius=via_r, height=z_top-(z_L3b))
  via64 = cylinder(axis=Z, base_centre=(1.2mm, -4.7mm, z_L3b), radius=via_r, height=z_top-(z_L3b))
  via65 = cylinder(axis=Z, base_centre=(2.4mm, -4.7mm, z_L3b), radius=via_r, height=z_top-(z_L3b))
  via66 = cylinder(axis=Z, base_centre=(3.6mm, -4.7mm, z_L3b), radius=via_r, height=z_top-(z_L3b))
  via67 = cylinder(axis=Z, base_centre=(4.8mm, -4.7mm, z_L3b), radius=via_r, height=z_top-(z_L3b))
  via68 = cylinder(axis=Z, base_centre=(6mm, -4.7mm, z_L3b), radius=via_r, height=z_top-(z_L3b))
  via69 = cylinder(axis=Z, base_centre=(7.2mm, -4.7mm, z_L3b), radius=via_r, height=z_top-(z_L3b))
  via70 = cylinder(axis=Z, base_centre=(8.4mm, -4.7mm, z_L3b), radius=via_r, height=z_top-(z_L3b))
  via71 = cylinder(axis=Z, base_centre=(9.6mm, -4.7mm, z_L3b), radius=via_r, height=z_top-(z_L3b))
  via72 = cylinder(axis=Z, base_centre=(10.8mm, -4.7mm, z_L3b), radius=via_r, height=z_top-(z_L3b))
  via73 = cylinder(axis=Z, base_centre=(12mm, -4.7mm, z_L3b), radius=via_r, height=z_top-(z_L3b))
  via74 = cylinder(axis=Z, base_centre=(13.2mm, -4.7mm, z_L3b), radius=via_r, height=z_top-(z_L3b))
  via75 = cylinder(axis=Z, base_centre=(14.4mm, -4.7mm, z_L3b), radius=via_r, height=z_top-(z_L3b))
  via76 = cylinder(axis=Z, base_centre=(-14.4mm, -0.5mm, 0mm), radius=via_r, height=z_top-(0mm))
  via77 = cylinder(axis=Z, base_centre=(-13.2mm, -0.5mm, 0mm), radius=via_r, height=z_top-(0mm))
  via78 = cylinder(axis=Z, base_centre=(-12mm, -0.5mm, 0mm), radius=via_r, height=z_top-(0mm))
  via79 = cylinder(axis=Z, base_centre=(-10.8mm, -0.5mm, 0mm), radius=via_r, height=z_top-(0mm))
  via80 = cylinder(axis=Z, base_centre=(-9.6mm, -0.5mm, 0mm), radius=via_r, height=z_top-(0mm))
  via81 = cylinder(axis=Z, base_centre=(-8.4mm, -0.5mm, 0mm), radius=via_r, height=z_top-(0mm))
  via82 = cylinder(axis=Z, base_centre=(-7.2mm, -0.5mm, 0mm), radius=via_r, height=z_top-(0mm))
  via83 = cylinder(axis=Z, base_centre=(-6mm, -0.5mm, 0mm), radius=via_r, height=z_top-(0mm))
  via84 = cylinder(axis=Z, base_centre=(-4.8mm, -0.5mm, 0mm), radius=via_r, height=z_top-(0mm))
  via85 = cylinder(axis=Z, base_centre=(-3.6mm, -0.5mm, 0mm), radius=via_r, height=z_top-(0mm))
  via86 = cylinder(axis=Z, base_centre=(-2.4mm, -0.5mm, 0mm), radius=via_r, height=z_top-(0mm))
  via87 = cylinder(axis=Z, base_centre=(-1.2mm, -0.5mm, 0mm), radius=via_r, height=z_top-(0mm))
  via88 = cylinder(axis=Z, base_centre=(0mm, -0.5mm, 0mm), radius=via_r, height=z_top-(0mm))
  via89 = cylinder(axis=Z, base_centre=(1.2mm, -0.5mm, 0mm), radius=via_r, height=z_top-(0mm))
  via90 = cylinder(axis=Z, base_centre=(2.4mm, -0.5mm, 0mm), radius=via_r, height=z_top-(0mm))
  via91 = cylinder(axis=Z, base_centre=(3.6mm, -0.5mm, 0mm), radius=via_r, height=z_top-(0mm))
  via92 = cylinder(axis=Z, base_centre=(4.8mm, -0.5mm, 0mm), radius=via_r, height=z_top-(0mm))
  via93 = cylinder(axis=Z, base_centre=(6mm, -0.5mm, 0mm), radius=via_r, height=z_top-(0mm))
  via94 = cylinder(axis=Z, base_centre=(7.2mm, -0.5mm, 0mm), radius=via_r, height=z_top-(0mm))
  via95 = cylinder(axis=Z, base_centre=(8.4mm, -0.5mm, 0mm), radius=via_r, height=z_top-(0mm))
  via96 = cylinder(axis=Z, base_centre=(9.6mm, -0.5mm, 0mm), radius=via_r, height=z_top-(0mm))
  via97 = cylinder(axis=Z, base_centre=(10.8mm, -0.5mm, 0mm), radius=via_r, height=z_top-(0mm))
  via98 = cylinder(axis=Z, base_centre=(12mm, -0.5mm, 0mm), radius=via_r, height=z_top-(0mm))
  via99 = cylinder(axis=Z, base_centre=(13.2mm, -0.5mm, 0mm), radius=via_r, height=z_top-(0mm))
  via100 = cylinder(axis=Z, base_centre=(14.4mm, -0.5mm, 0mm), radius=via_r, height=z_top-(0mm))
  via101 = cylinder(axis=Z, base_centre=(-11.55mm, 2.8mm, z_L3b), radius=via_r, height=z_top-(z_L3b))
  via102 = cylinder(axis=Z, base_centre=(-10.65mm, 2.8mm, z_L3b), radius=via_r, height=z_top-(z_L3b))
  via103 = cylinder(axis=Z, base_centre=(-9.75mm, 2.8mm, z_L3b), radius=via_r, height=z_top-(z_L3b))
  via104 = cylinder(axis=Z, base_centre=(-8.85mm, 2.8mm, z_L3b), radius=via_r, height=z_top-(z_L3b))
  via105 = cylinder(axis=Z, base_centre=(-7.95mm, 2.8mm, z_L3b), radius=via_r, height=z_top-(z_L3b))
  via106 = cylinder(axis=Z, base_centre=(-7.05mm, 2.8mm, z_L3b), radius=via_r, height=z_top-(z_L3b))
  via107 = cylinder(axis=Z, base_centre=(-6.15mm, 2.8mm, z_L3b), radius=via_r, height=z_top-(z_L3b))
  via108 = cylinder(axis=Z, base_centre=(-5.25mm, 2.8mm, z_L3b), radius=via_r, height=z_top-(z_L3b))
  via109 = cylinder(axis=Z, base_centre=(-4.35mm, 2.8mm, z_L3b), radius=via_r, height=z_top-(z_L3b))
  via110 = cylinder(axis=Z, base_centre=(-3.45mm, 2.8mm, z_L3b), radius=via_r, height=z_top-(z_L3b))
  via111 = cylinder(axis=Z, base_centre=(-11.55mm, 7.05mm, z_L4b), radius=via_r, height=z_top-(z_L4b))
  via112 = cylinder(axis=Z, base_centre=(-10.65mm, 7.05mm, z_L4b), radius=via_r, height=z_top-(z_L4b))
  via113 = cylinder(axis=Z, base_centre=(-9.75mm, 7.05mm, z_L4b), radius=via_r, height=z_top-(z_L4b))
  via114 = cylinder(axis=Z, base_centre=(-8.85mm, 7.05mm, z_L4b), radius=via_r, height=z_top-(z_L4b))
  via115 = cylinder(axis=Z, base_centre=(-7.95mm, 7.05mm, z_L4b), radius=via_r, height=z_top-(z_L4b))
  via116 = cylinder(axis=Z, base_centre=(-7.05mm, 7.05mm, z_L4b), radius=via_r, height=z_top-(z_L4b))
  via117 = cylinder(axis=Z, base_centre=(-6.15mm, 7.05mm, z_L4b), radius=via_r, height=z_top-(z_L4b))
  via118 = cylinder(axis=Z, base_centre=(-5.25mm, 7.05mm, z_L4b), radius=via_r, height=z_top-(z_L4b))
  via119 = cylinder(axis=Z, base_centre=(-4.35mm, 7.05mm, z_L4b), radius=via_r, height=z_top-(z_L4b))
  via120 = cylinder(axis=Z, base_centre=(-3.45mm, 7.05mm, z_L4b), radius=via_r, height=z_top-(z_L4b))
  via121 = cylinder(axis=Z, base_centre=(-11.55mm, 11.1mm, 0mm), radius=via_r, height=z_top-(0mm))
  via122 = cylinder(axis=Z, base_centre=(-10.65mm, 11.1mm, 0mm), radius=via_r, height=z_top-(0mm))
  via123 = cylinder(axis=Z, base_centre=(-9.75mm, 11.1mm, 0mm), radius=via_r, height=z_top-(0mm))
  via124 = cylinder(axis=Z, base_centre=(-8.85mm, 11.1mm, 0mm), radius=via_r, height=z_top-(0mm))
  via125 = cylinder(axis=Z, base_centre=(-7.95mm, 11.1mm, 0mm), radius=via_r, height=z_top-(0mm))
  via126 = cylinder(axis=Z, base_centre=(-7.05mm, 11.1mm, 0mm), radius=via_r, height=z_top-(0mm))
  via127 = cylinder(axis=Z, base_centre=(-6.15mm, 11.1mm, 0mm), radius=via_r, height=z_top-(0mm))
  via128 = cylinder(axis=Z, base_centre=(-5.25mm, 11.1mm, 0mm), radius=via_r, height=z_top-(0mm))
  via129 = cylinder(axis=Z, base_centre=(-4.35mm, 11.1mm, 0mm), radius=via_r, height=z_top-(0mm))
  via130 = cylinder(axis=Z, base_centre=(-3.45mm, 11.1mm, 0mm), radius=via_r, height=z_top-(0mm))
  via131 = cylinder(axis=Z, base_centre=(3.45mm, 2.8mm, z_L3b), radius=via_r, height=z_top-(z_L3b))
  via132 = cylinder(axis=Z, base_centre=(4.35mm, 2.8mm, z_L3b), radius=via_r, height=z_top-(z_L3b))
  via133 = cylinder(axis=Z, base_centre=(5.25mm, 2.8mm, z_L3b), radius=via_r, height=z_top-(z_L3b))
  via134 = cylinder(axis=Z, base_centre=(6.15mm, 2.8mm, z_L3b), radius=via_r, height=z_top-(z_L3b))
  via135 = cylinder(axis=Z, base_centre=(7.05mm, 2.8mm, z_L3b), radius=via_r, height=z_top-(z_L3b))
  via136 = cylinder(axis=Z, base_centre=(7.95mm, 2.8mm, z_L3b), radius=via_r, height=z_top-(z_L3b))
  via137 = cylinder(axis=Z, base_centre=(8.85mm, 2.8mm, z_L3b), radius=via_r, height=z_top-(z_L3b))
  via138 = cylinder(axis=Z, base_centre=(9.75mm, 2.8mm, z_L3b), radius=via_r, height=z_top-(z_L3b))
  via139 = cylinder(axis=Z, base_centre=(10.65mm, 2.8mm, z_L3b), radius=via_r, height=z_top-(z_L3b))
  via140 = cylinder(axis=Z, base_centre=(11.55mm, 2.8mm, z_L3b), radius=via_r, height=z_top-(z_L3b))
  via141 = cylinder(axis=Z, base_centre=(3.45mm, 7.05mm, z_L4b), radius=via_r, height=z_top-(z_L4b))
  via142 = cylinder(axis=Z, base_centre=(4.35mm, 7.05mm, z_L4b), radius=via_r, height=z_top-(z_L4b))
  via143 = cylinder(axis=Z, base_centre=(5.25mm, 7.05mm, z_L4b), radius=via_r, height=z_top-(z_L4b))
  via144 = cylinder(axis=Z, base_centre=(6.15mm, 7.05mm, z_L4b), radius=via_r, height=z_top-(z_L4b))
  via145 = cylinder(axis=Z, base_centre=(7.05mm, 7.05mm, z_L4b), radius=via_r, height=z_top-(z_L4b))
  via146 = cylinder(axis=Z, base_centre=(7.95mm, 7.05mm, z_L4b), radius=via_r, height=z_top-(z_L4b))
  via147 = cylinder(axis=Z, base_centre=(8.85mm, 7.05mm, z_L4b), radius=via_r, height=z_top-(z_L4b))
  via148 = cylinder(axis=Z, base_centre=(9.75mm, 7.05mm, z_L4b), radius=via_r, height=z_top-(z_L4b))
  via149 = cylinder(axis=Z, base_centre=(10.65mm, 7.05mm, z_L4b), radius=via_r, height=z_top-(z_L4b))
  via150 = cylinder(axis=Z, base_centre=(11.55mm, 7.05mm, z_L4b), radius=via_r, height=z_top-(z_L4b))
  via151 = cylinder(axis=Z, base_centre=(3.45mm, 11.1mm, 0mm), radius=via_r, height=z_top-(0mm))
  via152 = cylinder(axis=Z, base_centre=(4.35mm, 11.1mm, 0mm), radius=via_r, height=z_top-(0mm))
  via153 = cylinder(axis=Z, base_centre=(5.25mm, 11.1mm, 0mm), radius=via_r, height=z_top-(0mm))
  via154 = cylinder(axis=Z, base_centre=(6.15mm, 11.1mm, 0mm), radius=via_r, height=z_top-(0mm))
  via155 = cylinder(axis=Z, base_centre=(7.05mm, 11.1mm, 0mm), radius=via_r, height=z_top-(0mm))
  via156 = cylinder(axis=Z, base_centre=(7.95mm, 11.1mm, 0mm), radius=via_r, height=z_top-(0mm))
  via157 = cylinder(axis=Z, base_centre=(8.85mm, 11.1mm, 0mm), radius=via_r, height=z_top-(0mm))
  via158 = cylinder(axis=Z, base_centre=(9.75mm, 11.1mm, 0mm), radius=via_r, height=z_top-(0mm))
  via159 = cylinder(axis=Z, base_centre=(10.65mm, 11.1mm, 0mm), radius=via_r, height=z_top-(0mm))
  via160 = cylinder(axis=Z, base_centre=(11.55mm, 11.1mm, 0mm), radius=via_r, height=z_top-(0mm))
  G_branch [copper] = box(corner=(-5.5mm, 9.075mm, z_L1), size=(11mm, 0.25mm, (z_top)-(z_L1)))
  G_trunk = box(corner=(-0.125mm, 7.75mm, z_L1), size=(0.25mm, 1.45mm, (z_top)-(z_L1)))
  DrvOut_l1 = box(corner=(-0.3mm, 7.75mm, z_L1), size=(0.6mm, 0.5mm, (z_top)-(z_L1)))
  DrvOut = box(corner=(-0.3mm, 7.75mm, z_top), size=(0.6mm, 0.5mm, (z_top+t_pad)-(z_top)))
  GateL1_L = box(corner=(-5.5mm, 9.05mm, z_L1), size=(0.4mm, 0.3mm, (z_top)-(z_L1)))
  Gate_L = box(corner=(-5.5mm, 9.05mm, z_top), size=(0.4mm, 0.3mm, (z_top+t_pad)-(z_top)))
  GateL1_R = box(corner=(5.1mm, 9.05mm, z_L1), size=(0.4mm, 0.3mm, (z_top)-(z_L1)))
  Gate_R = box(corner=(5.1mm, 9.05mm, z_top), size=(0.4mm, 0.3mm, (z_top+t_pad)-(z_top)))
  DrvGnd_l1 = box(corner=(-0.3mm, 7.05mm, z_L1), size=(0.6mm, 0.4mm, (z_top)-(z_L1)))
  DrvGnd = box(corner=(-0.3mm, 7.05mm, z_top), size=(0.6mm, 0.4mm, (z_top+t_pad)-(z_top)))
  via161 = cylinder(axis=Z, base_centre=(0mm, 7.25mm, 0mm), radius=via_r, height=z_top-(0mm))
  KS_stub_L = box(corner=(-5.5mm, 9.05mm, 0mm), size=(0.4mm, 1.1mm, (t_L2)-(0mm)))
  slot162 = box(corner=(-5.7mm, 8.85mm, -0.05mm), size=(0.8mm, 1.5mm, (t_L2+0.05mm)-(-0.05mm)))
  KS_stub_R = box(corner=(5.1mm, 9.05mm, 0mm), size=(0.4mm, 1.1mm, (t_L2)-(0mm)))
  slot163 = box(corner=(4.9mm, 8.85mm, -0.05mm), size=(0.8mm, 1.5mm, (t_L2+0.05mm)-(-0.05mm)))
  KS_branch = box(corner=(-5.5mm, 9.05mm, 0mm), size=(11mm, 0.3mm, (t_L2)-(0mm)))
  slot164 = box(corner=(-5.7mm, 8.85mm, -0.05mm), size=(11.4mm, 0.7mm, (t_L2+0.05mm)-(-0.05mm)))
  KS_trunk = box(corner=(-0.45mm, 7mm, 0mm), size=(0.9mm, 2.35mm, (t_L2)-(0mm)))
  slot165 = box(corner=(-0.65mm, 6.8mm, -0.05mm), size=(1.3mm, 2.75mm, (t_L2+0.05mm)-(-0.05mm)))
  via166 = cylinder(axis=Z, base_centre=(-5.3mm, 9.95mm, 0mm), radius=via_r, height=z_top-(0mm))
  via167 = cylinder(axis=Z, base_centre=(5.3mm, 9.95mm, 0mm), radius=via_r, height=z_top-(0mm))
  L2_DCN.subtract(slot162..slot165)
  anti168 = cylinder(axis=Z, base_centre=(-14.4mm, -4.7mm, z_L4b-1mm), radius=r_anti, height=z_top-z_L4b+2mm)
  anti169 = cylinder(axis=Z, base_centre=(-13.2mm, -4.7mm, z_L4b-1mm), radius=r_anti, height=z_top-z_L4b+2mm)
  anti170 = cylinder(axis=Z, base_centre=(-12mm, -4.7mm, z_L4b-1mm), radius=r_anti, height=z_top-z_L4b+2mm)
  anti171 = cylinder(axis=Z, base_centre=(-10.8mm, -4.7mm, z_L4b-1mm), radius=r_anti, height=z_top-z_L4b+2mm)
  anti172 = cylinder(axis=Z, base_centre=(-9.6mm, -4.7mm, z_L4b-1mm), radius=r_anti, height=z_top-z_L4b+2mm)
  anti173 = cylinder(axis=Z, base_centre=(-8.4mm, -4.7mm, z_L4b-1mm), radius=r_anti, height=z_top-z_L4b+2mm)
  anti174 = cylinder(axis=Z, base_centre=(-7.2mm, -4.7mm, z_L4b-1mm), radius=r_anti, height=z_top-z_L4b+2mm)
  anti175 = cylinder(axis=Z, base_centre=(-6mm, -4.7mm, z_L4b-1mm), radius=r_anti, height=z_top-z_L4b+2mm)
  anti176 = cylinder(axis=Z, base_centre=(-4.8mm, -4.7mm, z_L4b-1mm), radius=r_anti, height=z_top-z_L4b+2mm)
  anti177 = cylinder(axis=Z, base_centre=(-3.6mm, -4.7mm, z_L4b-1mm), radius=r_anti, height=z_top-z_L4b+2mm)
  anti178 = cylinder(axis=Z, base_centre=(-2.4mm, -4.7mm, z_L4b-1mm), radius=r_anti, height=z_top-z_L4b+2mm)
  anti179 = cylinder(axis=Z, base_centre=(-1.2mm, -4.7mm, z_L4b-1mm), radius=r_anti, height=z_top-z_L4b+2mm)
  anti180 = cylinder(axis=Z, base_centre=(0mm, -4.7mm, z_L4b-1mm), radius=r_anti, height=z_top-z_L4b+2mm)
  anti181 = cylinder(axis=Z, base_centre=(1.2mm, -4.7mm, z_L4b-1mm), radius=r_anti, height=z_top-z_L4b+2mm)
  anti182 = cylinder(axis=Z, base_centre=(2.4mm, -4.7mm, z_L4b-1mm), radius=r_anti, height=z_top-z_L4b+2mm)
  anti183 = cylinder(axis=Z, base_centre=(3.6mm, -4.7mm, z_L4b-1mm), radius=r_anti, height=z_top-z_L4b+2mm)
  anti184 = cylinder(axis=Z, base_centre=(4.8mm, -4.7mm, z_L4b-1mm), radius=r_anti, height=z_top-z_L4b+2mm)
  anti185 = cylinder(axis=Z, base_centre=(6mm, -4.7mm, z_L4b-1mm), radius=r_anti, height=z_top-z_L4b+2mm)
  anti186 = cylinder(axis=Z, base_centre=(7.2mm, -4.7mm, z_L4b-1mm), radius=r_anti, height=z_top-z_L4b+2mm)
  anti187 = cylinder(axis=Z, base_centre=(8.4mm, -4.7mm, z_L4b-1mm), radius=r_anti, height=z_top-z_L4b+2mm)
  anti188 = cylinder(axis=Z, base_centre=(9.6mm, -4.7mm, z_L4b-1mm), radius=r_anti, height=z_top-z_L4b+2mm)
  anti189 = cylinder(axis=Z, base_centre=(10.8mm, -4.7mm, z_L4b-1mm), radius=r_anti, height=z_top-z_L4b+2mm)
  anti190 = cylinder(axis=Z, base_centre=(12mm, -4.7mm, z_L4b-1mm), radius=r_anti, height=z_top-z_L4b+2mm)
  anti191 = cylinder(axis=Z, base_centre=(13.2mm, -4.7mm, z_L4b-1mm), radius=r_anti, height=z_top-z_L4b+2mm)
  anti192 = cylinder(axis=Z, base_centre=(14.4mm, -4.7mm, z_L4b-1mm), radius=r_anti, height=z_top-z_L4b+2mm)
  anti193 = cylinder(axis=Z, base_centre=(-11.55mm, 2.8mm, z_L4b-1mm), radius=r_anti, height=z_top-z_L4b+2mm)
  anti194 = cylinder(axis=Z, base_centre=(-10.65mm, 2.8mm, z_L4b-1mm), radius=r_anti, height=z_top-z_L4b+2mm)
  anti195 = cylinder(axis=Z, base_centre=(-9.75mm, 2.8mm, z_L4b-1mm), radius=r_anti, height=z_top-z_L4b+2mm)
  anti196 = cylinder(axis=Z, base_centre=(-8.85mm, 2.8mm, z_L4b-1mm), radius=r_anti, height=z_top-z_L4b+2mm)
  anti197 = cylinder(axis=Z, base_centre=(-7.95mm, 2.8mm, z_L4b-1mm), radius=r_anti, height=z_top-z_L4b+2mm)
  anti198 = cylinder(axis=Z, base_centre=(-7.05mm, 2.8mm, z_L4b-1mm), radius=r_anti, height=z_top-z_L4b+2mm)
  anti199 = cylinder(axis=Z, base_centre=(-6.15mm, 2.8mm, z_L4b-1mm), radius=r_anti, height=z_top-z_L4b+2mm)
  anti200 = cylinder(axis=Z, base_centre=(-5.25mm, 2.8mm, z_L4b-1mm), radius=r_anti, height=z_top-z_L4b+2mm)
  anti201 = cylinder(axis=Z, base_centre=(-4.35mm, 2.8mm, z_L4b-1mm), radius=r_anti, height=z_top-z_L4b+2mm)
  anti202 = cylinder(axis=Z, base_centre=(-3.45mm, 2.8mm, z_L4b-1mm), radius=r_anti, height=z_top-z_L4b+2mm)
  anti203 = cylinder(axis=Z, base_centre=(-11.55mm, 7.05mm, z_L4b-1mm), radius=r_anti, height=z_top-z_L4b+2mm)
  anti204 = cylinder(axis=Z, base_centre=(-10.65mm, 7.05mm, z_L4b-1mm), radius=r_anti, height=z_top-z_L4b+2mm)
  anti205 = cylinder(axis=Z, base_centre=(-9.75mm, 7.05mm, z_L4b-1mm), radius=r_anti, height=z_top-z_L4b+2mm)
  anti206 = cylinder(axis=Z, base_centre=(-8.85mm, 7.05mm, z_L4b-1mm), radius=r_anti, height=z_top-z_L4b+2mm)
  anti207 = cylinder(axis=Z, base_centre=(-7.95mm, 7.05mm, z_L4b-1mm), radius=r_anti, height=z_top-z_L4b+2mm)
  anti208 = cylinder(axis=Z, base_centre=(-7.05mm, 7.05mm, z_L4b-1mm), radius=r_anti, height=z_top-z_L4b+2mm)
  anti209 = cylinder(axis=Z, base_centre=(-6.15mm, 7.05mm, z_L4b-1mm), radius=r_anti, height=z_top-z_L4b+2mm)
  anti210 = cylinder(axis=Z, base_centre=(-5.25mm, 7.05mm, z_L4b-1mm), radius=r_anti, height=z_top-z_L4b+2mm)
  anti211 = cylinder(axis=Z, base_centre=(-4.35mm, 7.05mm, z_L4b-1mm), radius=r_anti, height=z_top-z_L4b+2mm)
  anti212 = cylinder(axis=Z, base_centre=(-3.45mm, 7.05mm, z_L4b-1mm), radius=r_anti, height=z_top-z_L4b+2mm)
  anti213 = cylinder(axis=Z, base_centre=(3.45mm, 2.8mm, z_L4b-1mm), radius=r_anti, height=z_top-z_L4b+2mm)
  anti214 = cylinder(axis=Z, base_centre=(4.35mm, 2.8mm, z_L4b-1mm), radius=r_anti, height=z_top-z_L4b+2mm)
  anti215 = cylinder(axis=Z, base_centre=(5.25mm, 2.8mm, z_L4b-1mm), radius=r_anti, height=z_top-z_L4b+2mm)
  anti216 = cylinder(axis=Z, base_centre=(6.15mm, 2.8mm, z_L4b-1mm), radius=r_anti, height=z_top-z_L4b+2mm)
  anti217 = cylinder(axis=Z, base_centre=(7.05mm, 2.8mm, z_L4b-1mm), radius=r_anti, height=z_top-z_L4b+2mm)
  anti218 = cylinder(axis=Z, base_centre=(7.95mm, 2.8mm, z_L4b-1mm), radius=r_anti, height=z_top-z_L4b+2mm)
  anti219 = cylinder(axis=Z, base_centre=(8.85mm, 2.8mm, z_L4b-1mm), radius=r_anti, height=z_top-z_L4b+2mm)
  anti220 = cylinder(axis=Z, base_centre=(9.75mm, 2.8mm, z_L4b-1mm), radius=r_anti, height=z_top-z_L4b+2mm)
  anti221 = cylinder(axis=Z, base_centre=(10.65mm, 2.8mm, z_L4b-1mm), radius=r_anti, height=z_top-z_L4b+2mm)
  anti222 = cylinder(axis=Z, base_centre=(11.55mm, 2.8mm, z_L4b-1mm), radius=r_anti, height=z_top-z_L4b+2mm)
  anti223 = cylinder(axis=Z, base_centre=(3.45mm, 7.05mm, z_L4b-1mm), radius=r_anti, height=z_top-z_L4b+2mm)
  anti224 = cylinder(axis=Z, base_centre=(4.35mm, 7.05mm, z_L4b-1mm), radius=r_anti, height=z_top-z_L4b+2mm)
  anti225 = cylinder(axis=Z, base_centre=(5.25mm, 7.05mm, z_L4b-1mm), radius=r_anti, height=z_top-z_L4b+2mm)
  anti226 = cylinder(axis=Z, base_centre=(6.15mm, 7.05mm, z_L4b-1mm), radius=r_anti, height=z_top-z_L4b+2mm)
  anti227 = cylinder(axis=Z, base_centre=(7.05mm, 7.05mm, z_L4b-1mm), radius=r_anti, height=z_top-z_L4b+2mm)
  anti228 = cylinder(axis=Z, base_centre=(7.95mm, 7.05mm, z_L4b-1mm), radius=r_anti, height=z_top-z_L4b+2mm)
  anti229 = cylinder(axis=Z, base_centre=(8.85mm, 7.05mm, z_L4b-1mm), radius=r_anti, height=z_top-z_L4b+2mm)
  anti230 = cylinder(axis=Z, base_centre=(9.75mm, 7.05mm, z_L4b-1mm), radius=r_anti, height=z_top-z_L4b+2mm)
  anti231 = cylinder(axis=Z, base_centre=(10.65mm, 7.05mm, z_L4b-1mm), radius=r_anti, height=z_top-z_L4b+2mm)
  anti232 = cylinder(axis=Z, base_centre=(11.55mm, 7.05mm, z_L4b-1mm), radius=r_anti, height=z_top-z_L4b+2mm)
  L2_DCN.subtract(anti168..anti232)
  P1.unite(P2, B1P_u1..B1P_u8, B2P_l1..B2P_l8, B3P_u1..B3P_u8, CapPL0..CapPL5, DCP_L, QH_D_L, CapPR0..CapPR5, DCP_R, QH_D_R, L3_DCP, T_DCP, via1..via25, via51..via75, via101..via110, via131..via140)
  AC_L.unite(QH_S_L, QL_D_L, AC_R, QH_S_R, QL_D_R, L4_AC, T_AC, via111..via120, via141..via150)
  G_branch.unite(G_trunk, DrvOut_l1, DrvOut, GateL1_L, Gate_L, GateL1_R, Gate_R)
  N1.unite(N2, B1N_l1..B1N_l8, B2N_u1..B2N_u8, B3N_l1..B3N_l8, CapNL0..CapNL5, SRC_L, QL_S_L, CapNR0..CapNR5, SRC_R, QL_S_R, L2_DCN, T_DCN, via26..via50, via76..via100, via121..via130, via151..via160, DrvGnd_l1, DrvGnd, via161, KS_stub_L, KS_stub_R, KS_branch, KS_trunk, via166, via167)
boundaries and excitations:
  DCP: SignalNet Objects=P1
  AC: SignalNet Objects=AC_L
  G: SignalNet Objects=G_branch
  DCN: SignalNet Objects=N1
  CapB1P: Source Faces=P1.face(at (-4.75, -12, 0.275), at (-7.75, -12, 0.275), at (-10.75, -12, 0.275), at (-13.75, -12, 0.275), at (4.75, -12, 0.275), at (7.75, -12, 0.275), at (10.75, -12, 0.275), at (13.75, -12, 0.275)) TerminalType=ConstantVoltage Net=DCP
  CapB1N: Source Faces=N1.face(at (-4.75, -9.4, 0.275), at (-7.75, -9.4, 0.275), at (-10.75, -9.4, 0.275), at (-13.75, -9.4, 0.275), at (4.75, -9.4, 0.275), at (7.75, -9.4, 0.275), at (10.75, -9.4, 0.275), at (13.75, -9.4, 0.275)) TerminalType=ConstantVoltage Net=DCN
  CapB2P: Source Faces=P1.face(at (-4.75, -5.4, 0.275), at (-7.75, -5.4, 0.275), at (-10.75, -5.4, 0.275), at (-13.75, -5.4, 0.275), at (4.75, -5.4, 0.275), at (7.75, -5.4, 0.275), at (10.75, -5.4, 0.275), at (13.75, -5.4, 0.275)) TerminalType=ConstantVoltage Net=DCP
  CapB2N: Source Faces=N1.face(at (-4.75, -8, 0.275), at (-7.75, -8, 0.275), at (-10.75, -8, 0.275), at (-13.75, -8, 0.275), at (4.75, -8, 0.275), at (7.75, -8, 0.275), at (10.75, -8, 0.275), at (13.75, -8, 0.275)) TerminalType=ConstantVoltage Net=DCN
  CapB3P: Source Faces=P1.face(at (-4.75, -4, 0.275), at (-7.75, -4, 0.275), at (-10.75, -4, 0.275), at (-13.75, -4, 0.275), at (4.75, -4, 0.275), at (7.75, -4, 0.275), at (10.75, -4, 0.275), at (13.75, -4, 0.275)) TerminalType=ConstantVoltage Net=DCP
  CapB3N: Source Faces=N1.face(at (-4.75, -1.4, 0.275), at (-7.75, -1.4, 0.275), at (-10.75, -1.4, 0.275), at (-13.75, -1.4, 0.275), at (4.75, -1.4, 0.275), at (7.75, -1.4, 0.275), at (10.75, -1.4, 0.275), at (13.75, -1.4, 0.275)) TerminalType=ConstantVoltage Net=DCN
  CapPL: Source Faces=P1.face(at (-11, 1.95, 0.275), at (-9.6, 1.95, 0.275), at (-8.2, 1.95, 0.275), at (-6.8, 1.95, 0.275), at (-5.4, 1.95, 0.275), at (-4, 1.95, 0.275)) TerminalType=ConstantVoltage Net=DCP
  CapNL: Source Faces=N1.face(at (-11, 0.45, 0.275), at (-9.6, 0.45, 0.275), at (-8.2, 0.45, 0.275), at (-6.8, 0.45, 0.275), at (-5.4, 0.45, 0.275), at (-4, 0.45, 0.275)) TerminalType=ConstantVoltage Net=DCN
  QH_D_L: Source Faces=P1.face(at (-7.5, 3.9, 0.275)) TerminalType=ConstantVoltage Net=DCP
  QH_S_L: Source Faces=AC_L.face(at (-7.5, 5.9, 0.275)) TerminalType=ConstantVoltage Net=AC
  QL_D_L: Source Faces=AC_L.face(at (-7.5, 8.2, 0.275)) TerminalType=ConstantVoltage Net=AC
  QL_S_L: Source Faces=N1.face(at (-7.5, 10.2, 0.275)) TerminalType=ConstantVoltage Net=DCN
  CapPR: Source Faces=P1.face(at (4, 1.95, 0.275), at (5.4, 1.95, 0.275), at (6.8, 1.95, 0.275), at (8.2, 1.95, 0.275), at (9.6, 1.95, 0.275), at (11, 1.95, 0.275)) TerminalType=ConstantVoltage Net=DCP
  CapNR: Source Faces=N1.face(at (4, 0.45, 0.275), at (5.4, 0.45, 0.275), at (6.8, 0.45, 0.275), at (8.2, 0.45, 0.275), at (9.6, 0.45, 0.275), at (11, 0.45, 0.275)) TerminalType=ConstantVoltage Net=DCN
  QH_D_R: Source Faces=P1.face(at (7.5, 3.9, 0.275)) TerminalType=ConstantVoltage Net=DCP
  QH_S_R: Source Faces=AC_L.face(at (7.5, 5.9, 0.275)) TerminalType=ConstantVoltage Net=AC
  QL_D_R: Source Faces=AC_L.face(at (7.5, 8.2, 0.275)) TerminalType=ConstantVoltage Net=AC
  QL_S_R: Source Faces=N1.face(at (7.5, 10.2, 0.275)) TerminalType=ConstantVoltage Net=DCN
  Gate_L: Source Faces=G_branch.face(at (-5.3, 9.2, 0.275)) TerminalType=ConstantVoltage Net=G
  Gate_R: Source Faces=G_branch.face(at (5.3, 9.2, 0.275)) TerminalType=ConstantVoltage Net=G
  DrvGnd: Source Faces=N1.face(at (0, 7.25, 0.275)) TerminalType=ConstantVoltage Net=DCN
  T_DCP: Sink Faces=P1.face(at (0, -13, 0.275)) TerminalType=ConstantVoltage Net=DCP
  T_DCN: Sink Faces=N1.face(at (0, -8.7, 0.275)) TerminalType=ConstantVoltage Net=DCN
  T_AC: Sink Faces=AC_L.face(at (0, 14.2, -1.475)) TerminalType=ConstantVoltage Net=AC
  DrvOut: Sink Faces=G_branch.face(at (0, 8, 0.275)) TerminalType=ConstantVoltage Net=G
setups:
  Setup1: Matrix AdaptiveFreq=100MHz Cap{MaxPass=4 MinPass=1 MinConvPass=1 PerError=5 PerRefine=30 AutoIncreaseAccuracy AccuracyLevel=High Solver_Type=Iterative} DC{Cond{MaxPass=10 MinPass=1 MinConvPass=1 PerError=1 PerRefine=30} Mult{MaxPass=1 MinPass=1 MinConvPass=1 PerError=1 PerRefine=30} AccuracyLevel=Normal} AC{MaxPass=12 MinPass=2 MinConvPass=2 PerError=1 PerRefine=30 ACRLSolverType=ACA} ErrorValue=0.1
source amplitudes:
  AC:QH_S_L, AC:QH_S_R, AC:QL_D_L, AC:QL_D_R, DCN:CapB1N, DCN:CapB2N, DCN:CapB3N, DCN:CapNL, DCN:CapNR, DCN:DrvGnd, DCN:QL_S_L, DCN:QL_S_R, DCP:CapB2P, DCP:CapB3P, DCP:CapPL, DCP:CapPR, DCP:QH_D_L, DCP:QH_D_R, G:Gate_L, G:Gate_R: AC R/L Fields 0A
  DCP:CapB1P: AC R/L Fields 1A
  AC, DCN, G: CG Fields 0V 0deg
  DCP: CG Fields 1V 0deg
  AC:QH_S_L, AC:QH_S_R, AC:QL_D_L, AC:QL_D_R, DCN:CapB1N, DCN:CapB2N, DCN:CapB3N, DCN:CapNL, DCN:CapNR, DCN:DrvGnd, DCN:QL_S_L, DCN:QL_S_R, DCP:CapB2P, DCP:CapB3P, DCP:CapPL, DCP:CapPR, DCP:QH_D_L, DCP:QH_D_R, G:Gate_L, G:Gate_R: DC R/L Fields 0A
  DCP:CapB1P: DC R/L Fields 1A

design BB_CS_noK (Q3D Extractor, model units mm)
options: SParamCalcMethod=EqTransLine Calculate_Lossy_Dielectrics
variables:
  h_diel = 0.1mm
  h_23 = 1.2mm
  h_34 = 0.1mm
  t_L1 = 0.07mm
  t_L2 = 0.07mm
  t_L3 = 0.07mm
  t_L4 = 0.07mm
  t_pad = 0.035mm
  via_r = 0.15mm
  r_anti = 0.35mm
  z_L1 = t_L2+h_diel
  z_top = z_L1+t_L1
  z_L3t = -h_23
  z_L3b = -h_23-t_L3
  z_L4t = z_L3b-h_34
  z_L4b = z_L4t-t_L4
geometry:
  P1 [copper] = box(corner=(-15mm, -13.4mm, z_L1), size=(30mm, 2.4mm, (z_top)-(z_L1)))
  N1 [copper] = box(corner=(-15mm, -10.4mm, z_L1), size=(30mm, 3.4mm, (z_top)-(z_L1)))
  P2 = box(corner=(-15mm, -6.4mm, z_L1), size=(30mm, 3.4mm, (z_top)-(z_L1)))
  N2 = box(corner=(-15mm, -2.4mm, z_L1), size=(30mm, 3.3mm, (z_top)-(z_L1)))
  B1P_u1 = box(corner=(-5.75mm, -12.4mm, z_top), size=(2mm, 0.8mm, (z_top+t_pad)-(z_top)))
  B1N_l1 = box(corner=(-5.75mm, -9.8mm, z_top), size=(2mm, 0.8mm, (z_top+t_pad)-(z_top)))
  B1P_u2 = box(corner=(-8.75mm, -12.4mm, z_top), size=(2mm, 0.8mm, (z_top+t_pad)-(z_top)))
  B1N_l2 = box(corner=(-8.75mm, -9.8mm, z_top), size=(2mm, 0.8mm, (z_top+t_pad)-(z_top)))
  B1P_u3 = box(corner=(-11.75mm, -12.4mm, z_top), size=(2mm, 0.8mm, (z_top+t_pad)-(z_top)))
  B1N_l3 = box(corner=(-11.75mm, -9.8mm, z_top), size=(2mm, 0.8mm, (z_top+t_pad)-(z_top)))
  B1P_u4 = box(corner=(-14.75mm, -12.4mm, z_top), size=(2mm, 0.8mm, (z_top+t_pad)-(z_top)))
  B1N_l4 = box(corner=(-14.75mm, -9.8mm, z_top), size=(2mm, 0.8mm, (z_top+t_pad)-(z_top)))
  B1P_u5 = box(corner=(3.75mm, -12.4mm, z_top), size=(2mm, 0.8mm, (z_top+t_pad)-(z_top)))
  B1N_l5 = box(corner=(3.75mm, -9.8mm, z_top), size=(2mm, 0.8mm, (z_top+t_pad)-(z_top)))
  B1P_u6 = box(corner=(6.75mm, -12.4mm, z_top), size=(2mm, 0.8mm, (z_top+t_pad)-(z_top)))
  B1N_l6 = box(corner=(6.75mm, -9.8mm, z_top), size=(2mm, 0.8mm, (z_top+t_pad)-(z_top)))
  B1P_u7 = box(corner=(9.75mm, -12.4mm, z_top), size=(2mm, 0.8mm, (z_top+t_pad)-(z_top)))
  B1N_l7 = box(corner=(9.75mm, -9.8mm, z_top), size=(2mm, 0.8mm, (z_top+t_pad)-(z_top)))
  B1P_u8 = box(corner=(12.75mm, -12.4mm, z_top), size=(2mm, 0.8mm, (z_top+t_pad)-(z_top)))
  B1N_l8 = box(corner=(12.75mm, -9.8mm, z_top), size=(2mm, 0.8mm, (z_top+t_pad)-(z_top)))
  B2N_u1 = box(corner=(-5.75mm, -8.4mm, z_top), size=(2mm, 0.8mm, (z_top+t_pad)-(z_top)))
  B2P_l1 = box(corner=(-5.75mm, -5.8mm, z_top), size=(2mm, 0.8mm, (z_top+t_pad)-(z_top)))
  B2N_u2 = box(corner=(-8.75mm, -8.4mm, z_top), size=(2mm, 0.8mm, (z_top+t_pad)-(z_top)))
  B2P_l2 = box(corner=(-8.75mm, -5.8mm, z_top), size=(2mm, 0.8mm, (z_top+t_pad)-(z_top)))
  B2N_u3 = box(corner=(-11.75mm, -8.4mm, z_top), size=(2mm, 0.8mm, (z_top+t_pad)-(z_top)))
  B2P_l3 = box(corner=(-11.75mm, -5.8mm, z_top), size=(2mm, 0.8mm, (z_top+t_pad)-(z_top)))
  B2N_u4 = box(corner=(-14.75mm, -8.4mm, z_top), size=(2mm, 0.8mm, (z_top+t_pad)-(z_top)))
  B2P_l4 = box(corner=(-14.75mm, -5.8mm, z_top), size=(2mm, 0.8mm, (z_top+t_pad)-(z_top)))
  B2N_u5 = box(corner=(3.75mm, -8.4mm, z_top), size=(2mm, 0.8mm, (z_top+t_pad)-(z_top)))
  B2P_l5 = box(corner=(3.75mm, -5.8mm, z_top), size=(2mm, 0.8mm, (z_top+t_pad)-(z_top)))
  B2N_u6 = box(corner=(6.75mm, -8.4mm, z_top), size=(2mm, 0.8mm, (z_top+t_pad)-(z_top)))
  B2P_l6 = box(corner=(6.75mm, -5.8mm, z_top), size=(2mm, 0.8mm, (z_top+t_pad)-(z_top)))
  B2N_u7 = box(corner=(9.75mm, -8.4mm, z_top), size=(2mm, 0.8mm, (z_top+t_pad)-(z_top)))
  B2P_l7 = box(corner=(9.75mm, -5.8mm, z_top), size=(2mm, 0.8mm, (z_top+t_pad)-(z_top)))
  B2N_u8 = box(corner=(12.75mm, -8.4mm, z_top), size=(2mm, 0.8mm, (z_top+t_pad)-(z_top)))
  B2P_l8 = box(corner=(12.75mm, -5.8mm, z_top), size=(2mm, 0.8mm, (z_top+t_pad)-(z_top)))
  B3P_u1 = box(corner=(-5.75mm, -4.4mm, z_top), size=(2mm, 0.8mm, (z_top+t_pad)-(z_top)))
  B3N_l1 = box(corner=(-5.75mm, -1.8mm, z_top), size=(2mm, 0.8mm, (z_top+t_pad)-(z_top)))
  B3P_u2 = box(corner=(-8.75mm, -4.4mm, z_top), size=(2mm, 0.8mm, (z_top+t_pad)-(z_top)))
  B3N_l2 = box(corner=(-8.75mm, -1.8mm, z_top), size=(2mm, 0.8mm, (z_top+t_pad)-(z_top)))
  B3P_u3 = box(corner=(-11.75mm, -4.4mm, z_top), size=(2mm, 0.8mm, (z_top+t_pad)-(z_top)))
  B3N_l3 = box(corner=(-11.75mm, -1.8mm, z_top), size=(2mm, 0.8mm, (z_top+t_pad)-(z_top)))
  B3P_u4 = box(corner=(-14.75mm, -4.4mm, z_top), size=(2mm, 0.8mm, (z_top+t_pad)-(z_top)))
  B3N_l4 = box(corner=(-14.75mm, -1.8mm, z_top), size=(2mm, 0.8mm, (z_top+t_pad)-(z_top)))
  B3P_u5 = box(corner=(3.75mm, -4.4mm, z_top), size=(2mm, 0.8mm, (z_top+t_pad)-(z_top)))
  B3N_l5 = box(corner=(3.75mm, -1.8mm, z_top), size=(2mm, 0.8mm, (z_top+t_pad)-(z_top)))
  B3P_u6 = box(corner=(6.75mm, -4.4mm, z_top), size=(2mm, 0.8mm, (z_top+t_pad)-(z_top)))
  B3N_l6 = box(corner=(6.75mm, -1.8mm, z_top), size=(2mm, 0.8mm, (z_top+t_pad)-(z_top)))
  B3P_u7 = box(corner=(9.75mm, -4.4mm, z_top), size=(2mm, 0.8mm, (z_top+t_pad)-(z_top)))
  B3N_l7 = box(corner=(9.75mm, -1.8mm, z_top), size=(2mm, 0.8mm, (z_top+t_pad)-(z_top)))
  B3P_u8 = box(corner=(12.75mm, -4.4mm, z_top), size=(2mm, 0.8mm, (z_top+t_pad)-(z_top)))
  B3N_l8 = box(corner=(12.75mm, -1.8mm, z_top), size=(2mm, 0.8mm, (z_top+t_pad)-(z_top)))
  CapNL0 = box(corner=(-11.625mm, 0.2mm, z_top), size=(1.25mm, 0.5mm, (z_top+t_pad)-(z_top)))
  CapPL0 = box(corner=(-11.625mm, 1.7mm, z_top), size=(1.25mm, 0.5mm, (z_top+t_pad)-(z_top)))
  CapNL1 = box(corner=(-10.225mm, 0.2mm, z_top), size=(1.25mm, 0.5mm, (z_top+t_pad)-(z_top)))
  CapPL1 = box(corner=(-10.225mm, 1.7mm, z_top), size=(1.25mm, 0.5mm, (z_top+t_pad)-(z_top)))
  CapNL2 = box(corner=(-8.825mm, 0.2mm, z_top), size=(1.25mm, 0.5mm, (z_top+t_pad)-(z_top)))
  CapPL2 = box(corner=(-8.825mm, 1.7mm, z_top), size=(1.25mm, 0.5mm, (z_top+t_pad)-(z_top)))
  CapNL3 = box(corner=(-7.425mm, 0.2mm, z_top), size=(1.25mm, 0.5mm, (z_top+t_pad)-(z_top)))
  CapPL3 = box(corner=(-7.425mm, 1.7mm, z_top), size=(1.25mm, 0.5mm, (z_top+t_pad)-(z_top)))
  CapNL4 = box(corner=(-6.025mm, 0.2mm, z_top), size=(1.25mm, 0.5mm, (z_top+t_pad)-(z_top)))
  CapPL4 = box(corner=(-6.025mm, 1.7mm, z_top), size=(1.25mm, 0.5mm, (z_top+t_pad)-(z_top)))
  CapNL5 = box(corner=(-4.625mm, 0.2mm, z_top), size=(1.25mm, 0.5mm, (z_top+t_pad)-(z_top)))
  CapPL5 = box(corner=(-4.625mm, 1.7mm, z_top), size=(1.25mm, 0.5mm, (z_top+t_pad)-(z_top)))
  DCP_L = box(corner=(-12mm, 1.5mm, z_L1), size=(9mm, 3.1mm, (z_top)-(z_L1)))
  AC_L [copper] = box(corner=(-12mm, 5.2mm, z_L1), size=(9mm, 3.7mm, (z_top)-(z_L1)))
  SRC_L = box(corner=(-12mm, 9.5mm, z_L1), size=(9mm, 2mm, (z_top)-(z_L1)))
  QH_D_L = box(corner=(-10mm, 3.4mm, z_top), size=(5mm, 1mm, (z_top+t_pad)-(z_top)))
  QH_S_L = box(corner=(-10mm, 5.4mm, z_top), size=(5mm, 1mm, (z_top+t_pad)-(z_top)))
  QL_D_L = box(corner=(-10mm, 7.7mm, z_top), size=(5mm, 1mm, (z_top+t_pad)-(z_top)))
  QL_S_L = box(corner=(-10mm, 9.7mm, z_top), size=(5mm, 1mm, (z_top+t_pad)-(z_top)))
  CapNR0 = box(corner=(3.375mm, 0.2mm, z_top), size=(1.25mm, 0.5mm, (z_top+t_pad)-(z_top)))
  CapPR0 = box(corner=(3.375mm, 1.7mm, z_top), size=(1.25mm, 0.5mm, (z_top+t_pad)-(z_top)))
  CapNR1 = box(corner=(4.775mm, 0.2mm, z_top), size=(1.25mm, 0.5mm, (z_top+t_pad)-(z_top)))
  CapPR1 = box(corner=(4.775mm, 1.7mm, z_top), size=(1.25mm, 0.5mm, (z_top+t_pad)-(z_top)))
  CapNR2 = box(corner=(6.175mm, 0.2mm, z_top), size=(1.25mm, 0.5mm, (z_top+t_pad)-(z_top)))
  CapPR2 = box(corner=(6.175mm, 1.7mm, z_top), size=(1.25mm, 0.5mm, (z_top+t_pad)-(z_top)))
  CapNR3 = box(corner=(7.575mm, 0.2mm, z_top), size=(1.25mm, 0.5mm, (z_top+t_pad)-(z_top)))
  CapPR3 = box(corner=(7.575mm, 1.7mm, z_top), size=(1.25mm, 0.5mm, (z_top+t_pad)-(z_top)))
  CapNR4 = box(corner=(8.975mm, 0.2mm, z_top), size=(1.25mm, 0.5mm, (z_top+t_pad)-(z_top)))
  CapPR4 = box(corner=(8.975mm, 1.7mm, z_top), size=(1.25mm, 0.5mm, (z_top+t_pad)-(z_top)))
  CapNR5 = box(corner=(10.375mm, 0.2mm, z_top), size=(1.25mm, 0.5mm, (z_top+t_pad)-(z_top)))
  CapPR5 = box(corner=(10.375mm, 1.7mm, z_top), size=(1.25mm, 0.5mm, (z_top+t_pad)-(z_top)))
  DCP_R = box(corner=(3mm, 1.5mm, z_L1), size=(9mm, 3.1mm, (z_top)-(z_L1)))
  AC_R = box(corner=(3mm, 5.2mm, z_L1), size=(9mm, 3.7mm, (z_top)-(z_L1)))
  SRC_R = box(corner=(3mm, 9.5mm, z_L1), size=(9mm, 2mm, (z_top)-(z_L1)))
  QH_D_R = box(corner=(5mm, 3.4mm, z_top), size=(5mm, 1mm, (z_top+t_pad)-(z_top)))
  QH_S_R = box(corner=(5mm, 5.4mm, z_top), size=(5mm, 1mm, (z_top+t_pad)-(z_top)))
  QL_D_R = box(corner=(5mm, 7.7mm, z_top), size=(5mm, 1mm, (z_top+t_pad)-(z_top)))
  QL_S_R = box(corner=(5mm, 9.7mm, z_top), size=(5mm, 1mm, (z_top+t_pad)-(z_top)))
  L2_DCN = box(corner=(-15mm, -10.4mm, 0mm), size=(30mm, 22.3mm, (t_L2)-(0mm)))
  L3_DCP = box(corner=(-15mm, -13.4mm, z_L3b), size=(30mm, 18mm, (z_L3t)-(z_L3b)))
  L4_AC = box(corner=(-12mm, 4.6mm, z_L4b), size=(24mm, 10.4mm, (z_L4t)-(z_L4b)))
  T_DCP = box(corner=(-3mm, -13.4mm, z_top), size=(6mm, 0.8mm, (z_top+t_pad)-(z_top)))
  T_DCN = box(corner=(-3mm, -9.6mm, z_top), size=(6mm, 1.8mm, (z_top+t_pad)-(z_top)))
  T_AC = box(corner=(-4mm, 13.6mm, z_L4b-t_pad), size=(8mm, 1.2mm, (z_L4b)-(z_L4b-t_pad)))
  via1 = cylinder(axis=Z, base_centre=(-14.4mm, -12.9mm, z_L3b), radius=via_r, height=z_top-(z_L3b))
  via2 = cylinder(axis=Z, base_centre=(-13.2mm, -12.9mm, z_L3b), radius=via_r, height=z_top-(z_L3b))
  via3 = cylinder(axis=Z, base_centre=(-12mm, -12.9mm, z_L3b), radius=via_r, height=z_top-(z_L3b))
  via4 = cylinder(axis=Z, base_centre=(-10.8mm, -12.9mm, z_L3b), radius=via_r, height=z_top-(z_L3b))
  via5 = cylinder(axis=Z, base_centre=(-9.6mm, -12.9mm, z_L3b), radius=via_r, height=z_top-(z_L3b))
  via6 = cylinder(axis=Z, base_centre=(-8.4mm, -12.9mm, z_L3b), radius=via_r, height=z_top-(z_L3b))
  via7 = cylinder(axis=Z, base_centre=(-7.2mm, -12.9mm, z_L3b), radius=via_r, height=z_top-(z_L3b))
  via8 = cylinder(axis=Z, base_centre=(-6mm, -12.9mm, z_L3b), radius=via_r, height=z_top-(z_L3b))
  via9 = cylinder(axis=Z, base_centre=(-4.8mm, -12.9mm, z_L3b), radius=via_r, height=z_top-(z_L3b))
  via10 = cylinder(axis=Z, base_centre=(-3.6mm, -12.9mm, z_L3b), radius=via_r, height=z_top-(z_L3b))
  via11 = cylinder(axis=Z, base_centre=(-2.4mm, -12.9mm, z_L3b), radius=via_r, height=z_top-(z_L3b))
  via12 = cylinder(axis=Z, base_centre=(-1.2mm, -12.9mm, z_L3b), radius=via_r, height=z_top-(z_L3b))
  via13 = cylinder(axis=Z, base_centre=(0mm, -12.9mm, z_L3b), radius=via_r, height=z_top-(z_L3b))
  via14 = cylinder(axis=Z, base_centre=(1.2mm, -12.9mm, z_L3b), radius=via_r, height=z_top-(z_L3b))
  via15 = cylinder(axis=Z, base_centre=(2.4mm, -12.9mm, z_L3b), radius=via_r, height=z_top-(z_L3b))
  via16 = cylinder(axis=Z, base_centre=(3.6mm, -12.9mm, z_L3b), radius=via_r, height=z_top-(z_L3b))
  via17 = cylinder(axis=Z, base_centre=(4.8mm, -12.9mm, z_L3b), radius=via_r, height=z_top-(z_L3b))
  via18 = cylinder(axis=Z, base_centre=(6mm, -12.9mm, z_L3b), radius=via_r, height=z_top-(z_L3b))
  via19 = cylinder(axis=Z, base_centre=(7.2mm, -12.9mm, z_L3b), radius=via_r, height=z_top-(z_L3b))
  via20 = cylinder(axis=Z, base_centre=(8.4mm, -12.9mm, z_L3b), radius=via_r, height=z_top-(z_L3b))
  via21 = cylinder(axis=Z, base_centre=(9.6mm, -12.9mm, z_L3b), radius=via_r, height=z_top-(z_L3b))
  via22 = cylinder(axis=Z, base_centre=(10.8mm, -12.9mm, z_L3b), radius=via_r, height=z_top-(z_L3b))
  via23 = cylinder(axis=Z, base_centre=(12mm, -12.9mm, z_L3b), radius=via_r, height=z_top-(z_L3b))
  via24 = cylinder(axis=Z, base_centre=(13.2mm, -12.9mm, z_L3b), radius=via_r, height=z_top-(z_L3b))
  via25 = cylinder(axis=Z, base_centre=(14.4mm, -12.9mm, z_L3b), radius=via_r, height=z_top-(z_L3b))
  via26 = cylinder(axis=Z, base_centre=(-14.4mm, -8.7mm, 0mm), radius=via_r, height=z_top-(0mm))
  via27 = cylinder(axis=Z, base_centre=(-13.2mm, -8.7mm, 0mm), radius=via_r, height=z_top-(0mm))
  via28 = cylinder(axis=Z, base_centre=(-12mm, -8.7mm, 0mm), radius=via_r, height=z_top-(0mm))
  via29 = cylinder(axis=Z, base_centre=(-10.8mm, -8.7mm, 0mm), radius=via_r, height=z_top-(0mm))
  via30 = cylinder(axis=Z, base_centre=(-9.6mm, -8.7mm, 0mm), radius=via_r, height=z_top-(0mm))
  via31 = cylinder(axis=Z, base_centre=(-8.4mm, -8.7mm, 0mm), radius=via_r, height=z_top-(0mm))
  via32 = cylinder(axis=Z, base_centre=(-7.2mm, -8.7mm, 0mm), radius=via_r, height=z_top-(0mm))
  via33 = cylinder(axis=Z, base_centre=(-6mm, -8.7mm, 0mm), radius=via_r, height=z_top-(0mm))
  via34 = cylinder(axis=Z, base_centre=(-4.8mm, -8.7mm, 0mm), radius=via_r, height=z_top-(0mm))
  via35 = cylinder(axis=Z, base_centre=(-3.6mm, -8.7mm, 0mm), radius=via_r, height=z_top-(0mm))
  via36 = cylinder(axis=Z, base_centre=(-2.4mm, -8.7mm, 0mm), radius=via_r, height=z_top-(0mm))
  via37 = cylinder(axis=Z, base_centre=(-1.2mm, -8.7mm, 0mm), radius=via_r, height=z_top-(0mm))
  via38 = cylinder(axis=Z, base_centre=(0mm, -8.7mm, 0mm), radius=via_r, height=z_top-(0mm))
  via39 = cylinder(axis=Z, base_centre=(1.2mm, -8.7mm, 0mm), radius=via_r, height=z_top-(0mm))
  via40 = cylinder(axis=Z, base_centre=(2.4mm, -8.7mm, 0mm), radius=via_r, height=z_top-(0mm))
  via41 = cylinder(axis=Z, base_centre=(3.6mm, -8.7mm, 0mm), radius=via_r, height=z_top-(0mm))
  via42 = cylinder(axis=Z, base_centre=(4.8mm, -8.7mm, 0mm), radius=via_r, height=z_top-(0mm))
  via43 = cylinder(axis=Z, base_centre=(6mm, -8.7mm, 0mm), radius=via_r, height=z_top-(0mm))
  via44 = cylinder(axis=Z, base_centre=(7.2mm, -8.7mm, 0mm), radius=via_r, height=z_top-(0mm))
  via45 = cylinder(axis=Z, base_centre=(8.4mm, -8.7mm, 0mm), radius=via_r, height=z_top-(0mm))
  via46 = cylinder(axis=Z, base_centre=(9.6mm, -8.7mm, 0mm), radius=via_r, height=z_top-(0mm))
  via47 = cylinder(axis=Z, base_centre=(10.8mm, -8.7mm, 0mm), radius=via_r, height=z_top-(0mm))
  via48 = cylinder(axis=Z, base_centre=(12mm, -8.7mm, 0mm), radius=via_r, height=z_top-(0mm))
  via49 = cylinder(axis=Z, base_centre=(13.2mm, -8.7mm, 0mm), radius=via_r, height=z_top-(0mm))
  via50 = cylinder(axis=Z, base_centre=(14.4mm, -8.7mm, 0mm), radius=via_r, height=z_top-(0mm))
  via51 = cylinder(axis=Z, base_centre=(-14.4mm, -4.7mm, z_L3b), radius=via_r, height=z_top-(z_L3b))
  via52 = cylinder(axis=Z, base_centre=(-13.2mm, -4.7mm, z_L3b), radius=via_r, height=z_top-(z_L3b))
  via53 = cylinder(axis=Z, base_centre=(-12mm, -4.7mm, z_L3b), radius=via_r, height=z_top-(z_L3b))
  via54 = cylinder(axis=Z, base_centre=(-10.8mm, -4.7mm, z_L3b), radius=via_r, height=z_top-(z_L3b))
  via55 = cylinder(axis=Z, base_centre=(-9.6mm, -4.7mm, z_L3b), radius=via_r, height=z_top-(z_L3b))
  via56 = cylinder(axis=Z, base_centre=(-8.4mm, -4.7mm, z_L3b), radius=via_r, height=z_top-(z_L3b))
  via57 = cylinder(axis=Z, base_centre=(-7.2mm, -4.7mm, z_L3b), radius=via_r, height=z_top-(z_L3b))
  via58 = cylinder(axis=Z, base_centre=(-6mm, -4.7mm, z_L3b), radius=via_r, height=z_top-(z_L3b))
  via59 = cylinder(axis=Z, base_centre=(-4.8mm, -4.7mm, z_L3b), radius=via_r, height=z_top-(z_L3b))
  via60 = cylinder(axis=Z, base_centre=(-3.6mm, -4.7mm, z_L3b), radius=via_r, height=z_top-(z_L3b))
  via61 = cylinder(axis=Z, base_centre=(-2.4mm, -4.7mm, z_L3b), radius=via_r, height=z_top-(z_L3b))
  via62 = cylinder(axis=Z, base_centre=(-1.2mm, -4.7mm, z_L3b), radius=via_r, height=z_top-(z_L3b))
  via63 = cylinder(axis=Z, base_centre=(0mm, -4.7mm, z_L3b), radius=via_r, height=z_top-(z_L3b))
  via64 = cylinder(axis=Z, base_centre=(1.2mm, -4.7mm, z_L3b), radius=via_r, height=z_top-(z_L3b))
  via65 = cylinder(axis=Z, base_centre=(2.4mm, -4.7mm, z_L3b), radius=via_r, height=z_top-(z_L3b))
  via66 = cylinder(axis=Z, base_centre=(3.6mm, -4.7mm, z_L3b), radius=via_r, height=z_top-(z_L3b))
  via67 = cylinder(axis=Z, base_centre=(4.8mm, -4.7mm, z_L3b), radius=via_r, height=z_top-(z_L3b))
  via68 = cylinder(axis=Z, base_centre=(6mm, -4.7mm, z_L3b), radius=via_r, height=z_top-(z_L3b))
  via69 = cylinder(axis=Z, base_centre=(7.2mm, -4.7mm, z_L3b), radius=via_r, height=z_top-(z_L3b))
  via70 = cylinder(axis=Z, base_centre=(8.4mm, -4.7mm, z_L3b), radius=via_r, height=z_top-(z_L3b))
  via71 = cylinder(axis=Z, base_centre=(9.6mm, -4.7mm, z_L3b), radius=via_r, height=z_top-(z_L3b))
  via72 = cylinder(axis=Z, base_centre=(10.8mm, -4.7mm, z_L3b), radius=via_r, height=z_top-(z_L3b))
  via73 = cylinder(axis=Z, base_centre=(12mm, -4.7mm, z_L3b), radius=via_r, height=z_top-(z_L3b))
  via74 = cylinder(axis=Z, base_centre=(13.2mm, -4.7mm, z_L3b), radius=via_r, height=z_top-(z_L3b))
  via75 = cylinder(axis=Z, base_centre=(14.4mm, -4.7mm, z_L3b), radius=via_r, height=z_top-(z_L3b))
  via76 = cylinder(axis=Z, base_centre=(-14.4mm, -0.5mm, 0mm), radius=via_r, height=z_top-(0mm))
  via77 = cylinder(axis=Z, base_centre=(-13.2mm, -0.5mm, 0mm), radius=via_r, height=z_top-(0mm))
  via78 = cylinder(axis=Z, base_centre=(-12mm, -0.5mm, 0mm), radius=via_r, height=z_top-(0mm))
  via79 = cylinder(axis=Z, base_centre=(-10.8mm, -0.5mm, 0mm), radius=via_r, height=z_top-(0mm))
  via80 = cylinder(axis=Z, base_centre=(-9.6mm, -0.5mm, 0mm), radius=via_r, height=z_top-(0mm))
  via81 = cylinder(axis=Z, base_centre=(-8.4mm, -0.5mm, 0mm), radius=via_r, height=z_top-(0mm))
  via82 = cylinder(axis=Z, base_centre=(-7.2mm, -0.5mm, 0mm), radius=via_r, height=z_top-(0mm))
  via83 = cylinder(axis=Z, base_centre=(-6mm, -0.5mm, 0mm), radius=via_r, height=z_top-(0mm))
  via84 = cylinder(axis=Z, base_centre=(-4.8mm, -0.5mm, 0mm), radius=via_r, height=z_top-(0mm))
  via85 = cylinder(axis=Z, base_centre=(-3.6mm, -0.5mm, 0mm), radius=via_r, height=z_top-(0mm))
  via86 = cylinder(axis=Z, base_centre=(-2.4mm, -0.5mm, 0mm), radius=via_r, height=z_top-(0mm))
  via87 = cylinder(axis=Z, base_centre=(-1.2mm, -0.5mm, 0mm), radius=via_r, height=z_top-(0mm))
  via88 = cylinder(axis=Z, base_centre=(0mm, -0.5mm, 0mm), radius=via_r, height=z_top-(0mm))
  via89 = cylinder(axis=Z, base_centre=(1.2mm, -0.5mm, 0mm), radius=via_r, height=z_top-(0mm))
  via90 = cylinder(axis=Z, base_centre=(2.4mm, -0.5mm, 0mm), radius=via_r, height=z_top-(0mm))
  via91 = cylinder(axis=Z, base_centre=(3.6mm, -0.5mm, 0mm), radius=via_r, height=z_top-(0mm))
  via92 = cylinder(axis=Z, base_centre=(4.8mm, -0.5mm, 0mm), radius=via_r, height=z_top-(0mm))
  via93 = cylinder(axis=Z, base_centre=(6mm, -0.5mm, 0mm), radius=via_r, height=z_top-(0mm))
  via94 = cylinder(axis=Z, base_centre=(7.2mm, -0.5mm, 0mm), radius=via_r, height=z_top-(0mm))
  via95 = cylinder(axis=Z, base_centre=(8.4mm, -0.5mm, 0mm), radius=via_r, height=z_top-(0mm))
  via96 = cylinder(axis=Z, base_centre=(9.6mm, -0.5mm, 0mm), radius=via_r, height=z_top-(0mm))
  via97 = cylinder(axis=Z, base_centre=(10.8mm, -0.5mm, 0mm), radius=via_r, height=z_top-(0mm))
  via98 = cylinder(axis=Z, base_centre=(12mm, -0.5mm, 0mm), radius=via_r, height=z_top-(0mm))
  via99 = cylinder(axis=Z, base_centre=(13.2mm, -0.5mm, 0mm), radius=via_r, height=z_top-(0mm))
  via100 = cylinder(axis=Z, base_centre=(14.4mm, -0.5mm, 0mm), radius=via_r, height=z_top-(0mm))
  via101 = cylinder(axis=Z, base_centre=(-11.55mm, 2.8mm, z_L3b), radius=via_r, height=z_top-(z_L3b))
  via102 = cylinder(axis=Z, base_centre=(-10.65mm, 2.8mm, z_L3b), radius=via_r, height=z_top-(z_L3b))
  via103 = cylinder(axis=Z, base_centre=(-9.75mm, 2.8mm, z_L3b), radius=via_r, height=z_top-(z_L3b))
  via104 = cylinder(axis=Z, base_centre=(-8.85mm, 2.8mm, z_L3b), radius=via_r, height=z_top-(z_L3b))
  via105 = cylinder(axis=Z, base_centre=(-7.95mm, 2.8mm, z_L3b), radius=via_r, height=z_top-(z_L3b))
  via106 = cylinder(axis=Z, base_centre=(-7.05mm, 2.8mm, z_L3b), radius=via_r, height=z_top-(z_L3b))
  via107 = cylinder(axis=Z, base_centre=(-6.15mm, 2.8mm, z_L3b), radius=via_r, height=z_top-(z_L3b))
  via108 = cylinder(axis=Z, base_centre=(-5.25mm, 2.8mm, z_L3b), radius=via_r, height=z_top-(z_L3b))
  via109 = cylinder(axis=Z, base_centre=(-4.35mm, 2.8mm, z_L3b), radius=via_r, height=z_top-(z_L3b))
  via110 = cylinder(axis=Z, base_centre=(-3.45mm, 2.8mm, z_L3b), radius=via_r, height=z_top-(z_L3b))
  via111 = cylinder(axis=Z, base_centre=(-11.55mm, 7.05mm, z_L4b), radius=via_r, height=z_top-(z_L4b))
  via112 = cylinder(axis=Z, base_centre=(-10.65mm, 7.05mm, z_L4b), radius=via_r, height=z_top-(z_L4b))
  via113 = cylinder(axis=Z, base_centre=(-9.75mm, 7.05mm, z_L4b), radius=via_r, height=z_top-(z_L4b))
  via114 = cylinder(axis=Z, base_centre=(-8.85mm, 7.05mm, z_L4b), radius=via_r, height=z_top-(z_L4b))
  via115 = cylinder(axis=Z, base_centre=(-7.95mm, 7.05mm, z_L4b), radius=via_r, height=z_top-(z_L4b))
  via116 = cylinder(axis=Z, base_centre=(-7.05mm, 7.05mm, z_L4b), radius=via_r, height=z_top-(z_L4b))
  via117 = cylinder(axis=Z, base_centre=(-6.15mm, 7.05mm, z_L4b), radius=via_r, height=z_top-(z_L4b))
  via118 = cylinder(axis=Z, base_centre=(-5.25mm, 7.05mm, z_L4b), radius=via_r, height=z_top-(z_L4b))
  via119 = cylinder(axis=Z, base_centre=(-4.35mm, 7.05mm, z_L4b), radius=via_r, height=z_top-(z_L4b))
  via120 = cylinder(axis=Z, base_centre=(-3.45mm, 7.05mm, z_L4b), radius=via_r, height=z_top-(z_L4b))
  via121 = cylinder(axis=Z, base_centre=(-11.55mm, 11.1mm, 0mm), radius=via_r, height=z_top-(0mm))
  via122 = cylinder(axis=Z, base_centre=(-10.65mm, 11.1mm, 0mm), radius=via_r, height=z_top-(0mm))
  via123 = cylinder(axis=Z, base_centre=(-9.75mm, 11.1mm, 0mm), radius=via_r, height=z_top-(0mm))
  via124 = cylinder(axis=Z, base_centre=(-8.85mm, 11.1mm, 0mm), radius=via_r, height=z_top-(0mm))
  via125 = cylinder(axis=Z, base_centre=(-7.95mm, 11.1mm, 0mm), radius=via_r, height=z_top-(0mm))
  via126 = cylinder(axis=Z, base_centre=(-7.05mm, 11.1mm, 0mm), radius=via_r, height=z_top-(0mm))
  via127 = cylinder(axis=Z, base_centre=(-6.15mm, 11.1mm, 0mm), radius=via_r, height=z_top-(0mm))
  via128 = cylinder(axis=Z, base_centre=(-5.25mm, 11.1mm, 0mm), radius=via_r, height=z_top-(0mm))
  via129 = cylinder(axis=Z, base_centre=(-4.35mm, 11.1mm, 0mm), radius=via_r, height=z_top-(0mm))
  via130 = cylinder(axis=Z, base_centre=(-3.45mm, 11.1mm, 0mm), radius=via_r, height=z_top-(0mm))
  via131 = cylinder(axis=Z, base_centre=(3.45mm, 2.8mm, z_L3b), radius=via_r, height=z_top-(z_L3b))
  via132 = cylinder(axis=Z, base_centre=(4.35mm, 2.8mm, z_L3b), radius=via_r, height=z_top-(z_L3b))
  via133 = cylinder(axis=Z, base_centre=(5.25mm, 2.8mm, z_L3b), radius=via_r, height=z_top-(z_L3b))
  via134 = cylinder(axis=Z, base_centre=(6.15mm, 2.8mm, z_L3b), radius=via_r, height=z_top-(z_L3b))
  via135 = cylinder(axis=Z, base_centre=(7.05mm, 2.8mm, z_L3b), radius=via_r, height=z_top-(z_L3b))
  via136 = cylinder(axis=Z, base_centre=(7.95mm, 2.8mm, z_L3b), radius=via_r, height=z_top-(z_L3b))
  via137 = cylinder(axis=Z, base_centre=(8.85mm, 2.8mm, z_L3b), radius=via_r, height=z_top-(z_L3b))
  via138 = cylinder(axis=Z, base_centre=(9.75mm, 2.8mm, z_L3b), radius=via_r, height=z_top-(z_L3b))
  via139 = cylinder(axis=Z, base_centre=(10.65mm, 2.8mm, z_L3b), radius=via_r, height=z_top-(z_L3b))
  via140 = cylinder(axis=Z, base_centre=(11.55mm, 2.8mm, z_L3b), radius=via_r, height=z_top-(z_L3b))
  via141 = cylinder(axis=Z, base_centre=(3.45mm, 7.05mm, z_L4b), radius=via_r, height=z_top-(z_L4b))
  via142 = cylinder(axis=Z, base_centre=(4.35mm, 7.05mm, z_L4b), radius=via_r, height=z_top-(z_L4b))
  via143 = cylinder(axis=Z, base_centre=(5.25mm, 7.05mm, z_L4b), radius=via_r, height=z_top-(z_L4b))
  via144 = cylinder(axis=Z, base_centre=(6.15mm, 7.05mm, z_L4b), radius=via_r, height=z_top-(z_L4b))
  via145 = cylinder(axis=Z, base_centre=(7.05mm, 7.05mm, z_L4b), radius=via_r, height=z_top-(z_L4b))
  via146 = cylinder(axis=Z, base_centre=(7.95mm, 7.05mm, z_L4b), radius=via_r, height=z_top-(z_L4b))
  via147 = cylinder(axis=Z, base_centre=(8.85mm, 7.05mm, z_L4b), radius=via_r, height=z_top-(z_L4b))
  via148 = cylinder(axis=Z, base_centre=(9.75mm, 7.05mm, z_L4b), radius=via_r, height=z_top-(z_L4b))
  via149 = cylinder(axis=Z, base_centre=(10.65mm, 7.05mm, z_L4b), radius=via_r, height=z_top-(z_L4b))
  via150 = cylinder(axis=Z, base_centre=(11.55mm, 7.05mm, z_L4b), radius=via_r, height=z_top-(z_L4b))
  via151 = cylinder(axis=Z, base_centre=(3.45mm, 11.1mm, 0mm), radius=via_r, height=z_top-(0mm))
  via152 = cylinder(axis=Z, base_centre=(4.35mm, 11.1mm, 0mm), radius=via_r, height=z_top-(0mm))
  via153 = cylinder(axis=Z, base_centre=(5.25mm, 11.1mm, 0mm), radius=via_r, height=z_top-(0mm))
  via154 = cylinder(axis=Z, base_centre=(6.15mm, 11.1mm, 0mm), radius=via_r, height=z_top-(0mm))
  via155 = cylinder(axis=Z, base_centre=(7.05mm, 11.1mm, 0mm), radius=via_r, height=z_top-(0mm))
  via156 = cylinder(axis=Z, base_centre=(7.95mm, 11.1mm, 0mm), radius=via_r, height=z_top-(0mm))
  via157 = cylinder(axis=Z, base_centre=(8.85mm, 11.1mm, 0mm), radius=via_r, height=z_top-(0mm))
  via158 = cylinder(axis=Z, base_centre=(9.75mm, 11.1mm, 0mm), radius=via_r, height=z_top-(0mm))
  via159 = cylinder(axis=Z, base_centre=(10.65mm, 11.1mm, 0mm), radius=via_r, height=z_top-(0mm))
  via160 = cylinder(axis=Z, base_centre=(11.55mm, 11.1mm, 0mm), radius=via_r, height=z_top-(0mm))
  G_branch [copper] = box(corner=(-5.5mm, 9.075mm, z_L1), size=(11mm, 0.25mm, (z_top)-(z_L1)))
  G_trunk = box(corner=(-0.125mm, 7.75mm, z_L1), size=(0.25mm, 1.45mm, (z_top)-(z_L1)))
  DrvOut_l1 = box(corner=(-0.3mm, 7.75mm, z_L1), size=(0.6mm, 0.5mm, (z_top)-(z_L1)))
  DrvOut = box(corner=(-0.3mm, 7.75mm, z_top), size=(0.6mm, 0.5mm, (z_top+t_pad)-(z_top)))
  GateL1_L = box(corner=(-5.5mm, 9.05mm, z_L1), size=(0.4mm, 0.3mm, (z_top)-(z_L1)))
  Gate_L = box(corner=(-5.5mm, 9.05mm, z_top), size=(0.4mm, 0.3mm, (z_top+t_pad)-(z_top)))
  GateL1_R = box(corner=(5.1mm, 9.05mm, z_L1), size=(0.4mm, 0.3mm, (z_top)-(z_L1)))
  Gate_R = box(corner=(5.1mm, 9.05mm, z_top), size=(0.4mm, 0.3mm, (z_top+t_pad)-(z_top)))
  DrvGnd_l1 = box(corner=(-0.3mm, 7.05mm, z_L1), size=(0.6mm, 0.4mm, (z_top)-(z_L1)))
  DrvGnd = box(corner=(-0.3mm, 7.05mm, z_top), size=(0.6mm, 0.4mm, (z_top+t_pad)-(z_top)))
  via161 = cylinder(axis=Z, base_centre=(0mm, 7.25mm, 0mm), radius=via_r, height=z_top-(0mm))
  anti162 = cylinder(axis=Z, base_centre=(-14.4mm, -4.7mm, z_L4b-1mm), radius=r_anti, height=z_top-z_L4b+2mm)
  anti163 = cylinder(axis=Z, base_centre=(-13.2mm, -4.7mm, z_L4b-1mm), radius=r_anti, height=z_top-z_L4b+2mm)
  anti164 = cylinder(axis=Z, base_centre=(-12mm, -4.7mm, z_L4b-1mm), radius=r_anti, height=z_top-z_L4b+2mm)
  anti165 = cylinder(axis=Z, base_centre=(-10.8mm, -4.7mm, z_L4b-1mm), radius=r_anti, height=z_top-z_L4b+2mm)
  anti166 = cylinder(axis=Z, base_centre=(-9.6mm, -4.7mm, z_L4b-1mm), radius=r_anti, height=z_top-z_L4b+2mm)
  anti167 = cylinder(axis=Z, base_centre=(-8.4mm, -4.7mm, z_L4b-1mm), radius=r_anti, height=z_top-z_L4b+2mm)
  anti168 = cylinder(axis=Z, base_centre=(-7.2mm, -4.7mm, z_L4b-1mm), radius=r_anti, height=z_top-z_L4b+2mm)
  anti169 = cylinder(axis=Z, base_centre=(-6mm, -4.7mm, z_L4b-1mm), radius=r_anti, height=z_top-z_L4b+2mm)
  anti170 = cylinder(axis=Z, base_centre=(-4.8mm, -4.7mm, z_L4b-1mm), radius=r_anti, height=z_top-z_L4b+2mm)
  anti171 = cylinder(axis=Z, base_centre=(-3.6mm, -4.7mm, z_L4b-1mm), radius=r_anti, height=z_top-z_L4b+2mm)
  anti172 = cylinder(axis=Z, base_centre=(-2.4mm, -4.7mm, z_L4b-1mm), radius=r_anti, height=z_top-z_L4b+2mm)
  anti173 = cylinder(axis=Z, base_centre=(-1.2mm, -4.7mm, z_L4b-1mm), radius=r_anti, height=z_top-z_L4b+2mm)
  anti174 = cylinder(axis=Z, base_centre=(0mm, -4.7mm, z_L4b-1mm), radius=r_anti, height=z_top-z_L4b+2mm)
  anti175 = cylinder(axis=Z, base_centre=(1.2mm, -4.7mm, z_L4b-1mm), radius=r_anti, height=z_top-z_L4b+2mm)
  anti176 = cylinder(axis=Z, base_centre=(2.4mm, -4.7mm, z_L4b-1mm), radius=r_anti, height=z_top-z_L4b+2mm)
  anti177 = cylinder(axis=Z, base_centre=(3.6mm, -4.7mm, z_L4b-1mm), radius=r_anti, height=z_top-z_L4b+2mm)
  anti178 = cylinder(axis=Z, base_centre=(4.8mm, -4.7mm, z_L4b-1mm), radius=r_anti, height=z_top-z_L4b+2mm)
  anti179 = cylinder(axis=Z, base_centre=(6mm, -4.7mm, z_L4b-1mm), radius=r_anti, height=z_top-z_L4b+2mm)
  anti180 = cylinder(axis=Z, base_centre=(7.2mm, -4.7mm, z_L4b-1mm), radius=r_anti, height=z_top-z_L4b+2mm)
  anti181 = cylinder(axis=Z, base_centre=(8.4mm, -4.7mm, z_L4b-1mm), radius=r_anti, height=z_top-z_L4b+2mm)
  anti182 = cylinder(axis=Z, base_centre=(9.6mm, -4.7mm, z_L4b-1mm), radius=r_anti, height=z_top-z_L4b+2mm)
  anti183 = cylinder(axis=Z, base_centre=(10.8mm, -4.7mm, z_L4b-1mm), radius=r_anti, height=z_top-z_L4b+2mm)
  anti184 = cylinder(axis=Z, base_centre=(12mm, -4.7mm, z_L4b-1mm), radius=r_anti, height=z_top-z_L4b+2mm)
  anti185 = cylinder(axis=Z, base_centre=(13.2mm, -4.7mm, z_L4b-1mm), radius=r_anti, height=z_top-z_L4b+2mm)
  anti186 = cylinder(axis=Z, base_centre=(14.4mm, -4.7mm, z_L4b-1mm), radius=r_anti, height=z_top-z_L4b+2mm)
  anti187 = cylinder(axis=Z, base_centre=(-11.55mm, 2.8mm, z_L4b-1mm), radius=r_anti, height=z_top-z_L4b+2mm)
  anti188 = cylinder(axis=Z, base_centre=(-10.65mm, 2.8mm, z_L4b-1mm), radius=r_anti, height=z_top-z_L4b+2mm)
  anti189 = cylinder(axis=Z, base_centre=(-9.75mm, 2.8mm, z_L4b-1mm), radius=r_anti, height=z_top-z_L4b+2mm)
  anti190 = cylinder(axis=Z, base_centre=(-8.85mm, 2.8mm, z_L4b-1mm), radius=r_anti, height=z_top-z_L4b+2mm)
  anti191 = cylinder(axis=Z, base_centre=(-7.95mm, 2.8mm, z_L4b-1mm), radius=r_anti, height=z_top-z_L4b+2mm)
  anti192 = cylinder(axis=Z, base_centre=(-7.05mm, 2.8mm, z_L4b-1mm), radius=r_anti, height=z_top-z_L4b+2mm)
  anti193 = cylinder(axis=Z, base_centre=(-6.15mm, 2.8mm, z_L4b-1mm), radius=r_anti, height=z_top-z_L4b+2mm)
  anti194 = cylinder(axis=Z, base_centre=(-5.25mm, 2.8mm, z_L4b-1mm), radius=r_anti, height=z_top-z_L4b+2mm)
  anti195 = cylinder(axis=Z, base_centre=(-4.35mm, 2.8mm, z_L4b-1mm), radius=r_anti, height=z_top-z_L4b+2mm)
  anti196 = cylinder(axis=Z, base_centre=(-3.45mm, 2.8mm, z_L4b-1mm), radius=r_anti, height=z_top-z_L4b+2mm)
  anti197 = cylinder(axis=Z, base_centre=(-11.55mm, 7.05mm, z_L4b-1mm), radius=r_anti, height=z_top-z_L4b+2mm)
  anti198 = cylinder(axis=Z, base_centre=(-10.65mm, 7.05mm, z_L4b-1mm), radius=r_anti, height=z_top-z_L4b+2mm)
  anti199 = cylinder(axis=Z, base_centre=(-9.75mm, 7.05mm, z_L4b-1mm), radius=r_anti, height=z_top-z_L4b+2mm)
  anti200 = cylinder(axis=Z, base_centre=(-8.85mm, 7.05mm, z_L4b-1mm), radius=r_anti, height=z_top-z_L4b+2mm)
  anti201 = cylinder(axis=Z, base_centre=(-7.95mm, 7.05mm, z_L4b-1mm), radius=r_anti, height=z_top-z_L4b+2mm)
  anti202 = cylinder(axis=Z, base_centre=(-7.05mm, 7.05mm, z_L4b-1mm), radius=r_anti, height=z_top-z_L4b+2mm)
  anti203 = cylinder(axis=Z, base_centre=(-6.15mm, 7.05mm, z_L4b-1mm), radius=r_anti, height=z_top-z_L4b+2mm)
  anti204 = cylinder(axis=Z, base_centre=(-5.25mm, 7.05mm, z_L4b-1mm), radius=r_anti, height=z_top-z_L4b+2mm)
  anti205 = cylinder(axis=Z, base_centre=(-4.35mm, 7.05mm, z_L4b-1mm), radius=r_anti, height=z_top-z_L4b+2mm)
  anti206 = cylinder(axis=Z, base_centre=(-3.45mm, 7.05mm, z_L4b-1mm), radius=r_anti, height=z_top-z_L4b+2mm)
  anti207 = cylinder(axis=Z, base_centre=(3.45mm, 2.8mm, z_L4b-1mm), radius=r_anti, height=z_top-z_L4b+2mm)
  anti208 = cylinder(axis=Z, base_centre=(4.35mm, 2.8mm, z_L4b-1mm), radius=r_anti, height=z_top-z_L4b+2mm)
  anti209 = cylinder(axis=Z, base_centre=(5.25mm, 2.8mm, z_L4b-1mm), radius=r_anti, height=z_top-z_L4b+2mm)
  anti210 = cylinder(axis=Z, base_centre=(6.15mm, 2.8mm, z_L4b-1mm), radius=r_anti, height=z_top-z_L4b+2mm)
  anti211 = cylinder(axis=Z, base_centre=(7.05mm, 2.8mm, z_L4b-1mm), radius=r_anti, height=z_top-z_L4b+2mm)
  anti212 = cylinder(axis=Z, base_centre=(7.95mm, 2.8mm, z_L4b-1mm), radius=r_anti, height=z_top-z_L4b+2mm)
  anti213 = cylinder(axis=Z, base_centre=(8.85mm, 2.8mm, z_L4b-1mm), radius=r_anti, height=z_top-z_L4b+2mm)
  anti214 = cylinder(axis=Z, base_centre=(9.75mm, 2.8mm, z_L4b-1mm), radius=r_anti, height=z_top-z_L4b+2mm)
  anti215 = cylinder(axis=Z, base_centre=(10.65mm, 2.8mm, z_L4b-1mm), radius=r_anti, height=z_top-z_L4b+2mm)
  anti216 = cylinder(axis=Z, base_centre=(11.55mm, 2.8mm, z_L4b-1mm), radius=r_anti, height=z_top-z_L4b+2mm)
  anti217 = cylinder(axis=Z, base_centre=(3.45mm, 7.05mm, z_L4b-1mm), radius=r_anti, height=z_top-z_L4b+2mm)
  anti218 = cylinder(axis=Z, base_centre=(4.35mm, 7.05mm, z_L4b-1mm), radius=r_anti, height=z_top-z_L4b+2mm)
  anti219 = cylinder(axis=Z, base_centre=(5.25mm, 7.05mm, z_L4b-1mm), radius=r_anti, height=z_top-z_L4b+2mm)
  anti220 = cylinder(axis=Z, base_centre=(6.15mm, 7.05mm, z_L4b-1mm), radius=r_anti, height=z_top-z_L4b+2mm)
  anti221 = cylinder(axis=Z, base_centre=(7.05mm, 7.05mm, z_L4b-1mm), radius=r_anti, height=z_top-z_L4b+2mm)
  anti222 = cylinder(axis=Z, base_centre=(7.95mm, 7.05mm, z_L4b-1mm), radius=r_anti, height=z_top-z_L4b+2mm)
  anti223 = cylinder(axis=Z, base_centre=(8.85mm, 7.05mm, z_L4b-1mm), radius=r_anti, height=z_top-z_L4b+2mm)
  anti224 = cylinder(axis=Z, base_centre=(9.75mm, 7.05mm, z_L4b-1mm), radius=r_anti, height=z_top-z_L4b+2mm)
  anti225 = cylinder(axis=Z, base_centre=(10.65mm, 7.05mm, z_L4b-1mm), radius=r_anti, height=z_top-z_L4b+2mm)
  anti226 = cylinder(axis=Z, base_centre=(11.55mm, 7.05mm, z_L4b-1mm), radius=r_anti, height=z_top-z_L4b+2mm)
  L2_DCN.subtract(anti162..anti226)
  P1.unite(P2, B1P_u1..B1P_u8, B2P_l1..B2P_l8, B3P_u1..B3P_u8, CapPL0..CapPL5, DCP_L, QH_D_L, CapPR0..CapPR5, DCP_R, QH_D_R, L3_DCP, T_DCP, via1..via25, via51..via75, via101..via110, via131..via140)
  AC_L.unite(QH_S_L, QL_D_L, AC_R, QH_S_R, QL_D_R, L4_AC, T_AC, via111..via120, via141..via150)
  G_branch.unite(G_trunk, DrvOut_l1, DrvOut, GateL1_L, Gate_L, GateL1_R, Gate_R)
  N1.unite(N2, B1N_l1..B1N_l8, B2N_u1..B2N_u8, B3N_l1..B3N_l8, CapNL0..CapNL5, SRC_L, QL_S_L, CapNR0..CapNR5, SRC_R, QL_S_R, L2_DCN, T_DCN, via26..via50, via76..via100, via121..via130, via151..via160, DrvGnd_l1, DrvGnd, via161)
boundaries and excitations:
  DCP: SignalNet Objects=P1
  AC: SignalNet Objects=AC_L
  G: SignalNet Objects=G_branch
  DCN: SignalNet Objects=N1
  CapB1P: Source Faces=P1.face(at (-4.75, -12, 0.275), at (-7.75, -12, 0.275), at (-10.75, -12, 0.275), at (-13.75, -12, 0.275), at (4.75, -12, 0.275), at (7.75, -12, 0.275), at (10.75, -12, 0.275), at (13.75, -12, 0.275)) TerminalType=ConstantVoltage Net=DCP
  CapB1N: Source Faces=N1.face(at (-4.75, -9.4, 0.275), at (-7.75, -9.4, 0.275), at (-10.75, -9.4, 0.275), at (-13.75, -9.4, 0.275), at (4.75, -9.4, 0.275), at (7.75, -9.4, 0.275), at (10.75, -9.4, 0.275), at (13.75, -9.4, 0.275)) TerminalType=ConstantVoltage Net=DCN
  CapB2P: Source Faces=P1.face(at (-4.75, -5.4, 0.275), at (-7.75, -5.4, 0.275), at (-10.75, -5.4, 0.275), at (-13.75, -5.4, 0.275), at (4.75, -5.4, 0.275), at (7.75, -5.4, 0.275), at (10.75, -5.4, 0.275), at (13.75, -5.4, 0.275)) TerminalType=ConstantVoltage Net=DCP
  CapB2N: Source Faces=N1.face(at (-4.75, -8, 0.275), at (-7.75, -8, 0.275), at (-10.75, -8, 0.275), at (-13.75, -8, 0.275), at (4.75, -8, 0.275), at (7.75, -8, 0.275), at (10.75, -8, 0.275), at (13.75, -8, 0.275)) TerminalType=ConstantVoltage Net=DCN
  CapB3P: Source Faces=P1.face(at (-4.75, -4, 0.275), at (-7.75, -4, 0.275), at (-10.75, -4, 0.275), at (-13.75, -4, 0.275), at (4.75, -4, 0.275), at (7.75, -4, 0.275), at (10.75, -4, 0.275), at (13.75, -4, 0.275)) TerminalType=ConstantVoltage Net=DCP
  CapB3N: Source Faces=N1.face(at (-4.75, -1.4, 0.275), at (-7.75, -1.4, 0.275), at (-10.75, -1.4, 0.275), at (-13.75, -1.4, 0.275), at (4.75, -1.4, 0.275), at (7.75, -1.4, 0.275), at (10.75, -1.4, 0.275), at (13.75, -1.4, 0.275)) TerminalType=ConstantVoltage Net=DCN
  CapPL: Source Faces=P1.face(at (-11, 1.95, 0.275), at (-9.6, 1.95, 0.275), at (-8.2, 1.95, 0.275), at (-6.8, 1.95, 0.275), at (-5.4, 1.95, 0.275), at (-4, 1.95, 0.275)) TerminalType=ConstantVoltage Net=DCP
  CapNL: Source Faces=N1.face(at (-11, 0.45, 0.275), at (-9.6, 0.45, 0.275), at (-8.2, 0.45, 0.275), at (-6.8, 0.45, 0.275), at (-5.4, 0.45, 0.275), at (-4, 0.45, 0.275)) TerminalType=ConstantVoltage Net=DCN
  QH_D_L: Source Faces=P1.face(at (-7.5, 3.9, 0.275)) TerminalType=ConstantVoltage Net=DCP
  QH_S_L: Source Faces=AC_L.face(at (-7.5, 5.9, 0.275)) TerminalType=ConstantVoltage Net=AC
  QL_D_L: Source Faces=AC_L.face(at (-7.5, 8.2, 0.275)) TerminalType=ConstantVoltage Net=AC
  QL_S_L: Source Faces=N1.face(at (-7.5, 10.2, 0.275)) TerminalType=ConstantVoltage Net=DCN
  CapPR: Source Faces=P1.face(at (4, 1.95, 0.275), at (5.4, 1.95, 0.275), at (6.8, 1.95, 0.275), at (8.2, 1.95, 0.275), at (9.6, 1.95, 0.275), at (11, 1.95, 0.275)) TerminalType=ConstantVoltage Net=DCP
  CapNR: Source Faces=N1.face(at (4, 0.45, 0.275), at (5.4, 0.45, 0.275), at (6.8, 0.45, 0.275), at (8.2, 0.45, 0.275), at (9.6, 0.45, 0.275), at (11, 0.45, 0.275)) TerminalType=ConstantVoltage Net=DCN
  QH_D_R: Source Faces=P1.face(at (7.5, 3.9, 0.275)) TerminalType=ConstantVoltage Net=DCP
  QH_S_R: Source Faces=AC_L.face(at (7.5, 5.9, 0.275)) TerminalType=ConstantVoltage Net=AC
  QL_D_R: Source Faces=AC_L.face(at (7.5, 8.2, 0.275)) TerminalType=ConstantVoltage Net=AC
  QL_S_R: Source Faces=N1.face(at (7.5, 10.2, 0.275)) TerminalType=ConstantVoltage Net=DCN
  Gate_L: Source Faces=G_branch.face(at (-5.3, 9.2, 0.275)) TerminalType=ConstantVoltage Net=G
  Gate_R: Source Faces=G_branch.face(at (5.3, 9.2, 0.275)) TerminalType=ConstantVoltage Net=G
  DrvGnd: Source Faces=N1.face(at (0, 7.25, 0.275)) TerminalType=ConstantVoltage Net=DCN
  T_DCP: Sink Faces=P1.face(at (0, -13, 0.275)) TerminalType=ConstantVoltage Net=DCP
  T_DCN: Sink Faces=N1.face(at (0, -8.7, 0.275)) TerminalType=ConstantVoltage Net=DCN
  T_AC: Sink Faces=AC_L.face(at (0, 14.2, -1.475)) TerminalType=ConstantVoltage Net=AC
  DrvOut: Sink Faces=G_branch.face(at (0, 8, 0.275)) TerminalType=ConstantVoltage Net=G
setups:
  Setup1: Matrix AdaptiveFreq=100MHz Cap{MaxPass=4 MinPass=1 MinConvPass=1 PerError=5 PerRefine=30 AutoIncreaseAccuracy AccuracyLevel=High Solver_Type=Iterative} DC{Cond{MaxPass=10 MinPass=1 MinConvPass=1 PerError=1 PerRefine=30} Mult{MaxPass=1 MinPass=1 MinConvPass=1 PerError=1 PerRefine=30} AccuracyLevel=Normal} AC{MaxPass=12 MinPass=2 MinConvPass=2 PerError=1 PerRefine=30 ACRLSolverType=ACA} ErrorValue=0.1
source amplitudes:
  AC:QH_S_L, AC:QH_S_R, AC:QL_D_L, AC:QL_D_R, DCN:CapB1N, DCN:CapB2N, DCN:CapB3N, DCN:CapNL, DCN:CapNR, DCN:DrvGnd, DCN:QL_S_L, DCN:QL_S_R, DCP:CapB2P, DCP:CapB3P, DCP:CapPL, DCP:CapPR, DCP:QH_D_L, DCP:QH_D_R, G:Gate_L, G:Gate_R: AC R/L Fields 0A
  DCP:CapB1P: AC R/L Fields 1A
  AC, DCN, G: CG Fields 0V 0deg
  DCP: CG Fields 1V 0deg
  AC:QH_S_L, AC:QH_S_R, AC:QL_D_L, AC:QL_D_R, DCN:CapB1N, DCN:CapB2N, DCN:CapB3N, DCN:CapNL, DCN:CapNR, DCN:DrvGnd, DCN:QL_S_L, DCN:QL_S_R, DCP:CapB2P, DCP:CapB3P, DCP:CapPL, DCP:CapPR, DCP:QH_D_L, DCP:QH_D_R, G:Gate_L, G:Gate_R: DC R/L Fields 0A
  DCP:CapB1P: DC R/L Fields 1A
