# Ansys Electronics Desktop project, version 2024.2
materials:
  vacuum: permittivity=1
  copper: permeability=0.999991 conductivity=58000000

design BB_PL_LX_dpt (Q3D Extractor, model units mm)
options: SParamCalcMethod=EqTransLine Calculate_Lossy_Dielectrics
geometry:
  P0_DCN_L1 [copper] = polyline(z=0.17mm, xy in mm: (-28.6908, 12.9189) (-28.65, 20.101) (-28.7184, 20.1952) (-43.551, 20.2) (-43.6452, 20.1316) (-43.65, 12.999) (-43.5816, 12.9048) (-28.749, 12.9) (-28.6908, 12.9189), closed, covered)
  P0_DCN_L1.sweep_along_vector((0mm, 0mm, 0.07mm))
  P1_DCN_L1 = polyline(z=0.17mm, xy in mm: (-3.8908, 12.9189) (-3.85, 20.101) (-3.9184, 20.1952) (-18.751, 20.2) (-18.8452, 20.1316) (-18.85, 12.999) (-18.7816, 12.9048) (-3.949, 12.9) (-3.8908, 12.9189), closed, covered)
  P1_DCN_L1.sweep_along_vector((0mm, 0mm, 0.07mm))
  P2_DCN_L1 = polyline(z=0.17mm, xy in mm: (18.8092, 12.9189) (18.85, 20.101) (18.7816, 20.1952) (3.949, 20.2) (3.8548, 20.1316) (3.85, 12.999) (3.9184, 12.9048) (18.751, 12.9) (18.8092, 12.9189), closed, covered)
  P2_DCN_L1.sweep_along_vector((0mm, 0mm, 0.07mm))
  P3_DCN_L1 = polyline(z=0.17mm, xy in mm: (43.6092, 12.9189) (43.65, 20.101) (43.5816, 20.1952) (28.749, 20.2) (28.6548, 20.1316) (28.65, 12.999) (28.7184, 12.9048) (43.551, 12.9) (43.6092, 12.9189), closed, covered)
  P3_DCN_L1.sweep_along_vector((0mm, 0mm, 0.07mm))
  P4_DCN_L1 = polyline(z=0.17mm, xy in mm: (39.7092, -4.1811) (39.75, 0.801) (39.651, 0.9) (-39.651, 0.9) (-39.75, 0.801) (-39.75, -4.101) (-39.651, -4.2) (39.651, -4.2) (39.7092, -4.1811), closed, covered)
  P4_DCN_L1.sweep_along_vector((0mm, 0mm, 0.07mm))
  P5_DCN_L2 = polyline(z=0mm, xy in mm: (39.75, 11.9) (43.951, 11.9) (44.0452, 11.9684) (44.0311, 20.5592) (28.6908, 20.5756) (28.65, 11.9) (28.3548, 11.8316) (28.35, 10) (27.149, 10) (27.0548, 9.9316) (27.05, 3.3) (20.45, 3.3) (20.45, 9.901) (20.351, 10) (19.15, 10) (19.15, 11.801) (19.0816, 11.8952) (18.85, 11.9) (18.8311, 20.5537) (6.4245, 20.6) (6.3255, 20.501) (6.3255, 2.7456) (6.5056, 2.32) (6.4254, 2.0466) (6.2101, 1.86) (5.7899, 1.86) (5.5746, 2.0466) (5.4944, 2.32) (5.6745, 2.7456) (5.6745, 20.501) (5.5755, 20.6) (-1.45, 20.6) (-1.45, 25.3227) (0.2092, 26.5049) (0.0351, 26.7492) (-1.648, 25.55) (-1.75, 25.55) (-1.8092, 25.4351) (-1.75, 25.352) (-1.75, 20.6) (-18.8092, 20.5756) (-18.85, 11.9) (-19.1452, 11.8316) (-19.15, 10) (-20.351, 10) (-20.4452, 9.9316) (-20.45, 3.3) (-27.05, 3.3) (-27.05, 9.901) (-27.149, 10) (-28.35, 10) (-28.35, 11.801) (-28.4184, 11.8952) (-28.65, 11.9) (-28.6689, 20.5537) (-43.951, 20.6) (-44.05, 20.501) (-44.0311, 11.9408) (-39.75, 11.9) (-39.75, -4.6) (39.75, -4.6) (39.75, 11.9), closed, covered)
  P5_DCN_L2_h0 = polyline(z=0mm, xy in mm: (-37.4351, 11.34) (-37.7102, 11.6575) (-37.7102, 11.9425) (-37.4351, 12.26) (-37.0149, 12.26) (-36.7398, 11.9425) (-36.7398, 11.6575) (-37.0149, 11.34) (-37.297, 11.2995) (-37.4351, 11.34), closed, covered)
  P5_DCN_L2_h1 = polyline(z=0mm, xy in mm: (-10.4851, 11.34) (-10.7602, 11.6575) (-10.7602, 11.9425) (-10.4851, 12.26) (-10.0649, 12.26) (-9.7898, 11.9425) (-9.7898, 11.6575) (-10.0649, 11.34) (-10.347, 11.2995) (-10.4851, 11.34), closed, covered)
  P5_DCN_L2_h2 = polyline(z=0mm, xy in mm: (10.0649, 11.34) (9.7898, 11.6575) (9.7898, 11.9425) (10.0649, 12.26) (10.4851, 12.26) (10.7602, 11.9425) (10.7602, 11.6575) (10.4851, 11.34) (10.203, 11.2995) (10.0649, 11.34), closed, covered)
  P5_DCN_L2_h3 = polyline(z=0mm, xy in mm: (37.0149, 11.34) (36.7398, 11.6575) (36.7398, 11.9425) (37.0149, 12.26) (37.4351, 12.26) (37.7102, 11.9425) (37.7102, 11.6575) (37.4351, 11.34) (37.153, 11.2995) (37.0149, 11.34), closed, covered)
  P5_DCN_L2_h4 = polyline(z=0mm, xy in mm: (-29.2831, 10.0203) (-29.4985, 10.1768) (-29.5597, 10.5631) (-29.4032, 10.7785) (-29.0169, 10.8397) (-28.8015, 10.6832) (-28.7192, 10.43) (-28.8015, 10.1768) (-29.15, 9.9992) (-29.2831, 10.0203), closed, covered)
  P5_DCN_L2_h5 = polyline(z=0mm, xy in mm: (18.2169, 10.0203) (18.0015, 10.1768) (17.9403, 10.5631) (18.0968, 10.7785) (18.4831, 10.8397) (18.6985, 10.6832) (18.7808, 10.43) (18.6985, 10.1768) (18.35, 9.9992) (18.2169, 10.0203), closed, covered)
  P5_DCN_L2_h6 = polyline(z=0mm, xy in mm: (-29.9811, 8.9703) (-30.1965, 9.1268) (-30.2577, 9.5131) (-30.1012, 9.7285) (-29.7149, 9.7897) (-29.4995, 9.6332) (-29.4172, 9.38) (-29.4995, 9.1268) (-29.848, 8.9492) (-29.9811, 8.9703), closed, covered)
  P5_DCN_L2_h7 = polyline(z=0mm, xy in mm: (17.5189, 8.9703) (17.3035, 9.1268) (17.2423, 9.5131) (17.3988, 9.7285) (17.7851, 9.7897) (18.0005, 9.6332) (18.0828, 9.38) (18.0005, 9.1268) (17.652, 8.9492) (17.5189, 8.9703), closed, covered)
  P5_DCN_L2_h8 = polyline(z=0mm, xy in mm: (-17.7851, 8.6103) (-18.0005, 8.7668) (-18.0617, 9.1531) (-17.9052, 9.3685) (-17.5189, 9.4297) (-17.3035, 9.2732) (-17.2212, 9.02) (-17.3035, 8.7668) (-17.652, 8.5892) (-17.7851, 8.6103), closed, covered)
  P5_DCN_L2_h9 = polyline(z=0mm, xy in mm: (29.7149, 8.6103) (29.4995, 8.7668) (29.4383, 9.1531) (29.5948, 9.3685) (29.9811, 9.4297) (30.1965, 9.2732) (30.2788, 9.02) (30.1965, 8.7668) (29.848, 8.5892) (29.7149, 8.6103), closed, covered)
  P5_DCN_L2_h10 = polyline(z=0mm, xy in mm: (-18.5101, 6.59) (-18.7852, 6.9075) (-18.7852, 7.1925) (-18.5573, 7.5609) (-18.7808, 7.97) (-18.6985, 8.2232) (-18.35, 8.4008) (-18.0968, 8.3185) (-17.9403, 8.1031) (-17.9403, 7.8369) (-18.1029, 7.5886) (-17.8746, 7.3234) (-17.7944, 7.05) (-17.9689, 6.6679) (-18.372, 6.5495) (-18.5101, 6.59), closed, covered)
  P5_DCN_L2_h11 = polyline(z=0mm, xy in mm: (28.9899, 6.59) (28.7148, 6.9075) (28.7148, 7.1925) (28.9427, 7.5609) (28.7192, 7.97) (28.8015, 8.2232) (29.15, 8.4008) (29.4032, 8.3185) (29.5597, 8.1031) (29.5597, 7.8369) (29.3971, 7.5886) (29.6254, 7.3234) (29.7056, 7.05) (29.5311, 6.6679) (29.128, 6.5495) (28.9899, 6.59), closed, covered)
  P5_DCN_L2_h12 = polyline(z=0mm, xy in mm: (-29.2831, 5.7203) (-29.5597, 5.9969) (-29.5597, 6.2631) (-29.3971, 6.5114) (-29.6254, 6.7766) (-29.7056, 7.05) (-29.5311, 7.4321) (-29.128, 7.5505) (-28.7746, 7.3234) (-28.6944, 7.05) (-28.9427, 6.5391) (-28.7403, 6.2631) (-28.7403, 5.9969) (-28.8968, 5.7815) (-29.15, 5.6992) (-29.2831, 5.7203), closed, covered)
  P5_DCN_L2_h13 = polyline(z=0mm, xy in mm: (18.2169, 5.7203) (17.9403, 5.9969) (17.9403, 6.2631) (18.1029, 6.5114) (17.8746, 6.7766) (17.7944, 7.05) (17.9689, 7.4321) (18.372, 7.5505) (18.7254, 7.3234) (18.8056, 7.05) (18.5573, 6.5391) (18.7597, 6.2631) (18.7597, 5.9969) (18.6032, 5.7815) (18.35, 5.6992) (18.2169, 5.7203), closed, covered)
  P5_DCN_L2_h14 = polyline(z=0mm, xy in mm: (-29.9811, 4.6703) (-30.1965, 4.8268) (-30.2577, 5.2131) (-30.1012, 5.4285) (-29.7149, 5.4897) (-29.4995, 5.3332) (-29.4172, 5.08) (-29.4995, 4.8268) (-29.848, 4.6492) (-29.9811, 4.6703), closed, covered)
  P5_DCN_L2_h15 = polyline(z=0mm, xy in mm: (17.5189, 4.6703) (17.3035, 4.8268) (17.2423, 5.2131) (17.3988, 5.4285) (17.7851, 5.4897) (18.0005, 5.3332) (18.0828, 5.08) (18.0005, 4.8268) (17.652, 4.6492) (17.5189, 4.6703), closed, covered)
  P5_DCN_L2_h16 = polyline(z=0mm, xy in mm: (-17.7851, 4.3103) (-18.0005, 4.4668) (-18.0617, 4.8531) (-17.9052, 5.0685) (-17.5189, 5.1297) (-17.3035, 4.9732) (-17.2212, 4.72) (-17.3035, 4.4668) (-17.652, 4.2892) (-17.7851, 4.3103), closed, covered)
  P5_DCN_L2_h17 = polyline(z=0mm, xy in mm: (29.7149, 4.3103) (29.4995, 4.4668) (29.4383, 4.8531) (29.5948, 5.0685) (29.9811, 5.1297) (30.1965, 4.9732) (30.2788, 4.72) (30.1965, 4.4668) (29.848, 4.2892) (29.7149, 4.3103), closed, covered)
  P5_DCN_L2_h18 = polyline(z=0mm, xy in mm: (-18.4831, 3.2603) (-18.6985, 3.4168) (-18.7597, 3.8031) (-18.6032, 4.0185) (-18.2169, 4.0797) (-18.0015, 3.9232) (-17.9192, 3.67) (-18.0015, 3.4168) (-18.35, 3.2392) (-18.4831, 3.2603), closed, covered)
  P5_DCN_L2_h19 = polyline(z=0mm, xy in mm: (29.0169, 3.2603) (28.8015, 3.4168) (28.7403, 3.8031) (28.8968, 4.0185) (29.2831, 4.0797) (29.4985, 3.9232) (29.5808, 3.67) (29.4985, 3.4168) (29.15, 3.2392) (29.0169, 3.2603), closed, covered)
  P5_DCN_L2_h20 = polyline(z=0mm, xy in mm: (-35.7101, 2.04) (-35.9852, 2.3575) (-35.9852, 2.6425) (-35.8311, 2.8821) (-35.572, 3.0005) (-35.2899, 2.96) (-35.0724, 2.7997) (-34.672, 3.0005) (-34.3899, 2.96) (-34.1724, 2.7997) (-33.772, 3.0005) (-33.4899, 2.96) (-33.2724, 2.7997) (-32.872, 3.0005) (-32.5899, 2.96) (-32.3724, 2.7997) (-31.972, 3.0005) (-31.6899, 2.96) (-31.4724, 2.7997) (-31.072, 3.0005) (-30.7899, 2.96) (-30.5724, 2.7997) (-30.172, 3.0005) (-29.8899, 2.96) (-29.6724, 2.7997) (-29.4101, 2.96) (-29.128, 3.0005) (-28.7746, 2.7734) (-28.6944, 2.5) (-28.7746, 2.2266) (-29.128, 1.9995) (-29.4101, 2.04) (-29.6276, 2.2003) (-30.028, 1.9995) (-30.3101, 2.04) (-30.5276, 2.2003) (-30.928, 1.9995) (-31.2101, 2.04) (-31.4276, 2.2003) (-31.828, 1.9995) (-32.1101, 2.04) (-32.3276, 2.2003) (-32.728, 1.9995) (-33.0101, 2.04) (-33.2276, 2.2003) (-33.628, 1.9995) (-33.9101, 2.04) (-34.1276, 2.2003) (-34.528, 1.9995) (-34.8101, 2.04) (-35.0276, 2.2003) (-35.2899, 2.04) (-35.572, 1.9995) (-35.7101, 2.04), closed, covered)
  P5_DCN_L2_h21 = polyline(z=0mm, xy in mm: (-18.5101, 2.04) (-18.7852, 2.3575) (-18.7852, 2.6425) (-18.6311, 2.8821) (-18.372, 3.0005) (-18.0899, 2.96) (-17.8724, 2.7997) (-17.472, 3.0005) (-17.1899, 2.96) (-16.9724, 2.7997) (-16.572, 3.0005) (-16.2899, 2.96) (-16.0724, 2.7997) (-15.672, 3.0005) (-15.3899, 2.96) (-15.1724, 2.7997) (-14.772, 3.0005) (-14.4899, 2.96) (-14.2724, 2.7997) (-13.872, 3.0005) (-13.5899, 2.96) (-13.3724, 2.7997) (-12.972, 3.0005) (-12.6899, 2.96) (-12.4724, 2.7997) (-12.2101, 2.96) (-11.928, 3.0005) (-11.5746, 2.7734) (-11.4944, 2.5) (-11.5746, 2.2266) (-11.928, 1.9995) (-12.2101, 2.04) (-12.4276, 2.2003) (-12.828, 1.9995) (-13.1101, 2.04) (-13.3276, 2.2003) (-13.728, 1.9995) (-14.0101, 2.04) (-14.2276, 2.2003) (-14.628, 1.9995) (-14.9101, 2.04) (-15.1276, 2.2003) (-15.528, 1.9995) (-15.8101, 2.04) (-16.0276, 2.2003) (-16.428, 1.9995) (-16.7101, 2.04) (-16.9276, 2.2003) (-17.328, 1.9995) (-17.6101, 2.04) (-17.8276, 2.2003) (-18.0899, 2.04) (-18.372, 1.9995) (-18.5101, 2.04), closed, covered)
  P5_DCN_L2_h22 = polyline(z=0mm, xy in mm: (11.7899, 2.04) (11.5148, 2.3575) (11.5148, 2.6425) (11.6689, 2.8821) (11.928, 3.0005) (12.2101, 2.96) (12.4276, 2.7997) (12.828, 3.0005) (13.1101, 2.96) (13.3276, 2.7997) (13.728, 3.0005) (14.0101, 2.96) (14.2276, 2.7997) (14.628, 3.0005) (14.9101, 2.96) (15.1276, 2.7997) (15.528, 3.0005) (15.8101, 2.96) (16.0276, 2.7997) (16.428, 3.0005) (16.7101, 2.96) (16.9276, 2.7997) (17.328, 3.0005) (17.6101, 2.96) (17.8276, 2.7997) (18.0899, 2.96) (18.372, 3.0005) (18.7254, 2.7734) (18.8056, 2.5) (18.7254, 2.2266) (18.372, 1.9995) (18.0899, 2.04) (17.8724, 2.2003) (17.472, 1.9995) (17.1899, 2.04) (16.9724, 2.2003) (16.572, 1.9995) (16.2899, 2.04) (16.0724, 2.2003) (15.672, 1.9995) (15.3899, 2.04) (15.1724, 2.2003) (14.772, 1.9995) (14.4899, 2.04) (14.2724, 2.2003) (13.872, 1.9995) (13.5899, 2.04) (13.3724, 2.2003) (12.972, 1.9995) (12.6899, 2.04) (12.4724, 2.2003) (12.2101, 2.04) (11.928, 1.9995) (11.7899, 2.04), closed, covered)
  P5_DCN_L2_h23 = polyline(z=0mm, xy in mm: (28.9899, 2.04) (28.7148, 2.3575) (28.7148, 2.6425) (28.8689, 2.8821) (29.128, 3.0005) (29.4101, 2.96) (29.6276, 2.7997) (30.028, 3.0005) (30.3101, 2.96) (30.5276, 2.7997) (30.928, 3.0005) (31.2101, 2.96) (31.4276, 2.7997) (31.828, 3.0005) (32.1101, 2.96) (32.3276, 2.7997) (32.728, 3.0005) (33.0101, 2.96) (33.2276, 2.7997) (33.628, 3.0005) (33.9101, 2.96) (34.1276, 2.7997) (34.528, 3.0005) (34.8101, 2.96) (35.0276, 2.7997) (35.2899, 2.96) (35.572, 3.0005) (35.9254, 2.7734) (36.0056, 2.5) (35.9254, 2.2266) (35.572, 1.9995) (35.2899, 2.04) (35.0724, 2.2003) (34.672, 1.9995) (34.3899, 2.04) (34.1724, 2.2003) (33.772, 1.9995) (33.4899, 2.04) (33.2724, 2.2003) (32.872, 1.9995) (32.5899, 2.04) (32.3724, 2.2003) (31.972, 1.9995) (31.6899, 2.04) (31.4724, 2.2003) (31.072, 1.9995) (30.7899, 2.04) (30.5724, 2.2003) (30.172, 1.9995) (29.8899, 2.04) (29.6724, 2.2003) (29.4101, 2.04) (29.128, 1.9995) (28.9899, 2.04), closed, covered)
  P5_DCN_L2.subtract(P5_DCN_L2_h0..P5_DCN_L2_h23)
  P5_DCN_L2.sweep_along_vector((0mm, 0mm, 0.07mm))
  P6_DCN_L4 = polyline(z=-1.44mm, xy in mm: (-28.4908, -1.1811) (-28.45, 0.851) (-28.5184, 0.9452) (-37.951, 0.95) (-38.0452, 0.8816) (-38.05, -1.101) (-37.9816, -1.1952) (-28.549, -1.2) (-28.4908, -1.1811), closed, covered)
  P6_DCN_L4.sweep_along_vector((0mm, 0mm, 0.07mm))
  P7_DCN_L4 = polyline(z=-1.44mm, xy in mm: (-9.4908, -1.1811) (-9.45, 0.851) (-9.5184, 0.9452) (-18.951, 0.95) (-19.0452, 0.8816) (-19.05, -1.101) (-18.9816, -1.1952) (-9.549, -1.2) (-9.4908, -1.1811), closed, covered)
  P7_DCN_L4.sweep_along_vector((0mm, 0mm, 0.07mm))
  P8_DCN_L4 = polyline(z=-1.44mm, xy in mm: (19.0092, -1.1811) (19.05, 0.851) (18.9816, 0.9452) (9.549, 0.95) (9.4548, 0.8816) (9.45, -1.101) (9.5184, -1.1952) (18.951, -1.2) (19.0092, -1.1811), closed, covered)
  P8_DCN_L4.sweep_along_vector((0mm, 0mm, 0.07mm))
  P9_DCN_L4 = polyline(z=-1.44mm, xy in mm: (38.0092, -1.1811) (38.05, 0.851) (37.9816, 0.9452) (28.549, 0.95) (28.4548, 0.8816) (28.45, -1.101) (28.5184, -1.1952) (37.951, -1.2) (38.0092, -1.1811), closed, covered)
  P9_DCN_L4.sweep_along_vector((0mm, 0mm, 0.07mm))
  P10_DCP_L1 [copper] = polyline(z=0.17mm, xy in mm: (-28.7908, 1.5189) (-28.75, 4.501) (-28.8184, 4.5952) (-30.1057, 4.5811) (-30.1495, 3.1377) (-30.2785, 2.9494) (-30.4106, 2.8995) (-31.3854, 2.8995) (-31.5996, 3.0315) (-31.6495, 4.501) (-31.7179, 4.5952) (-32.2005, 4.6) (-32.2947, 4.5316) (-32.2995, 3.1388) (-32.3736, 2.9736) (-32.5389, 2.8995) (-33.1886, 2.9149) (-33.3351, 3.0614) (-33.3505, 4.501) (-33.4189, 4.5952) (-33.9005, 4.6) (-33.9947, 4.5316) (-33.9995, 3.1388) (-34.0736, 2.9736) (-34.2389, 2.8995) (-34.8886, 2.9149) (-35.0351, 3.0614) (-35.0505, 4.501) (-35.1189, 4.5952) (-37.651, 4.6) (-37.7452, 4.5316) (-37.75, 1.599) (-37.6816, 1.5048) (-28.849, 1.5) (-28.7908, 1.5189), closed, covered)
  P10_DCP_L1.sweep_along_vector((0mm, 0mm, 0.07mm))
  P11_DCP_L1 = polyline(z=0.17mm, xy in mm: (-9.7908, 1.5189) (-9.75, 4.501) (-9.8184, 4.5952) (-12.4087, 4.5811) (-12.4495, 3.1388) (-12.5236, 2.9736) (-12.6889, 2.8995) (-13.3386, 2.9149) (-13.4851, 3.0614) (-13.5005, 4.501) (-13.5995, 4.6) (-14.0505, 4.6) (-14.1447, 4.5316) (-14.1495, 3.1388) (-14.3114, 2.9149) (-14.9612, 2.8995) (-15.1851, 3.0614) (-15.2005, 4.501) (-15.2995, 4.6) (-15.7515, 4.6) (-15.8457, 4.5316) (-15.9029, 4.3191) (-15.8535, 3.1377) (-16.0887, 2.9025) (-17.1153, 2.9025) (-17.3036, 3.0315) (-17.3724, 3.2787) (-17.4525, 3.3195) (-18.0769, 3.3195) (-18.35, 3.2392) (-18.651, 3.3195) (-18.7452, 3.2511) (-18.75, 1.599) (-18.6816, 1.5048) (-9.849, 1.5) (-9.7908, 1.5189), closed, covered)
  P11_DCP_L1.sweep_along_vector((0mm, 0mm, 0.07mm))
  P12_DCP_L1 = polyline(z=0.17mm, xy in mm: (18.7092, 1.5189) (18.75, 4.501) (18.6816, 4.5952) (17.3943, 4.5811) (17.3505, 3.1377) (17.2215, 2.9494) (17.0894, 2.8995) (16.1146, 2.8995) (15.9004, 3.0315) (15.8505, 4.501) (15.7821, 4.5952) (15.2995, 4.6) (15.2053, 4.5316) (15.2005, 3.1388) (15.1264, 2.9736) (14.9611, 2.8995) (14.3114, 2.9149) (14.1649, 3.0614) (14.1495, 4.501) (14.0811, 4.5952) (13.5995, 4.6) (13.5053, 4.5316) (13.5005, 3.1388) (13.4264, 2.9736) (13.2611, 2.8995) (12.6114, 2.9149) (12.4649, 3.0614) (12.4495, 4.501) (12.3811, 4.5952) (9.849, 4.6) (9.7548, 4.5316) (9.75, 1.599) (9.8184, 1.5048) (18.651, 1.5) (18.7092, 1.5189), closed, covered)
  P12_DCP_L1.sweep_along_vector((0mm, 0mm, 0.07mm))
  P13_DCP_L1 = polyline(z=0.17mm, xy in mm: (37.7092, 1.5189) (37.75, 4.501) (37.6816, 4.5952) (35.0913, 4.5811) (35.0505, 3.1388) (34.9764, 2.9736) (34.8111, 2.8995) (34.1614, 2.9149) (34.0149, 3.0614) (33.9995, 4.501) (33.9005, 4.6) (33.4495, 4.6) (33.3553, 4.5316) (33.3505, 3.1388) (33.1886, 2.9149) (32.5388, 2.8995) (32.3149, 3.0614) (32.2995, 4.501) (32.2005, 4.6) (31.7485, 4.6) (31.6543, 4.5316) (31.5971, 4.3191) (31.6465, 3.1377) (31.4113, 2.9025) (30.3847, 2.9025) (30.1964, 3.0315) (30.1276, 3.2787) (30.0475, 3.3195) (29.4231, 3.3195) (29.15, 3.2392) (28.849, 3.3195) (28.7548, 3.2511) (28.75, 1.599) (28.8184, 1.5048) (37.651, 1.5) (37.7092, 1.5189), closed, covered)
  P13_DCP_L1.sweep_along_vector((0mm, 0mm, 0.07mm))
  P14_DCP_L3 = polyline(z=-1.27mm, xy in mm: (39.75, -0.8373) (39.6204, -0.7431) (39.3601, -0.96) (39.078, -1.0005) (38.8189, -0.8821) (38.5812, -0.4988) (38.8189, -0.1179) (39.078, 0.0005) (39.3601, -0.04) (39.6286, -0.2592) (39.75, -0.1627) (39.75, 4.501) (39.651, 4.6) (30.3251, 4.6) (30.1012, 4.3715) (29.848, 4.2892) (29.5948, 4.3715) (29.3709, 4.6) (24.1975, 4.6) (23.822, 4.3995) (23.5399, 4.44) (23.3025, 4.6) (7.3293, 4.6) (7.2351, 4.4704) (7.4852, 4.1425) (7.4852, 3.8575) (7.3311, 3.6179) (7.072, 3.4995) (6.7899, 3.54) (6.5148, 3.8575) (6.5148, 4.1425) (6.763, 4.4651) (6.6707, 4.6) (-17.1749, 4.6) (-17.3988, 4.3715) (-17.652, 4.2892) (-17.9052, 4.3715) (-18.1291, 4.6) (-23.3025, 4.6) (-23.678, 4.3995) (-23.9601, 4.44) (-24.1975, 4.6) (-39.651, 4.6) (-39.75, 4.501) (-39.75, -0.1627) (-39.6204, -0.2569) (-39.3601, -0.04) (-39.078, 0.0005) (-38.8189, -0.1179) (-38.5812, -0.5012) (-38.8189, -0.8821) (-39.078, -1.0005) (-39.3601, -0.96) (-39.6286, -0.7408) (-39.7358, -0.7862) (-39.75, -4.6) (39.75, -4.6) (39.75, -0.8373), closed, covered)
  P14_DCP_L3_h0 = polyline(z=-1.27mm, xy in mm: (-18.4831, 3.2603) (-18.6985, 3.4168) (-18.7597, 3.8031) (-18.6032, 4.0185) (-18.2169, 4.0797) (-18.0015, 3.9232) (-17.9192, 3.67) (-18.0015, 3.4168) (-18.35, 3.2392) (-18.4831, 3.2603), closed, covered)
  P14_DCP_L3_h1 = polyline(z=-1.27mm, xy in mm: (29.0169, 3.2603) (28.8015, 3.4168) (28.7403, 3.8031) (28.8968, 4.0185) (29.2831, 4.0797) (29.4985, 3.9232) (29.5808, 3.67) (29.4985, 3.4168) (29.15, 3.2392) (29.0169, 3.2603), closed, covered)
  P14_DCP_L3_h2 = polyline(z=-1.27mm, xy in mm: (5.7899, 1.86) (5.5148, 2.1775) (5.5148, 2.4625) (5.7899, 2.78) (6.2101, 2.78) (6.4852, 2.4625) (6.4852, 2.1775) (6.2101, 1.86) (5.928, 1.8195) (5.7899, 1.86), closed, covered)
  P14_DCP_L3_h3 = polyline(z=-1.27mm, xy in mm: (-38.1754, -0.96) (-38.3908, -0.7734) (-38.5342, -0.4988) (-38.3908, -0.2266) (-38.1754, -0.04) (-37.7553, -0.04) (-37.54, -0.2266) (-37.3966, -0.5012) (-37.6343, -0.8821) (-38.0373, -1.0005) (-38.1754, -0.96), closed, covered)
  P14_DCP_L3_h4 = polyline(z=-1.27mm, xy in mm: (-36.9908, -0.96) (-37.2061, -0.7734) (-37.3496, -0.4988) (-37.2061, -0.2266) (-36.9908, -0.04) (-36.5707, -0.04) (-36.3554, -0.2266) (-36.212, -0.5012) (-36.4496, -0.8821) (-36.8527, -1.0005) (-36.9908, -0.96), closed, covered)
  P14_DCP_L3_h5 = polyline(z=-1.27mm, xy in mm: (-35.8062, -0.96) (-36.0215, -0.7734) (-36.165, -0.4988) (-36.0215, -0.2266) (-35.8062, -0.04) (-35.3861, -0.04) (-35.1708, -0.2266) (-35.0273, -0.5012) (-35.265, -0.8821) (-35.6681, -1.0005) (-35.8062, -0.96), closed, covered)
  P14_DCP_L3_h6 = polyline(z=-1.27mm, xy in mm: (-34.6216, -0.96) (-34.8369, -0.7734) (-34.9804, -0.4988) (-34.8369, -0.2266) (-34.6216, -0.04) (-34.2015, -0.04) (-33.9862, -0.2266) (-33.8427, -0.5012) (-34.0804, -0.8821) (-34.4835, -1.0005) (-34.6216, -0.96), closed, covered)
  P14_DCP_L3_h7 = polyline(z=-1.27mm, xy in mm: (-33.437, -0.96) (-33.6523, -0.7734) (-33.7957, -0.4988) (-33.6523, -0.2266) (-33.437, -0.04) (-33.0169, -0.04) (-32.8015, -0.2266) (-32.6581, -0.5012) (-32.8958, -0.8821) (-33.2989, -1.0005) (-33.437, -0.96), closed, covered)
  P14_DCP_L3_h8 = polyline(z=-1.27mm, xy in mm: (-32.2524, -0.96) (-32.4677, -0.7734) (-32.6111, -0.4988) (-32.4677, -0.2266) (-32.2524, -0.04) (-31.8323, -0.04) (-31.6169, -0.2266) (-31.4735, -0.5012) (-31.7112, -0.8821) (-32.1143, -1.0005) (-32.2524, -0.96), closed, covered)
  P14_DCP_L3_h9 = polyline(z=-1.27mm, xy in mm: (-31.0677, -0.96) (-31.2831, -0.7734) (-31.4265, -0.4988) (-31.2831, -0.2266) (-31.0678, -0.04) (-30.6476, -0.04) (-30.4323, -0.2266) (-30.2889, -0.5012) (-30.5266, -0.8821) (-30.9297, -1.0005) (-31.0677, -0.96), closed, covered)
  P14_DCP_L3_h10 = polyline(z=-1.27mm, xy in mm: (-29.8831, -0.96) (-30.0985, -0.7734) (-30.2419, -0.4988) (-30.0985, -0.2266) (-29.8831, -0.04) (-29.463, -0.04) (-29.2477, -0.2266) (-29.1043, -0.5012) (-29.3419, -0.8821) (-29.745, -1.0005) (-29.8831, -0.96), closed, covered)
  P14_DCP_L3_h11 = polyline(z=-1.27mm, xy in mm: (-28.6985, -0.96) (-28.9138, -0.7734) (-29.0573, -0.4988) (-28.9138, -0.2266) (-28.6985, -0.04) (-28.2784, -0.04) (-28.0631, -0.2266) (-27.9196, -0.5012) (-28.1573, -0.8821) (-28.5604, -1.0005) (-28.6985, -0.96), closed, covered)
  P14_DCP_L3_h12 = polyline(z=-1.27mm, xy in mm: (-27.5139, -0.96) (-27.7292, -0.7734) (-27.8727, -0.4988) (-27.7292, -0.2266) (-27.5139, -0.04) (-27.0938, -0.04) (-26.8785, -0.2266) (-26.735, -0.5012) (-26.9727, -0.8821) (-27.3758, -1.0005) (-27.5139, -0.96), closed, covered)
  P14_DCP_L3_h13 = polyline(z=-1.27mm, xy in mm: (-26.3293, -0.96) (-26.5446, -0.7734) (-26.688, -0.4988) (-26.5446, -0.2266) (-26.3293, -0.04) (-25.9092, -0.04) (-25.6939, -0.2266) (-25.5504, -0.5012) (-25.7881, -0.8821) (-26.1912, -1.0005) (-26.3293, -0.96), closed, covered)
  P14_DCP_L3_h14 = polyline(z=-1.27mm, xy in mm: (-25.1447, -0.96) (-25.36, -0.7734) (-25.5034, -0.4988) (-25.36, -0.2266) (-25.1447, -0.04) (-24.7246, -0.04) (-24.5092, -0.2266) (-24.3658, -0.5012) (-24.6035, -0.8821) (-25.0066, -1.0005) (-25.1447, -0.96), closed, covered)
  P14_DCP_L3_h15 = polyline(z=-1.27mm, xy in mm: (-23.9601, -0.96) (-24.1754, -0.7734) (-24.3188, -0.4988) (-24.1754, -0.2266) (-23.9601, -0.04) (-23.5399, -0.04) (-23.3246, -0.2266) (-23.1812, -0.5012) (-23.4189, -0.8821) (-23.822, -1.0005) (-23.9601, -0.96), closed, covered)
  P14_DCP_L3_h16 = polyline(z=-1.27mm, xy in mm: (-22.7754, -0.96) (-22.9908, -0.7734) (-23.1342, -0.4988) (-22.9908, -0.2266) (-22.7754, -0.04) (-22.3553, -0.04) (-22.14, -0.2266) (-21.9966, -0.5012) (-22.2343, -0.8821) (-22.6373, -1.0005) (-22.7754, -0.96), closed, covered)
  P14_DCP_L3_h17 = polyline(z=-1.27mm, xy in mm: (-21.5908, -0.96) (-21.8061, -0.7734) (-21.9496, -0.4988) (-21.8061, -0.2266) (-21.5908, -0.04) (-21.1707, -0.04) (-20.9554, -0.2266) (-20.812, -0.5012) (-21.0496, -0.8821) (-21.4527, -1.0005) (-21.5908, -0.96), closed, covered)
  P14_DCP_L3_h18 = polyline(z=-1.27mm, xy in mm: (-20.4062, -0.96) (-20.6215, -0.7734) (-20.765, -0.4988) (-20.6215, -0.2266) (-20.4062, -0.04) (-19.9861, -0.04) (-19.7708, -0.2266) (-19.6273, -0.5012) (-19.865, -0.8821) (-20.2681, -1.0005) (-20.4062, -0.96), closed, covered)
  P14_DCP_L3_h19 = polyline(z=-1.27mm, xy in mm: (-19.2216, -0.96) (-19.4369, -0.7734) (-19.5804, -0.4988) (-19.4369, -0.2266) (-19.2216, -0.04) (-18.8015, -0.04) (-18.5862, -0.2266) (-18.4427, -0.5012) (-18.6804, -0.8821) (-19.0835, -1.0005) (-19.2216, -0.96), closed, covered)
  P14_DCP_L3_h20 = polyline(z=-1.27mm, xy in mm: (-18.037, -0.96) (-18.2523, -0.7734) (-18.3957, -0.4988) (-18.2523, -0.2266) (-18.037, -0.04) (-17.6169, -0.04) (-17.4015, -0.2266) (-17.2581, -0.5012) (-17.4958, -0.8821) (-17.8989, -1.0005) (-18.037, -0.96), closed, covered)
  P14_DCP_L3_h21 = polyline(z=-1.27mm, xy in mm: (-16.8524, -0.96) (-17.0677, -0.7734) (-17.2111, -0.4988) (-17.0677, -0.2266) (-16.8524, -0.04) (-16.4323, -0.04) (-16.2169, -0.2266) (-16.0735, -0.5012) (-16.3112, -0.8821) (-16.7143, -1.0005) (-16.8524, -0.96), closed, covered)
  P14_DCP_L3_h22 = polyline(z=-1.27mm, xy in mm: (-15.6677, -0.96) (-15.8831, -0.7734) (-16.0265, -0.4988) (-15.8831, -0.2266) (-15.6678, -0.04) (-15.2476, -0.04) (-15.0323, -0.2266) (-14.8889, -0.5012) (-15.1266, -0.8821) (-15.5297, -1.0005) (-15.6677, -0.96), closed, covered)
  P14_DCP_L3_h23 = polyline(z=-1.27mm, xy in mm: (-14.4831, -0.96) (-14.6985, -0.7734) (-14.8419, -0.4988) (-14.6985, -0.2266) (-14.4831, -0.04) (-14.063, -0.04) (-13.8477, -0.2266) (-13.7043, -0.5012) (-13.9419, -0.8821) (-14.345, -1.0005) (-14.4831, -0.96), closed, covered)
  P14_DCP_L3_h24 = polyline(z=-1.27mm, xy in mm: (-13.2985, -0.96) (-13.5138, -0.7734) (-13.6573, -0.4988) (-13.5138, -0.2266) (-13.2985, -0.04) (-12.8784, -0.04) (-12.6631, -0.2266) (-12.5196, -0.5012) (-12.7573, -0.8821) (-13.1604, -1.0005) (-13.2985, -0.96), closed, covered)
  P14_DCP_L3_h25 = polyline(z=-1.27mm, xy in mm: (-12.1139, -0.96) (-12.3292, -0.7734) (-12.4727, -0.4988) (-12.3292, -0.2266) (-12.1139, -0.04) (-11.6938, -0.04) (-11.4785, -0.2266) (-11.335, -0.5012) (-11.5727, -0.8821) (-11.9758, -1.0005) (-12.1139, -0.96), closed, covered)
  P14_DCP_L3_h26 = polyline(z=-1.27mm, xy in mm: (-10.9293, -0.96) (-11.1446, -0.7734) (-11.288, -0.4988) (-11.1446, -0.2266) (-10.9293, -0.04) (-10.5092, -0.04) (-10.2939, -0.2266) (-10.1504, -0.5012) (-10.3881, -0.8821) (-10.7912, -1.0005) (-10.9293, -0.96), closed, covered)
  P14_DCP_L3_h27 = polyline(z=-1.27mm, xy in mm: (-9.7447, -0.96) (-9.96, -0.7734) (-10.1034, -0.4988) (-9.96, -0.2266) (-9.7447, -0.04) (-9.3246, -0.04) (-9.1092, -0.2266) (-8.9658, -0.5012) (-9.2035, -0.8821) (-9.6066, -1.0005) (-9.7447, -0.96), closed, covered)
  P14_DCP_L3_h28 = polyline(z=-1.27mm, xy in mm: (-8.56, -0.96) (-8.7754, -0.7734) (-8.9188, -0.4988) (-8.7754, -0.2266) (-8.5601, -0.04) (-8.1399, -0.04) (-7.8648, -0.3575) (-7.8648, -0.6425) (-8.1399, -0.96) (-8.422, -1.0005) (-8.56, -0.96), closed, covered)
  P14_DCP_L3_h29 = polyline(z=-1.27mm, xy in mm: (-7.3601, -0.96) (-7.6352, -0.6425) (-7.6352, -0.3575) (-7.3601, -0.04) (-6.9399, -0.04) (-6.6648, -0.3575) (-6.6648, -0.6425) (-6.9399, -0.96) (-7.222, -1.0005) (-7.3601, -0.96), closed, covered)
  P14_DCP_L3_h30 = polyline(z=-1.27mm, xy in mm: (-6.1601, -0.96) (-6.4352, -0.6425) (-6.4352, -0.3575) (-6.1601, -0.04) (-5.7399, -0.04) (-5.4648, -0.3575) (-5.4648, -0.6425) (-5.7399, -0.96) (-6.022, -1.0005) (-6.1601, -0.96), closed, covered)
  P14_DCP_L3_h31 = polyline(z=-1.27mm, xy in mm: (-4.9601, -0.96) (-5.2352, -0.6425) (-5.2352, -0.3575) (-4.9601, -0.04) (-4.5399, -0.04) (-4.2648, -0.3575) (-4.2648, -0.6425) (-4.5399, -0.96) (-4.822, -1.0005) (-4.9601, -0.96), closed, covered)
  P14_DCP_L3_h32 = polyline(z=-1.27mm, xy in mm: (-3.7601, -0.96) (-4.0352, -0.6425) (-4.0352, -0.3575) (-3.7601, -0.04) (-3.3399, -0.04) (-3.0648, -0.3575) (-3.0648, -0.6425) (-3.3399, -0.96) (-3.622, -1.0005) (-3.7601, -0.96), closed, covered)
  P14_DCP_L3_h33 = polyline(z=-1.27mm, xy in mm: (-2.56, -0.96) (-2.8352, -0.6425) (-2.8352, -0.3575) (-2.5601, -0.04) (-2.1399, -0.04) (-1.8648, -0.3575) (-1.8648, -0.6425) (-2.1399, -0.96) (-2.422, -1.0005) (-2.56, -0.96), closed, covered)
  P14_DCP_L3_h34 = polyline(z=-1.27mm, xy in mm: (-1.3601, -0.96) (-1.6352, -0.6425) (-1.6352, -0.3575) (-1.3601, -0.04) (-0.9399, -0.04) (-0.6648, -0.3575) (-0.6648, -0.6425) (-0.9399, -0.96) (-1.222, -1.0005) (-1.3601, -0.96), closed, covered)
  P14_DCP_L3_h35 = polyline(z=-1.27mm, xy in mm: (-0.1601, -0.96) (-0.4352, -0.6425) (-0.4352, -0.3575) (-0.1601, -0.04) (0.2601, -0.04) (0.5352, -0.3575) (0.5352, -0.6425) (0.2601, -0.96) (-0.022, -1.0005) (-0.1601, -0.96), closed, covered)
  P14_DCP_L3_h36 = polyline(z=-1.27mm, xy in mm: (1.0399, -0.96) (0.7648, -0.6425) (0.7648, -0.3575) (1.0399, -0.04) (1.4601, -0.04) (1.7352, -0.3575) (1.7352, -0.6425) (1.4601, -0.96) (1.178, -1.0005) (1.0399, -0.96), closed, covered)
  P14_DCP_L3_h37 = polyline(z=-1.27mm, xy in mm: (2.2399, -0.96) (1.9648, -0.6425) (1.9648, -0.3575) (2.2399, -0.04) (2.6601, -0.04) (2.9352, -0.3575) (2.9352, -0.6425) (2.6601, -0.96) (2.378, -1.0005) (2.2399, -0.96), closed, covered)
  P14_DCP_L3_h38 = polyline(z=-1.27mm, xy in mm: (3.4399, -0.96) (3.1648, -0.6425) (3.1648, -0.3575) (3.4399, -0.04) (3.8601, -0.04) (4.1352, -0.3575) (4.1352, -0.6425) (3.8601, -0.96) (3.578, -1.0005) (3.4399, -0.96), closed, covered)
  P14_DCP_L3_h39 = polyline(z=-1.27mm, xy in mm: (4.6399, -0.96) (4.3648, -0.6425) (4.3648, -0.3575) (4.6399, -0.04) (5.0601, -0.04) (5.3352, -0.3575) (5.3352, -0.6425) (5.0601, -0.96) (4.778, -1.0005) (4.6399, -0.96), closed, covered)
  P14_DCP_L3_h40 = polyline(z=-1.27mm, xy in mm: (5.8399, -0.96) (5.5648, -0.6425) (5.5648, -0.3575) (5.8399, -0.04) (6.2601, -0.04) (6.5352, -0.3575) (6.5352, -0.6425) (6.2601, -0.96) (5.978, -1.0005) (5.8399, -0.96), closed, covered)
  P14_DCP_L3_h41 = polyline(z=-1.27mm, xy in mm: (8.1399, -0.96) (7.8648, -0.6425) (7.8648, -0.3575) (8.1399, -0.04) (8.5601, -0.04) (8.7754, -0.2266) (8.9188, -0.5012) (8.6811, -0.8821) (8.278, -1.0005) (8.1399, -0.96), closed, covered)
  P14_DCP_L3_h42 = polyline(z=-1.27mm, xy in mm: (9.3246, -0.96) (9.1092, -0.7734) (8.9658, -0.4988) (9.1092, -0.2266) (9.3246, -0.04) (9.7447, -0.04) (9.96, -0.2266) (10.1034, -0.5012) (9.8657, -0.8821) (9.4626, -1.0005) (9.3246, -0.96), closed, covered)
  P14_DCP_L3_h43 = polyline(z=-1.27mm, xy in mm: (10.5092, -0.96) (10.2939, -0.7734) (10.1504, -0.4988) (10.2939, -0.2266) (10.5092, -0.04) (10.9293, -0.04) (11.1446, -0.2266) (11.288, -0.5012) (11.0504, -0.8821) (10.6473, -1.0005) (10.5092, -0.96), closed, covered)
  P14_DCP_L3_h44 = polyline(z=-1.27mm, xy in mm: (11.6938, -0.96) (11.4785, -0.7734) (11.335, -0.4988) (11.4785, -0.2266) (11.6938, -0.04) (12.1139, -0.04) (12.3292, -0.2266) (12.4727, -0.5012) (12.235, -0.8821) (11.8319, -1.0005) (11.6938, -0.96), closed, covered)
  P14_DCP_L3_h45 = polyline(z=-1.27mm, xy in mm: (12.8784, -0.96) (12.6631, -0.7734) (12.5196, -0.4988) (12.6631, -0.2266) (12.8784, -0.04) (13.2985, -0.04) (13.5138, -0.2266) (13.6573, -0.5012) (13.4196, -0.8821) (13.0165, -1.0005) (12.8784, -0.96), closed, covered)
  P14_DCP_L3_h46 = polyline(z=-1.27mm, xy in mm: (14.063, -0.96) (13.8477, -0.7734) (13.7043, -0.4988) (13.8477, -0.2266) (14.063, -0.04) (14.4831, -0.04) (14.6985, -0.2266) (14.8419, -0.5012) (14.6042, -0.8821) (14.2011, -1.0005) (14.063, -0.96), closed, covered)
  P14_DCP_L3_h47 = polyline(z=-1.27mm, xy in mm: (15.2476, -0.96) (15.0323, -0.7734) (14.8889, -0.4988) (15.0323, -0.2266) (15.2476, -0.04) (15.6677, -0.04) (15.8831, -0.2266) (16.0265, -0.5012) (15.7888, -0.8821) (15.3857, -1.0005) (15.2476, -0.96), closed, covered)
  P14_DCP_L3_h48 = polyline(z=-1.27mm, xy in mm: (16.4323, -0.96) (16.2169, -0.7734) (16.0735, -0.4988) (16.2169, -0.2266) (16.4322, -0.04) (16.8524, -0.04) (17.0677, -0.2266) (17.2111, -0.5012) (16.9734, -0.8821) (16.5703, -1.0005) (16.4323, -0.96), closed, covered)
  P14_DCP_L3_h49 = polyline(z=-1.27mm, xy in mm: (17.6169, -0.96) (17.4015, -0.7734) (17.2581, -0.4988) (17.4015, -0.2266) (17.6169, -0.04) (18.037, -0.04) (18.2523, -0.2266) (18.3957, -0.5012) (18.1581, -0.8821) (17.755, -1.0005) (17.6169, -0.96), closed, covered)
  P14_DCP_L3_h50 = polyline(z=-1.27mm, xy in mm: (18.8015, -0.96) (18.5862, -0.7734) (18.4427, -0.4988) (18.5862, -0.2266) (18.8015, -0.04) (19.2216, -0.04) (19.4369, -0.2266) (19.5804, -0.5012) (19.3427, -0.8821) (18.9396, -1.0005) (18.8015, -0.96), closed, covered)
  P14_DCP_L3_h51 = polyline(z=-1.27mm, xy in mm: (19.9861, -0.96) (19.7708, -0.7734) (19.6273, -0.4988) (19.7708, -0.2266) (19.9861, -0.04) (20.4062, -0.04) (20.6215, -0.2266) (20.765, -0.5012) (20.5273, -0.8821) (20.1242, -1.0005) (19.9861, -0.96), closed, covered)
  P14_DCP_L3_h52 = polyline(z=-1.27mm, xy in mm: (21.1707, -0.96) (20.9554, -0.7734) (20.812, -0.4988) (20.9554, -0.2266) (21.1707, -0.04) (21.5908, -0.04) (21.8061, -0.2266) (21.9496, -0.5012) (21.7119, -0.8821) (21.3088, -1.0005) (21.1707, -0.96), closed, covered)
  P14_DCP_L3_h53 = polyline(z=-1.27mm, xy in mm: (22.3553, -0.96) (22.14, -0.7734) (21.9966, -0.4988) (22.14, -0.2266) (22.3553, -0.04) (22.7754, -0.04) (22.9908, -0.2266) (23.1342, -0.5012) (22.8965, -0.8821) (22.4934, -1.0005) (22.3553, -0.96), closed, covered)
  P14_DCP_L3_h54 = polyline(z=-1.27mm, xy in mm: (23.5399, -0.96) (23.3246, -0.7734) (23.1812, -0.4988) (23.3246, -0.2266) (23.5399, -0.04) (23.9601, -0.04) (24.1754, -0.2266) (24.3188, -0.5012) (24.0811, -0.8821) (23.678, -1.0005) (23.5399, -0.96), closed, covered)
  P14_DCP_L3_h55 = polyline(z=-1.27mm, xy in mm: (24.7246, -0.96) (24.5092, -0.7734) (24.3658, -0.4988) (24.5092, -0.2266) (24.7246, -0.04) (25.1447, -0.04) (25.36, -0.2266) (25.5034, -0.5012) (25.2657, -0.8821) (24.8627, -1.0005) (24.7246, -0.96), closed, covered)
  P14_DCP_L3_h56 = polyline(z=-1.27mm, xy in mm: (25.9092, -0.96) (25.6939, -0.7734) (25.5504, -0.4988) (25.6939, -0.2266) (25.9092, -0.04) (26.3293, -0.04) (26.5446, -0.2266) (26.688, -0.5012) (26.4504, -0.8821) (26.0473, -1.0005) (25.9092, -0.96), closed, covered)
  P14_DCP_L3_h57 = polyline(z=-1.27mm, xy in mm: (27.0938, -0.96) (26.8785, -0.7734) (26.735, -0.4988) (26.8785, -0.2266) (27.0938, -0.04) (27.5139, -0.04) (27.7292, -0.2266) (27.8727, -0.5012) (27.635, -0.8821) (27.2319, -1.0005) (27.0938, -0.96), closed, covered)
  P14_DCP_L3_h58 = polyline(z=-1.27mm, xy in mm: (28.2784, -0.96) (28.0631, -0.7734) (27.9196, -0.4988) (28.0631, -0.2266) (28.2784, -0.04) (28.6985, -0.04) (28.9138, -0.2266) (29.0573, -0.5012) (28.8196, -0.8821) (28.4165, -1.0005) (28.2784, -0.96), closed, covered)
  P14_DCP_L3_h59 = polyline(z=-1.27mm, xy in mm: (29.463, -0.96) (29.2477, -0.7734) (29.1043, -0.4988) (29.2477, -0.2266) (29.463, -0.04) (29.8831, -0.04) (30.0985, -0.2266) (30.2419, -0.5012) (30.0042, -0.8821) (29.6011, -1.0005) (29.463, -0.96), closed, covered)
  P14_DCP_L3_h60 = polyline(z=-1.27mm, xy in mm: (30.6476, -0.96) (30.4323, -0.7734) (30.2889, -0.4988) (30.4323, -0.2266) (30.6476, -0.04) (31.0677, -0.04) (31.2831, -0.2266) (31.4265, -0.5012) (31.1888, -0.8821) (30.7857, -1.0005) (30.6476, -0.96), closed, covered)
  P14_DCP_L3_h61 = polyline(z=-1.27mm, xy in mm: (31.8323, -0.96) (31.6169, -0.7734) (31.4735, -0.4988) (31.6169, -0.2266) (31.8322, -0.04) (32.2524, -0.04) (32.4677, -0.2266) (32.6111, -0.5012) (32.3734, -0.8821) (31.9703, -1.0005) (31.8323, -0.96), closed, covered)
  P14_DCP_L3_h62 = polyline(z=-1.27mm, xy in mm: (33.0169, -0.96) (32.8015, -0.7734) (32.6581, -0.4988) (32.8015, -0.2266) (33.0169, -0.04) (33.437, -0.04) (33.6523, -0.2266) (33.7957, -0.5012) (33.5581, -0.8821) (33.155, -1.0005) (33.0169, -0.96), closed, covered)
  P14_DCP_L3_h63 = polyline(z=-1.27mm, xy in mm: (34.2015, -0.96) (33.9862, -0.7734) (33.8427, -0.4988) (33.9862, -0.2266) (34.2015, -0.04) (34.6216, -0.04) (34.8369, -0.2266) (34.9804, -0.5012) (34.7427, -0.8821) (34.3396, -1.0005) (34.2015, -0.96), closed, covered)
  P14_DCP_L3_h64 = polyline(z=-1.27mm, xy in mm: (35.3861, -0.96) (35.1708, -0.7734) (35.0273, -0.4988) (35.1708, -0.2266) (35.3861, -0.04) (35.8062, -0.04) (36.0215, -0.2266) (36.165, -0.5012) (35.9273, -0.8821) (35.5242, -1.0005) (35.3861, -0.96), closed, covered)
  P14_DCP_L3_h65 = polyline(z=-1.27mm, xy in mm: (36.5707, -0.96) (36.3554, -0.7734) (36.212, -0.4988) (36.3554, -0.2266) (36.5707, -0.04) (36.9908, -0.04) (37.2061, -0.2266) (37.3496, -0.5012) (37.1119, -0.8821) (36.7088, -1.0005) (36.5707, -0.96), closed, covered)
  P14_DCP_L3_h66 = polyline(z=-1.27mm, xy in mm: (37.7553, -0.96) (37.54, -0.7734) (37.3966, -0.4988) (37.54, -0.2266) (37.7553, -0.04) (38.1754, -0.04) (38.3908, -0.2266) (38.5342, -0.5012) (38.2965, -0.8821) (37.8934, -1.0005) (37.7553, -0.96), closed, covered)
  P14_DCP_L3.subtract(P14_DCP_L3_h0..P14_DCP_L3_h66)
  P14_DCP_L3.sweep_along_vector((0mm, 0mm, 0.07mm))
  P15_DCP_L4 = polyline(z=-1.44mm, xy in mm: (-28.4908, 1.4689) (-28.45, 3.201) (-28.5184, 3.2952) (-37.951, 3.3) (-38.0452, 3.2316) (-38.05, 1.549) (-37.9816, 1.4548) (-28.549, 1.45) (-28.4908, 1.4689), closed, covered)
  P15_DCP_L4.sweep_along_vector((0mm, 0mm, 0.07mm))
  P16_DCP_L4 = polyline(z=-1.44mm, xy in mm: (-11.4759, 1.4689) (-11.44, 1.5796) (-11.5755, 1.8657) (-11.5755, 2.5243) (-11.4138, 2.9018) (-11.5077, 2.9695) (-12.1597, 2.9724) (-12.5805, 3.3) (-13.1745, 3.3) (-13.4657, 3.1495) (-13.8632, 3.1559) (-14.1055, 3.3) (-14.4857, 3.1495) (-14.8832, 3.1559) (-15.1255, 3.3) (-18.1152, 3.3) (-18.35, 3.2392) (-18.951, 3.3) (-19.0452, 3.2316) (-19.05, 1.549) (-18.9816, 1.4548) (-11.5341, 1.45) (-11.4759, 1.4689), closed, covered)
  P16_DCP_L4.sweep_along_vector((0mm, 0mm, 0.07mm))
  P17_DCP_L4 = polyline(z=-1.44mm, xy in mm: (19.0092, 1.4689) (19.05, 3.201) (18.9816, 3.2952) (9.549, 3.3) (9.4548, 3.2316) (9.45, 1.549) (9.5184, 1.4548) (18.951, 1.45) (19.0092, 1.4689), closed, covered)
  P17_DCP_L4.sweep_along_vector((0mm, 0mm, 0.07mm))
  P18_DCP_L4 = polyline(z=-1.44mm, xy in mm: (36.0241, 1.4689) (36.06, 1.5796) (35.9245, 1.8657) (35.9245, 2.5243) (36.0862, 2.9018) (35.9923, 2.9695) (35.3403, 2.9724) (34.9195, 3.3) (34.3255, 3.3) (34.0343, 3.1495) (33.6368, 3.1559) (33.3945, 3.3) (33.0143, 3.1495) (32.6168, 3.1559) (32.3745, 3.3) (29.3848, 3.3) (29.15, 3.2392) (28.549, 3.3) (28.4548, 3.2316) (28.45, 1.549) (28.5184, 1.4548) (35.9659, 1.45) (36.0241, 1.4689), closed, covered)
  P18_DCP_L4.sweep_along_vector((0mm, 0mm, 0.07mm))
  P19_LSRC1_L1 [copper] = polyline(z=0.17mm, xy in mm: (-36.3943, 9.5189) (-36.3505, 10.9623) (-36.1153, 11.1975) (-35.1146, 11.2005) (-34.9004, 11.0685) (-34.8505, 9.599) (-34.7515, 9.5) (-34.2995, 9.5) (-34.2053, 9.5684) (-34.2005, 10.9612) (-34.1264, 11.1264) (-33.9611, 11.2005) (-33.3114, 11.1851) (-33.1495, 10.9611) (-33.1306, 9.5408) (-32.5995, 9.5) (-32.5005, 9.599) (-32.5005, 10.9612) (-32.4264, 11.1264) (-32.2611, 11.2005) (-30.4106, 11.2005) (-30.1964, 11.0685) (-30.0781, 10.7853) (-29.4231, 10.7805) (-29.15, 10.8608) (-28.7908, 10.7994) (-28.75, 11.2) (-28.65, 11.299) (-28.6689, 12.3592) (-43.6092, 12.3811) (-43.65, 11.299) (-43.5816, 11.2048) (-37.75, 11.2) (-37.7311, 9.5408) (-36.4525, 9.5) (-36.3943, 9.5189), closed, covered)
  P19_LSRC1_L1.sweep_along_vector((0mm, 0mm, 0.07mm))
  P20_LSRC1_L4 = polyline(z=-1.44mm, xy in mm: (-37.025, 13.225) (-37.025, 16.575) (-37.425, 16.575) (-37.425, 11.6) (-37.025, 11.6) (-37.025, 13.225), closed, covered)
  P20_LSRC1_L4.sweep_along_vector((0mm, 0mm, 0.07mm))
  P21_LSRC2_L1 [copper] = polyline(z=0.17mm, xy in mm: (-17.3943, 9.5189) (-17.3505, 10.9623) (-17.1153, 11.1975) (-15.2389, 11.2005) (-15.0736, 11.1264) (-14.9995, 10.9611) (-14.9995, 9.599) (-14.9005, 9.5) (-14.4495, 9.5) (-14.3553, 9.5684) (-14.3505, 10.9612) (-14.1886, 11.1851) (-13.5389, 11.2005) (-13.3736, 11.1264) (-13.2995, 10.9611) (-13.2806, 9.5408) (-12.7485, 9.5) (-12.6495, 9.599) (-12.5996, 11.0685) (-12.3854, 11.2005) (-11.3847, 11.1975) (-11.1495, 10.9623) (-11.1276, 9.5408) (-9.849, 9.5) (-9.75, 9.599) (-9.75, 11.2) (-3.949, 11.2) (-3.85, 11.299) (-3.85, 12.301) (-3.949, 12.4) (-18.751, 12.4) (-18.85, 12.301) (-18.85, 11.299) (-18.75, 11.2) (-18.7311, 9.5408) (-17.4525, 9.5) (-17.3943, 9.5189), closed, covered)
  P21_LSRC2_L1.sweep_along_vector((0mm, 0mm, 0.07mm))
  P22_LSRC2_L4 = polyline(z=-1.44mm, xy in mm: (-10.075, 13.225) (-10.075, 16.575) (-10.475, 16.575) (-10.475, 11.6) (-10.075, 11.6) (-10.075, 13.225), closed, covered)
  P22_LSRC2_L4.sweep_along_vector((0mm, 0mm, 0.07mm))
  P23_LSRC3_L1 [copper] = polyline(z=0.17mm, xy in mm: (11.1057, 9.5189) (11.1495, 10.9623) (11.3847, 11.1975) (12.3854, 11.2005) (12.5996, 11.0685) (12.6495, 9.599) (12.7485, 9.5) (13.2005, 9.5) (13.2947, 9.5684) (13.2995, 10.9612) (13.3736, 11.1264) (13.5389, 11.2005) (14.1886, 11.1851) (14.3505, 10.9611) (14.3694, 9.5408) (14.9005, 9.5) (14.9995, 9.599) (14.9995, 10.9612) (15.0736, 11.1264) (15.2389, 11.2005) (17.0894, 11.2005) (17.3036, 11.0685) (17.4219, 10.7853) (18.0769, 10.7805) (18.35, 10.8608) (18.7092, 10.7994) (18.75, 11.2) (18.85, 11.299) (18.8311, 12.3592) (3.8908, 12.3811) (3.85, 11.299) (3.9184, 11.2048) (9.75, 11.2) (9.7689, 9.5408) (11.0475, 9.5) (11.1057, 9.5189), closed, covered)
  P23_LSRC3_L1.sweep_along_vector((0mm, 0mm, 0.07mm))
  P24_LSRC3_L4 = polyline(z=-1.44mm, xy in mm: (10.475, 13.225) (10.475, 16.575) (10.075, 16.575) (10.075, 11.6) (10.475, 11.6) (10.475, 13.225), closed, covered)
  P24_LSRC3_L4.sweep_along_vector((0mm, 0mm, 0.07mm))
  P25_LSRC4_L1 [copper] = polyline(z=0.17mm, xy in mm: (30.1057, 9.5189) (30.1495, 10.9623) (30.3847, 11.1975) (32.2611, 11.2005) (32.4264, 11.1264) (32.5005, 10.9611) (32.5005, 9.599) (32.5995, 9.5) (33.0505, 9.5) (33.1447, 9.5684) (33.1495, 10.9612) (33.3114, 11.1851) (33.9611, 11.2005) (34.1264, 11.1264) (34.2005, 10.9611) (34.2194, 9.5408) (34.7515, 9.5) (34.8505, 9.599) (34.9004, 11.0685) (35.1146, 11.2005) (36.1153, 11.1975) (36.3505, 10.9623) (36.3724, 9.5408) (37.651, 9.5) (37.75, 9.599) (37.75, 11.2) (43.551, 11.2) (43.65, 11.299) (43.65, 12.301) (43.551, 12.4) (28.749, 12.4) (28.65, 12.301) (28.65, 11.299) (28.75, 11.2) (28.7689, 9.5408) (30.0475, 9.5) (30.1057, 9.5189), closed, covered)
  P25_LSRC4_L1.sweep_along_vector((0mm, 0mm, 0.07mm))
  P26_LSRC4_L4 = polyline(z=-1.44mm, xy in mm: (37.425, 13.225) (37.425, 16.575) (37.025, 16.575) (37.025, 11.6) (37.425, 11.6) (37.425, 13.225), closed, covered)
  P26_LSRC4_L4.sweep_along_vector((0mm, 0mm, 0.07mm))
  P27_AC_L1 [copper] = polyline(z=0.17mm, xy in mm: (-38.0011, 20.8189) (-37.9889, 22.8282) (-37.8782, 22.9389) (-37.349, 22.9505) (-37.25, 23.0495) (-37.2689, 23.418) (-37.5365, 23.5623) (-37.8277, 23.8535) (-38.0056, 24.44) (-37.8277, 25.0265) (-37.25, 25.5182) (-37.25, 39.3) (-10.25, 39.3) (-10.25, 25.5895) (-10.1816, 25.4953) (-9.6218, 25.4789) (-9.4995, 25.3097) (-9.5111, 23.5118) (-9.6218, 23.4011) (-10.151, 23.3895) (-10.25, 23.2905) (-10.2311, 22.922) (-9.8036, 22.6464) (-9.5147, 22.1059) (-9.5748, 21.496) (-9.8036, 21.1536) (-10.0733, 20.9422) (-9.9842, 20.8) (-3.949, 20.8) (-3.8548, 20.8684) (-3.85, 39.3) (3.85, 39.3) (3.85, 20.899) (3.949, 20.8) (9.4407, 20.8) (9.5348, 20.8684) (9.5111, 22.8282) (9.6218, 22.9389) (10.151, 22.9505) (10.25, 23.0495) (10.2311, 23.418) (9.9635, 23.5623) (9.6723, 23.8535) (9.4944, 24.44) (9.6723, 25.0265) (10.25, 25.5182) (10.25, 39.3) (37.25, 39.3) (37.25, 25.5895) (37.3184, 25.4953) (37.8782, 25.4789) (38.0005, 25.3097) (37.9889, 23.5118) (37.8782, 23.4011) (37.349, 23.3895) (37.25, 23.2905) (37.2689, 22.922) (37.5365, 22.7777) (37.8277, 22.4865) (38.0056, 21.9) (37.8277, 21.3136) (37.4183, 20.8816) (37.5158, 20.8) (43.6092, 20.8189) (43.65, 39.3) (43.9092, 39.3189) (43.95, 39.399) (43.9311, 52.455) (43.7709, 52.455) (43.2937, 51.9012) (42.6011, 51.6143) (41.8539, 51.6731) (41.2148, 52.0648) (40.8231, 52.7039) (40.7643, 53.4511) (41.0512, 54.1437) (41.6382, 54.6631) (41.5468, 54.8) (-41.605, 54.7811) (-41.605, 54.6209) (-41.0512, 54.1437) (-40.7643, 53.4511) (-40.8231, 52.7039) (-41.2148, 52.0648) (-41.8539, 51.6731) (-42.6011, 51.6143) (-43.2937, 51.9012) (-43.8131, 52.4882) (-43.9497, 52.4045) (-43.95, 39.399) (-43.8816, 39.3048) (-43.65, 39.3) (-43.65, 20.899) (-43.551, 20.8) (-38.0593, 20.8) (-38.0011, 20.8189), closed, covered)
  P27_AC_L1.sweep_along_vector((0mm, 0mm, 0.07mm))
  P28_AC_L1 = polyline(z=0.17mm, xy in mm: (-36.3943, 5.2189) (-36.3505, 6.6623) (-36.1153, 6.8975) (-35.1146, 6.9005) (-34.9004, 6.7685) (-34.8505, 5.299) (-34.7515, 5.2) (-34.2995, 5.2) (-34.2053, 5.2684) (-34.2005, 6.6612) (-34.0386, 6.8851) (-33.3889, 6.9005) (-33.1649, 6.7386) (-33.1495, 5.299) (-33.0505, 5.2) (-32.5995, 5.2) (-32.5053, 5.2684) (-32.5005, 6.6612) (-32.3386, 6.8851) (-30.4106, 6.9005) (-30.1964, 6.7685) (-30.0781, 6.4853) (-29.4231, 6.4805) (-29.15, 6.5608) (-28.7908, 6.4994) (-28.7689, 8.8592) (-30.1057, 8.8811) (-30.1964, 7.3315) (-30.4106, 7.1995) (-31.3854, 7.1995) (-31.5175, 7.2494) (-31.6465, 7.4377) (-31.6684, 8.8592) (-32.2587, 8.8811) (-32.3149, 7.3614) (-32.4614, 7.2149) (-33.1112, 7.1995) (-33.2764, 7.2736) (-33.3505, 7.4389) (-33.3694, 8.8592) (-33.9005, 8.9) (-33.9995, 8.801) (-34.0149, 7.3614) (-34.1614, 7.2149) (-34.8112, 7.1995) (-34.9764, 7.2736) (-35.0505, 7.4389) (-35.0505, 8.801) (-35.1189, 8.8952) (-37.7092, 8.8811) (-37.7311, 5.2408) (-36.4525, 5.2) (-36.3943, 5.2189), closed, covered)
  P28_AC_L1.sweep_along_vector((0mm, 0mm, 0.07mm))
  P29_AC_L1 = polyline(z=0.17mm, xy in mm: (-17.3943, 5.2189) (-17.3505, 6.6623) (-17.2215, 6.8506) (-17.0894, 6.9005) (-15.2389, 6.9005) (-15.0736, 6.8264) (-14.9995, 6.6611) (-14.9995, 5.299) (-14.9005, 5.2) (-14.4495, 5.2) (-14.3553, 5.2684) (-14.3505, 6.6612) (-14.1886, 6.8851) (-13.5389, 6.9005) (-13.3736, 6.8264) (-13.2995, 6.6611) (-13.2806, 5.2408) (-12.7485, 5.2) (-12.6495, 5.299) (-12.5996, 6.7685) (-12.3854, 6.9005) (-11.3847, 6.8975) (-11.1495, 6.6623) (-11.1276, 5.2408) (-9.7908, 5.2189) (-9.7689, 8.8592) (-12.4087, 8.8811) (-12.4495, 7.4388) (-12.5236, 7.2736) (-12.6889, 7.1995) (-13.3386, 7.2149) (-13.4851, 7.3614) (-13.5005, 8.801) (-13.5995, 8.9) (-14.0505, 8.9) (-14.1447, 8.8316) (-14.1495, 7.4388) (-14.3114, 7.2149) (-14.9612, 7.1995) (-15.1851, 7.3614) (-15.2005, 8.801) (-15.2995, 8.9) (-15.7515, 8.9) (-15.8457, 8.8316) (-15.9029, 8.6191) (-15.8535, 7.4377) (-16.0887, 7.2025) (-17.1153, 7.2025) (-17.3036, 7.3315) (-17.3724, 7.5787) (-17.4525, 7.6195) (-18.0769, 7.6195) (-18.35, 7.5392) (-18.7092, 7.6006) (-18.7311, 5.2408) (-17.4525, 5.2) (-17.3943, 5.2189), closed, covered)
  P29_AC_L1.sweep_along_vector((0mm, 0mm, 0.07mm))
  P30_AC_L1 = polyline(z=0.17mm, xy in mm: (11.1057, 5.2189) (11.1495, 6.6623) (11.3847, 6.8975) (12.3854, 6.9005) (12.5996, 6.7685) (12.6495, 5.299) (12.7485, 5.2) (13.2005, 5.2) (13.2947, 5.2684) (13.2995, 6.6612) (13.4614, 6.8851) (14.1111, 6.9005) (14.3351, 6.7386) (14.3505, 5.299) (14.4495, 5.2) (14.9005, 5.2) (14.9947, 5.2684) (14.9995, 6.6612) (15.1614, 6.8851) (17.0894, 6.9005) (17.3036, 6.7685) (17.4219, 6.4853) (18.0769, 6.4805) (18.35, 6.5608) (18.7092, 6.4994) (18.7311, 8.8592) (17.3943, 8.8811) (17.3036, 7.3315) (17.0894, 7.1995) (16.1146, 7.1995) (15.9825, 7.2494) (15.8535, 7.4377) (15.8316, 8.8592) (15.2413, 8.8811) (15.1851, 7.3614) (15.0386, 7.2149) (14.3888, 7.1995) (14.2236, 7.2736) (14.1495, 7.4389) (14.1306, 8.8592) (13.5995, 8.9) (13.5005, 8.801) (13.4851, 7.3614) (13.3386, 7.2149) (12.6888, 7.1995) (12.5236, 7.2736) (12.4495, 7.4389) (12.4495, 8.801) (12.3811, 8.8952) (9.7908, 8.8811) (9.7689, 5.2408) (11.0475, 5.2) (11.1057, 5.2189), closed, covered)
  P30_AC_L1.sweep_along_vector((0mm, 0mm, 0.07mm))
  P31_AC_L1 = polyline(z=0.17mm, xy in mm: (30.1057, 5.2189) (30.1495, 6.6623) (30.2785, 6.8506) (30.4106, 6.9005) (32.2611, 6.9005) (32.4264, 6.8264) (32.5005, 6.6611) (32.5005, 5.299) (32.5995, 5.2) (33.0505, 5.2) (33.1447, 5.2684) (33.1495, 6.6612) (33.3114, 6.8851) (33.9611, 6.9005) (34.1264, 6.8264) (34.2005, 6.6611) (34.2194, 5.2408) (34.7515, 5.2) (34.8505, 5.299) (34.9004, 6.7685) (35.1146, 6.9005) (36.1153, 6.8975) (36.3505, 6.6623) (36.3724, 5.2408) (37.7092, 5.2189) (37.7311, 8.8592) (35.0913, 8.8811) (35.0505, 7.4388) (34.9764, 7.2736) (34.8111, 7.1995) (34.1614, 7.2149) (34.0149, 7.3614) (33.9995, 8.801) (33.9005, 8.9) (33.4495, 8.9) (33.3553, 8.8316) (33.3505, 7.4388) (33.1886, 7.2149) (32.5388, 7.1995) (32.3149, 7.3614) (32.2995, 8.801) (32.2005, 8.9) (31.7485, 8.9) (31.6543, 8.8316) (31.5971, 8.6191) (31.6465, 7.4377) (31.4113, 7.2025) (30.3847, 7.2025) (30.1964, 7.3315) (30.1276, 7.5787) (30.0475, 7.6195) (29.4231, 7.6195) (29.15, 7.5392) (28.7908, 7.6006) (28.7689, 5.2408) (30.0475, 5.2) (30.1057, 5.2189), closed, covered)
  P31_AC_L1.sweep_along_vector((0mm, 0mm, 0.07mm))
  P32_AC_L2 = polyline(z=0mm, xy in mm: (-7.9632, 20.8025) (-3.949, 20.8055) (-3.8548, 20.8739) (-3.85, 39.3) (3.85, 39.3) (3.85, 22.5503) (3.9249, 22.4543) (6.185, 21.8739) (6.3178, 21.6909) (6.3255, 20.9045) (6.3939, 20.8103) (8.0044, 20.8) (9.4989, 20.8189) (9.5111, 22.8282) (9.6218, 22.9389) (10.151, 22.9505) (10.25, 23.0495) (10.2311, 23.418) (9.9635, 23.5623) (9.6723, 23.8535) (9.4944, 24.44) (9.6723, 25.0265) (10.25, 25.5182) (10.25, 39.3) (37.25, 39.3) (37.25, 25.5895) (37.3184, 25.4953) (37.8782, 25.4789) (38.0005, 25.3097) (37.9889, 23.5118) (37.8782, 23.4011) (37.349, 23.3895) (37.25, 23.2905) (37.2689, 22.922) (37.5365, 22.7777) (37.8277, 22.4865) (38.0056, 21.9) (37.8277, 21.3136) (37.4183, 20.8816) (37.5158, 20.8) (43.6092, 20.8189) (43.65, 39.3) (43.9092, 39.3189) (43.95, 39.399) (43.9311, 52.455) (43.7709, 52.455) (43.2937, 51.9012) (42.6011, 51.6143) (41.8539, 51.6731) (41.2148, 52.0648) (40.8231, 52.7039) (40.7643, 53.4511) (41.0512, 54.1437) (41.6382, 54.6631) (41.5468, 54.8) (-41.605, 54.7811) (-41.605, 54.6209) (-41.0512, 54.1437) (-40.7643, 53.4511) (-40.8231, 52.7039) (-41.2148, 52.0648) (-41.8539, 51.6731) (-42.6011, 51.6143) (-43.2937, 51.9012) (-43.8131, 52.4882) (-43.9497, 52.4045) (-43.95, 39.399) (-43.8816, 39.3048) (-43.65, 39.3) (-43.6311, 20.8463) (-38.063, 20.8055) (-37.9688, 20.8739) (-37.9889, 22.8282) (-37.8782, 22.9389) (-37.349, 22.9505) (-37.25, 23.0495) (-37.2689, 23.418) (-37.5365, 23.5623) (-37.8277, 23.8535) (-38.0056, 24.44) (-37.8277, 25.0265) (-37.25, 25.5182) (-37.25, 39.3) (-10.25, 39.3) (-10.25, 25.5895) (-10.1816, 25.4953) (-9.6218, 25.4789) (-9.4995, 25.3097) (-9.5111, 23.5118) (-9.6218, 23.4011) (-10.151, 23.3895) (-10.25, 23.2905) (-10.2311, 22.922) (-9.9635, 22.7777) (-9.6723, 22.4865) (-9.4944, 21.9) (-9.6723, 21.3136) (-10.0817, 20.8816) (-9.9842, 20.8) (-7.9853, 20.8) (-7.9632, 20.8025), closed, covered)
  P32_AC_L2.sweep_along_vector((0mm, 0mm, 0.07mm))
  P33_AC_L3 = polyline(z=-1.27mm, xy in mm: (-30.2669, 5.2189) (-30.1012, 5.4285) (-29.848, 5.5108) (-29.5948, 5.4285) (-29.4159, 5.2108) (-29.1908, 5.2189) (-29.15, 5.299) (-29.1689, 5.6728) (-29.4985, 5.8768) (-29.5808, 6.13) (-29.4985, 6.3832) (-29.15, 6.6454) (-29.15, 9.9146) (-29.4985, 10.1768) (-29.5808, 10.43) (-29.4985, 10.6832) (-29.15, 10.9454) (-29.15, 21.7604) (-29.2556, 22.1) (-29.15, 22.4396) (-29.15, 33.301) (-29.249, 33.4) (-37.25, 33.4) (-37.25, 39.3) (-10.25, 39.3) (-10.25, 33.4) (-18.251, 33.4) (-18.3452, 33.3316) (-18.35, 22.4396) (-18.2444, 22.1) (-18.35, 21.7604) (-18.3311, 16.0375) (-17.8724, 15.742) (-17.422, 16.0005) (-17.1399, 15.96) (-16.8724, 15.742) (-16.422, 16.0005) (-16.0189, 15.8821) (-15.8444, 15.5) (-15.9587, 15.1585) (-15.8444, 14.8) (-15.9448, 14.3989) (-15.8115, 14.3472) (-15.422, 14.6005) (-15.0189, 14.4821) (-14.8648, 14.2425) (-14.8648, 13.9575) (-14.9587, 13.7585) (-14.8724, 13.642) (-14.422, 13.9005) (-14.1399, 13.86) (-13.8724, 13.642) (-13.422, 13.9005) (-13.1399, 13.86) (-12.8724, 13.642) (-12.5601, 13.86) (-12.278, 13.9005) (-11.9246, 13.6734) (-11.8444, 13.4) (-11.9246, 13.1266) (-12.278, 12.8995) (-12.5601, 12.94) (-12.8276, 13.158) (-13.278, 12.8995) (-13.5601, 12.94) (-13.8276, 13.158) (-14.278, 12.8995) (-14.5601, 12.94) (-14.8276, 13.158) (-15.278, 12.8995) (-15.5601, 12.94) (-15.8276, 13.158) (-16.278, 12.8995) (-16.5601, 12.94) (-16.8276, 13.158) (-17.1399, 12.94) (-17.422, 12.8995) (-17.8276, 13.158) (-18.3294, 12.8647) (-18.35, 8.4854) (-18.0015, 8.2232) (-17.9192, 7.97) (-18.0015, 7.7168) (-18.3488, 7.4701) (-18.35, 5.299) (-18.251, 5.2) (-3.949, 5.2) (-3.8548, 5.2684) (-3.8689, 13.0056) (-3.9796, 13.0416) (-4.422, 12.8995) (-4.8276, 13.158) (-5.1399, 12.94) (-5.422, 12.8995) (-5.8276, 13.158) (-6.1399, 12.94) (-6.422, 12.8995) (-6.8276, 13.158) (-7.1399, 12.94) (-7.422, 12.8995) (-7.8276, 13.158) (-8.1399, 12.94) (-8.5601, 12.94) (-8.7754, 13.1266) (-8.8556, 13.4) (-8.7413, 13.7415) (-8.8556, 14.1) (-8.7552, 14.5011) (-8.8885, 14.5528) (-9.1399, 14.34) (-9.422, 14.2995) (-9.7754, 14.5266) (-9.8556, 14.8) (-9.7754, 15.0734) (-9.422, 15.3005) (-9.1399, 15.26) (-8.8724, 15.042) (-8.7752, 15.0736) (-8.8352, 15.6425) (-8.6811, 15.8821) (-8.422, 16.0005) (-8.1399, 15.96) (-7.8724, 15.742) (-7.422, 16.0005) (-7.1399, 15.96) (-6.8724, 15.742) (-6.422, 16.0005) (-6.1399, 15.96) (-5.8724, 15.742) (-5.422, 16.0005) (-5.1399, 15.96) (-4.8724, 15.742) (-4.422, 16.0005) (-3.8979, 15.8678) (-3.8689, 18.6056) (-3.9796, 18.6416) (-4.422, 18.4995) (-4.8276, 18.758) (-5.1399, 18.54) (-5.422, 18.4995) (-5.8276, 18.758) (-6.1399, 18.54) (-6.422, 18.4995) (-6.8276, 18.758) (-7.1399, 18.54) (-7.422, 18.4995) (-7.8276, 18.758) (-8.1399, 18.54) (-8.422, 18.4995) (-8.8276, 18.758) (-9.1399, 18.54) (-9.422, 18.4995) (-9.8276, 18.758) (-10.1399, 18.54) (-10.422, 18.4995) (-10.8276, 18.758) (-11.1399, 18.54) (-11.422, 18.4995) (-11.8276, 18.758) (-12.1399, 18.54) (-12.422, 18.4995) (-12.8276, 18.758) (-13.1399, 18.54) (-13.422, 18.4995) (-13.8276, 18.758) (-14.1399, 18.54) (-14.422, 18.4995) (-14.8276, 18.758) (-15.1399, 18.54) (-15.422, 18.4995) (-15.8276, 18.758) (-16.1399, 18.54) (-16.422, 18.4995) (-16.8276, 18.758) (-17.1399, 18.54) (-17.422, 18.4995) (-17.6811, 18.6179) (-17.8352, 18.8575) (-17.8352, 19.1425) (-17.7197, 19.3665) (-17.8556, 19.75) (-17.7056, 20.104) (-17.422, 20.2505) (-17.1399, 20.21) (-16.8724, 19.992) (-16.422, 20.2505) (-16.1399, 20.21) (-15.8724, 19.992) (-15.422, 20.2505) (-15.1399, 20.21) (-14.8724, 19.992) (-14.422, 20.2505) (-14.1399, 20.21) (-13.8724, 19.992) (-13.422, 20.2505) (-13.1399, 20.21) (-12.8724, 19.992) (-12.422, 20.2505) (-12.1399, 20.21) (-11.8724, 19.992) (-11.422, 20.2505) (-11.1399, 20.21) (-10.8724, 19.992) (-10.422, 20.2505) (-10.1399, 20.21) (-9.8724, 19.992) (-9.422, 20.2505) (-9.1399, 20.21) (-8.8724, 19.992) (-8.422, 20.2505) (-8.1399, 20.21) (-7.8724, 19.992) (-7.422, 20.2505) (-7.1399, 20.21) (-6.8724, 19.992) (-6.422, 20.2505) (-6.1399, 20.21) (-5.8724, 19.992) (-5.422, 20.2505) (-5.1399, 20.21) (-4.8724, 19.992) (-4.422, 20.2505) (-3.9575, 20.104) (-3.8578, 20.1641) (-3.85, 39.3) (3.85, 39.3) (3.85, 20.2026) (3.9796, 20.1084) (4.278, 20.2505) (4.5601, 20.21) (4.7754, 20.0234) (4.8556, 19.75) (4.7197, 19.3835) (4.8556, 19) (4.7754, 18.7266) (4.422, 18.4995) (3.9575, 18.646) (3.85, 18.5474) (3.8689, 15.8944) (3.9796, 15.8584) (4.278, 16.0005) (4.5601, 15.96) (4.7754, 15.7734) (4.8556, 15.5) (4.7413, 15.1585) (4.8556, 14.8) (4.7413, 14.4585) (4.8556, 14.1) (4.7413, 13.7585) (4.8352, 13.5425) (4.8352, 13.2575) (4.5601, 12.94) (4.278, 12.8995) (3.9575, 13.046) (3.85, 12.9474) (3.85, 5.299) (3.949, 5.2) (17.1749, 5.2) (17.3988, 5.4285) (17.652, 5.5108) (17.9052, 5.4285) (18.0841, 5.2108) (18.3452, 5.2684) (18.3311, 5.6728) (18.0015, 5.8768) (17.9192, 6.13) (18.0015, 6.3832) (18.3488, 6.6299) (18.35, 9.9146) (18.0015, 10.1768) (17.9192, 10.43) (18.0015, 10.6832) (18.35, 10.9454) (18.35, 21.7604) (18.2444, 22.1) (18.35, 22.4396) (18.35, 33.301) (18.251, 33.4) (10.25, 33.4) (10.25, 39.3) (37.25, 39.3) (37.25, 33.4) (29.249, 33.4) (29.1548, 33.3316) (29.15, 22.4396) (29.2556, 22.1) (29.15, 21.7604) (29.1689, 16.0375) (29.6276, 15.742) (30.078, 16.0005) (30.3601, 15.96) (30.6276, 15.742) (31.078, 16.0005) (31.4811, 15.8821) (31.6556, 15.5) (31.5413, 15.1585) (31.6556, 14.8) (31.5552, 14.3989) (31.6885, 14.3472) (32.078, 14.6005)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, closed, covered)
  P33_AC_L3_h0 = polyline(z=-1.27mm, xy in mm: (-30.4831, 30.5153) (-30.6985, 30.6718) (-30.7597, 31.0581) (-30.6032, 31.2735) (-30.2169, 31.3347) (-30.0015, 31.1782) (-29.9192, 30.925) (-30.0015, 30.6718) (-30.35, 30.4942) (-30.4831, 30.5153), closed, covered)
  P33_AC_L3_h1 = polyline(z=-1.27mm, xy in mm: (-17.2831, 30.5153) (-17.4985, 30.6718) (-17.5597, 31.0581) (-17.4032, 31.2735) (-17.0169, 31.3347) (-16.8015, 31.1782) (-16.7192, 30.925) (-16.8015, 30.6718) (-17.15, 30.4942) (-17.2831, 30.5153), closed, covered)
  P33_AC_L3_h2 = polyline(z=-1.27mm, xy in mm: (17.0169, 30.5153) (16.8015, 30.6718) (16.7403, 31.0581) (16.8968, 31.2735) (17.2831, 31.3347) (17.4985, 31.1782) (17.5808, 30.925) (17.4985, 30.6718) (17.15, 30.4942) (17.0169, 30.5153), closed, covered)
  P33_AC_L3_h3 = polyline(z=-1.27mm, xy in mm: (30.2169, 30.5153) (30.0015, 30.6718) (29.9403, 31.0581) (30.0968, 31.2735) (30.4831, 31.3347) (30.6985, 31.1782) (30.7808, 30.925) (30.6985, 30.6718) (30.35, 30.4942) (30.2169, 30.5153), closed, covered)
  P33_AC_L3_h4 = polyline(z=-1.27mm, xy in mm: (-34.7081, 29.9403) (-34.9235, 30.0968) (-34.9847, 30.4831) (-34.8282, 30.6985) (-34.4419, 30.7597) (-34.2265, 30.6032) (-34.1442, 30.35) (-34.2265, 30.0968) (-34.575, 29.9192) (-34.7081, 29.9403), closed, covered)
  P33_AC_L3_h5 = polyline(z=-1.27mm, xy in mm: (-12.8331, 29.9403) (-13.0485, 30.0968) (-13.1097, 30.4831) (-12.9532, 30.6985) (-12.5669, 30.7597) (-12.3515, 30.6032) (-12.2692, 30.35) (-12.3515, 30.0968) (-12.7, 29.9192) (-12.8331, 29.9403), closed, covered)
  P33_AC_L3_h6 = polyline(z=-1.27mm, xy in mm: (12.7919, 29.9403) (12.5765, 30.0968) (12.5153, 30.4831) (12.6718, 30.6985) (13.0581, 30.7597) (13.2735, 30.6032) (13.3558, 30.35) (13.2735, 30.0968) (12.925, 29.9192) (12.7919, 29.9403), closed, covered)
  P33_AC_L3_h7 = polyline(z=-1.27mm, xy in mm: (34.6669, 29.9403) (34.4515, 30.0968) (34.3903, 30.4831) (34.5468, 30.6985) (34.9331, 30.7597) (35.1485, 30.6032) (35.2308, 30.35) (35.1485, 30.0968) (34.8, 29.9192) (34.6669, 29.9403), closed, covered)
  P33_AC_L3_h8 = polyline(z=-1.27mm, xy in mm: (-33.8581, 25.7403) (-34.0735, 25.8968) (-34.1347, 26.2831) (-33.9782, 26.4985) (-33.5919, 26.5597) (-33.3765, 26.4032) (-33.2942, 26.15) (-33.3765, 25.8968) (-33.725, 25.7192) (-33.8581, 25.7403), closed, covered)
  P33_AC_L3_h9 = polyline(z=-1.27mm, xy in mm: (-13.9081, 25.7403) (-14.1235, 25.8968) (-14.1847, 26.2831) (-14.0282, 26.4985) (-13.6419, 26.5597) (-13.4265, 26.4032) (-13.3442, 26.15) (-13.4265, 25.8968) (-13.775, 25.7192) (-13.9081, 25.7403), closed, covered)
  P33_AC_L3_h10 = polyline(z=-1.27mm, xy in mm: (13.6419, 25.7403) (13.4265, 25.8968) (13.3653, 26.2831) (13.5218, 26.4985) (13.9081, 26.5597) (14.1235, 26.4032) (14.2058, 26.15) (14.1235, 25.8968) (13.775, 25.7192) (13.6419, 25.7403), closed, covered)
  P33_AC_L3_h11 = polyline(z=-1.27mm, xy in mm: (33.5919, 25.7403) (33.3765, 25.8968) (33.3153, 26.2831) (33.4718, 26.4985) (33.8581, 26.5597) (34.0735, 26.4032) (34.1558, 26.15) (34.0735, 25.8968) (33.725, 25.7192) (33.5919, 25.7403), closed, covered)
  P33_AC_L3_h12 = polyline(z=-1.27mm, xy in mm: (-37.1559, 23.4047) (-37.5365, 23.5623) (-37.8277, 23.8535) (-37.9853, 24.2341) (-37.9853, 24.6459) (-37.8277, 25.0265) (-37.5365, 25.3177) (-37.1559, 25.4753) (-36.7441, 25.4753) (-36.2036, 25.1864) (-35.9748, 24.844) (-35.8944, 24.44) (-35.9748, 24.036) (-36.2036, 23.6936) (-36.546, 23.4648) (-36.95, 23.3844) (-37.1559, 23.4047), closed, covered)
  P33_AC_L3_h13 = polyline(z=-1.27mm, xy in mm: (10.3441, 23.4047) (9.9635, 23.5623) (9.6723, 23.8535) (9.5147, 24.2341) (9.5147, 24.6459) (9.6723, 25.0265) (9.9635, 25.3177) (10.3441, 25.4753) (10.7559, 25.4753) (11.2964, 25.1864) (11.5252, 24.844) (11.6056, 24.44) (11.5252, 24.036) (11.2964, 23.6936) (10.954, 23.4648) (10.55, 23.3844) (10.3441, 23.4047), closed, covered)
  P33_AC_L3_h14 = polyline(z=-1.27mm, xy in mm: (-11.4198, 23.3895) (-11.6005, 23.5702) (-11.6005, 25.3098) (-11.5446, 25.4346) (-11.4198, 25.4905) (-9.6803, 25.4905) (-9.5554, 25.4346) (-9.4995, 25.3097) (-9.4995, 23.5703) (-9.5554, 23.4454) (-9.6802, 23.3895) (-11.4197, 23.3895) (-11.4198, 23.3895), closed, covered)
  P33_AC_L3_h15 = polyline(z=-1.27mm, xy in mm: (36.0802, 23.3895) (35.8995, 23.5702) (35.8995, 25.3098) (35.9554, 25.4346) (36.0802, 25.4905) (37.8197, 25.4905) (37.9446, 25.4346) (38.0005, 25.3097) (38.0005, 23.5703) (37.9446, 23.4454) (37.8198, 23.3895) (36.0803, 23.3895) (36.0802, 23.3895), closed, covered)
  P33_AC_L3_h16 = polyline(z=-1.27mm, xy in mm: (-10.7559, 20.8647) (-11.1365, 21.0223) (-11.4277, 21.3135) (-11.5853, 21.6941) (-11.5853, 22.1059) (-11.4277, 22.4865) (-11.1365, 22.7777) (-10.7559, 22.9353) (-10.3441, 22.9353) (-9.9635, 22.7777) (-9.6723, 22.4865) (-9.4944, 21.9) (-9.5748, 21.496) (-9.8036, 21.1536) (-10.146, 20.9248) (-10.55, 20.8444) (-10.7559, 20.8647), closed, covered)
  P33_AC_L3_h17 = polyline(z=-1.27mm, xy in mm: (36.7441, 20.8647) (36.3635, 21.0223) (36.0723, 21.3135) (35.9147, 21.6941) (35.9147, 22.1059) (36.0723, 22.4865) (36.3635, 22.7777) (36.7441, 22.9353) (37.1559, 22.9353) (37.5365, 22.7777) (37.8277, 22.4865) (38.0056, 21.9) (37.9252, 21.496) (37.6964, 21.1536) (37.354, 20.9248) (36.95, 20.8444) (36.7441, 20.8647), closed, covered)
  P33_AC_L3_h18 = polyline(z=-1.27mm, xy in mm: (-37.8198, 20.8495) (-38.0005, 21.0302) (-38.0005, 22.7698) (-37.9446, 22.8946) (-37.8198, 22.9505) (-36.0803, 22.9505) (-35.9554, 22.8946) (-35.8995, 22.7697) (-35.8995, 21.0303) (-35.9554, 20.9054) (-36.0802, 20.8495) (-37.8197, 20.8495) (-37.8198, 20.8495), closed, covered)
  P33_AC_L3_h19 = polyline(z=-1.27mm, xy in mm: (9.6802, 20.8495) (9.4995, 21.0302) (9.4995, 22.7698) (9.5554, 22.8946) (9.6802, 22.9505) (11.4197, 22.9505) (11.5446, 22.8946) (11.6005, 22.7697) (11.6005, 21.0303) (11.5446, 20.9054) (11.4198, 20.8495) (9.6803, 20.8495) (9.6802, 20.8495), closed, covered)
  P33_AC_L3_h20 = polyline(z=-1.27mm, xy in mm: (7.1399, 18.54) (6.8648, 18.8575) (6.8648, 19.1425) (6.9803, 19.3665) (6.8444, 19.75) (6.9246, 20.0234) (7.278, 20.2505) (7.5601, 20.21) (7.8276, 19.992) (8.278, 20.2505) (8.5601, 20.21) (8.8276, 19.992) (9.278, 20.2505) (9.5601, 20.21) (9.8276, 19.992) (10.278, 20.2505) (10.5601, 20.21) (10.8276, 19.992) (11.278, 20.2505) (11.5601, 20.21) (11.8276, 19.992) (12.278, 20.2505) (12.5601, 20.21) (12.8276, 19.992) (13.278, 20.2505) (13.5601, 20.21) (13.8276, 19.992) (14.278, 20.2505) (14.5601, 20.21) (14.8276, 19.992) (15.278, 20.2505) (15.5601, 20.21) (15.8276, 19.992) (16.278, 20.2505) (16.5601, 20.21) (16.8276, 19.992) (17.1399, 20.21) (17.422, 20.2505) (17.7754, 20.0234) (17.8556, 19.75) (17.7197, 19.3835) (17.8352, 19.1425) (17.8352, 18.8575) (17.6811, 18.6179) (17.422, 18.4995) (17.1399, 18.54) (16.8724, 18.758) (16.422, 18.4995) (16.1399, 18.54) (15.8724, 18.758) (15.422, 18.4995) (15.1399, 18.54) (14.8724, 18.758) (14.422, 18.4995) (14.1399, 18.54) (13.8724, 18.758) (13.422, 18.4995) (13.1399, 18.54) (12.8724, 18.758) (12.422, 18.4995) (12.1399, 18.54) (11.8724, 18.758) (11.422, 18.4995) (11.1399, 18.54) (10.8724, 18.758) (10.422, 18.4995) (10.1399, 18.54) (9.8724, 18.758) (9.422, 18.4995) (9.1399, 18.54) (8.8724, 18.758) (8.422, 18.4995) (8.1399, 18.54) (7.8724, 18.758) (7.5601, 18.54) (7.278, 18.4995) (7.1399, 18.54), closed, covered)
  P33_AC_L3_h21 = polyline(z=-1.27mm, xy in mm: (29.9399, 18.54) (29.6648, 18.8575) (29.6648, 19.1425) (29.7803, 19.3665) (29.6444, 19.75) (29.7944, 20.104) (30.078, 20.2505) (30.3601, 20.21) (30.6276, 19.992) (31.078, 20.2505) (31.3601, 20.21) (31.6276, 19.992) (32.078, 20.2505) (32.3601, 20.21) (32.6276, 19.992) (33.078, 20.2505) (33.3601, 20.21) (33.6276, 19.992) (34.078, 20.2505) (34.3601, 20.21) (34.6276, 19.992) (35.078, 20.2505) (35.3601, 20.21) (35.6276, 19.992) (36.078, 20.2505) (36.3601, 20.21) (36.6276, 19.992) (37.078, 20.2505) (37.3601, 20.21) (37.6276, 19.992) (38.078, 20.2505) (38.3601, 20.21) (38.6276, 19.992) (39.078, 20.2505) (39.3601, 20.21) (39.6276, 19.992) (39.9399, 20.21) (40.222, 20.2505) (40.5754, 20.0234) (40.6556, 19.75) (40.5197, 19.3835) (40.6352, 19.1425) (40.6352, 18.8575) (40.4811, 18.6179) (40.222, 18.4995) (39.9399, 18.54) (39.6724, 18.758) (39.222, 18.4995) (38.9399, 18.54) (38.6724, 18.758) (38.222, 18.4995) (37.9399, 18.54) (37.6724, 18.758) (37.222, 18.4995) (36.9399, 18.54) (36.6724, 18.758) (36.222, 18.4995) (35.9399, 18.54) (35.6724, 18.758) (35.222, 18.4995) (34.9399, 18.54) (34.6724, 18.758) (34.222, 18.4995) (33.9399, 18.54) (33.6724, 18.758) (33.222, 18.4995) (32.9399, 18.54) (32.6724, 18.758) (32.222, 18.4995) (31.9399, 18.54) (31.6724, 18.758) (31.222, 18.4995) (30.9399, 18.54) (30.6724, 18.758) (30.3601, 18.54) (30.078, 18.4995) (29.9399, 18.54), closed, covered)
  P33_AC_L3_h22 = polyline(z=-1.27mm, xy in mm: (-35.3601, 12.94) (-35.5754, 13.1266) (-35.6556, 13.4) (-35.5754, 13.6734) (-35.3601, 13.86) (-34.9399, 13.86) (-34.6724, 13.642) (-34.3601, 13.86) (-34.078, 13.9005) (-33.6724, 13.642) (-33.3601, 13.86) (-33.078, 13.9005) (-32.6115, 13.6472) (-32.5413, 13.7415) (-32.6352, 13.9575) (-32.6352, 14.2425) (-32.4811, 14.4821) (-32.078, 14.6005) (-31.6724, 14.342) (-31.5752, 14.3736) (-31.6556, 14.8) (-31.5413, 15.1415) (-31.6556, 15.5) (-31.5754, 15.7734) (-31.3601, 15.96) (-30.9399, 15.96) (-30.6724, 15.742) (-30.3601, 15.96) (-30.078, 16.0005) (-29.7246, 15.7734) (-29.6444, 15.5) (-29.7587, 15.1585) (-29.6444, 14.8) (-29.7587, 14.4585) (-29.6444, 14.1) (-29.7587, 13.7585) (-29.6444, 13.4) (-29.7246, 13.1266) (-29.9399, 12.94) (-30.3601, 12.94) (-30.6276, 13.158) (-30.9399, 12.94) (-31.222, 12.8995) (-31.6276, 13.158) (-31.9399, 12.94) (-32.222, 12.8995) (-32.6276, 13.158) (-32.9399, 12.94) (-33.222, 12.8995) (-33.6276, 13.158) (-33.9399, 12.94) (-34.222, 12.8995) (-34.6276, 13.158) (-34.9399, 12.94) (-35.222, 12.8995) (-35.3601, 12.94), closed, covered)
  P33_AC_L3_h23 = polyline(z=-1.27mm, xy in mm: (7.1399, 12.94) (6.9246, 13.1266) (6.8444, 13.4) (6.9587, 13.7415) (6.8444, 14.1) (6.9587, 14.4415) (6.8444, 14.8) (6.9587, 15.1415) (6.8444, 15.5) (7.0189, 15.8821) (7.422, 16.0005) (7.8276, 15.742) (8.1399, 15.96) (8.5601, 15.96) (8.8352, 15.6425) (8.7752, 15.0736) (8.8885, 15.0472) (9.1399, 15.26) (9.422, 15.3005) (9.7754, 15.0734) (9.8352, 14.6575) (9.5601, 14.34) (9.278, 14.2995) (8.8724, 14.558) (8.7652, 14.5148) (8.8556, 14.1) (8.7413, 13.7585) (8.8556, 13.4) (8.6811, 13.0179) (8.278, 12.8995) (7.8724, 13.158) (7.5601, 12.94) (7.278, 12.8995) (7.1399, 12.94), closed, covered)
  P33_AC_L3_h24 = polyline(z=-1.27mm, xy in mm: (12.1399, 12.94) (11.9246, 13.1266) (11.8444, 13.4) (11.9246, 13.6734) (12.1399, 13.86) (12.5601, 13.86) (12.8276, 13.642) (13.1399, 13.86) (13.422, 13.9005) (13.8276, 13.642) (14.1399, 13.86) (14.422, 13.9005) (14.8885, 13.6472) (14.9587, 13.7415) (14.8648, 13.9575) (14.8648, 14.2425) (15.0189, 14.4821) (15.422, 14.6005) (15.8276, 14.342) (15.9248, 14.3736) (15.8444, 14.8) (15.9587, 15.1415) (15.8444, 15.5) (15.9246, 15.7734) (16.1399, 15.96) (16.5601, 15.96) (16.8276, 15.742) (17.1399, 15.96) (17.422, 16.0005) (17.7754, 15.7734) (17.8556, 15.5) (17.7413, 15.1585) (17.8556, 14.8) (17.7413, 14.4585) (17.8556, 14.1) (17.7413, 13.7585) (17.8556, 13.4) (17.7754, 13.1266) (17.5601, 12.94) (17.1399, 12.94) (16.8724, 13.158) (16.5601, 12.94) (16.278, 12.8995) (15.8724, 13.158) (15.5601, 12.94) (15.278, 12.8995) (14.8724, 13.158) (14.5601, 12.94) (14.278, 12.8995) (13.8724, 13.158) (13.5601, 12.94) (13.278, 12.8995) (12.8724, 13.158) (12.5601, 12.94) (12.278, 12.8995) (12.1399, 12.94), closed, covered)
  P33_AC_L3_h25 = polyline(z=-1.27mm, xy in mm: (38.9399, 12.94) (38.7246, 13.1266) (38.6444, 13.4) (38.7587, 13.7415) (38.6444, 14.1) (38.7448, 14.5011) (38.6115, 14.5528) (38.222, 14.2995) (37.9399, 14.34) (37.6648, 14.6575) (37.7246, 15.0734) (38.078, 15.3005) (38.3601, 15.26) (38.6276, 15.042) (38.7248, 15.0736) (38.6648, 15.6425) (38.9399, 15.96) (39.3601, 15.96) (39.6276, 15.742) (39.9399, 15.96) (40.3601, 15.96) (40.5754, 15.7734) (40.6556, 15.5) (40.5413, 15.1585) (40.6556, 14.8) (40.5413, 14.4585) (40.6556, 14.1) (40.5413, 13.7585) (40.6352, 13.5425) (40.6352, 13.2575) (40.4811, 13.0179) (40.222, 12.8995) (39.9399, 12.94) (39.6724, 13.158) (39.3601, 12.94) (39.078, 12.8995) (38.9399, 12.94), closed, covered)
  P33_AC_L3_h26 = polyline(z=-1.27mm, xy in mm: (-37.4351, 11.34) (-37.7102, 11.6575) (-37.7102, 11.9425) (-37.4351, 12.26) (-37.0149, 12.26) (-36.7398, 11.9425) (-36.7398, 11.6575) (-37.0149, 11.34) (-37.297, 11.2995) (-37.4351, 11.34), closed, covered)
  P33_AC_L3_h27 = polyline(z=-1.27mm, xy in mm: (-10.4851, 11.34) (-10.7602, 11.6575) (-10.7602, 11.9425) (-10.4851, 12.26) (-10.0649, 12.26) (-9.7898, 11.9425) (-9.7898, 11.6575) (-10.0649, 11.34) (-10.347, 11.2995) (-10.4851, 11.34), closed, covered)
  P33_AC_L3_h28 = polyline(z=-1.27mm, xy in mm: (10.0649, 11.34) (9.7898, 11.6575) (9.7898, 11.9425) (10.0649, 12.26) (10.4851, 12.26) (10.7602, 11.9425) (10.7602, 11.6575) (10.4851, 11.34) (10.203, 11.2995) (10.0649, 11.34), closed, covered)
  P33_AC_L3_h29 = polyline(z=-1.27mm, xy in mm: (37.0149, 11.34) (36.7398, 11.6575) (36.7398, 11.9425) (37.0149, 12.26) (37.4351, 12.26) (37.7102, 11.9425) (37.7102, 11.6575) (37.4351, 11.34) (37.153, 11.2995) (37.0149, 11.34), closed, covered)
  P33_AC_L3_h30 = polyline(z=-1.27mm, xy in mm: (-29.9811, 8.9703) (-30.1965, 9.1268) (-30.2577, 9.5131) (-30.1012, 9.7285) (-29.7149, 9.7897) (-29.4995, 9.6332) (-29.4172, 9.38) (-29.4995, 9.1268) (-29.848, 8.9492) (-29.9811, 8.9703), closed, covered)
  P33_AC_L3_h31 = polyline(z=-1.27mm, xy in mm: (17.5189, 8.9703) (17.3035, 9.1268) (17.2423, 9.5131) (17.3988, 9.7285) (17.7851, 9.7897) (18.0005, 9.6332) (18.0828, 9.38) (18.0005, 9.1268) (17.652, 8.9492) (17.5189, 8.9703), closed, covered)
  P33_AC_L3_h32 = polyline(z=-1.27mm, xy in mm: (-17.7851, 8.6103) (-18.0005, 8.7668) (-18.0617, 9.1531) (-17.9052, 9.3685) (-17.5189, 9.4297) (-17.3035, 9.2732) (-17.2212, 9.02) (-17.3035, 8.7668) (-17.652, 8.5892) (-17.7851, 8.6103), closed, covered)
  P33_AC_L3_h33 = polyline(z=-1.27mm, xy in mm: (29.7149, 8.6103) (29.4995, 8.7668) (29.4383, 9.1531) (29.5948, 9.3685) (29.9811, 9.4297) (30.1965, 9.2732) (30.2788, 9.02) (30.1965, 8.7668) (29.848, 8.5892) (29.7149, 8.6103), closed, covered)
  P33_AC_L3.subtract(P33_AC_L3_h0..P33_AC_L3_h33)
  P33_AC_L3.sweep_along_vector((0mm, 0mm, 0.07mm))
  P34_AC_L4 = polyline(z=-1.44mm, xy in mm: (-38.5663, 4.6189) (-38.5226, 5.0147) (-38.3971, 5.2522) (-38.1597, 5.3776) (-37.7245, 5.3805) (-37.6255, 5.4795) (-37.6444, 6.8387) (-38.2879, 6.9272) (-38.5226, 7.2453) (-38.5226, 7.9647) (-38.3972, 8.2021) (-38.1597, 8.3276) (-36.1621, 8.2828) (-35.9245, 7.9343) (-35.9274, 7.2453) (-36.0862, 6.8982) (-35.9923, 6.8305) (-35.2121, 6.7828) (-34.9039, 6.4555) (-34.3627, 6.4555) (-34.0343, 6.6505) (-33.6368, 6.6441) (-33.3379, 6.4407) (-33.0143, 6.6505) (-32.6168, 6.6441) (-32.3373, 6.4555) (-29.4671, 6.4555) (-29.15, 6.5608) (-28.8968, 6.4785) (-28.7192, 6.13) (-28.8015, 5.8768) (-29.0169, 5.7203) (-29.4671, 5.8045) (-32.3373, 5.8045) (-32.6168, 5.6159) (-33.0143, 5.6095) (-33.3621, 5.8193) (-33.6368, 5.6159) (-34.0343, 5.6095) (-34.3627, 5.8045) (-34.9039, 5.8045) (-35.0988, 5.5633) (-35.0505, 5.4106) (-30.1651, 5.4055) (-29.848, 5.5108) (-29.5749, 5.4305) (-28.4995, 5.4305) (-28.4053, 5.4989) (-28.3754, 5.8927) (-28.2191, 6.0625) (-27.149, 6.1005) (-27.05, 6.1995) (-27.0689, 7.9587) (-28.0793, 7.9959) (-28.2683, 8.0696) (-28.3945, 8.2628) (-28.4005, 8.9305) (-28.4689, 9.0247) (-29.5749, 9.0295) (-29.848, 8.9492) (-30.1651, 9.0545) (-39.0255, 9.0545) (-39.1197, 8.9861) (-39.1722, 8.4671) (-39.5207, 8.2295) (-41.3597, 8.2324) (-41.5971, 8.3578) (-41.7226, 8.5953) (-41.7226, 9.3147) (-41.5972, 9.5521) (-41.3597, 9.6776) (-40.9245, 9.6805) (-40.8255, 9.7795) (-40.8444, 11.1387) (-41.4879, 11.2272) (-41.7226, 11.5453) (-41.6778, 12.3929) (-41.3293, 12.6305) (-39.3621, 12.5828) (-39.1245, 12.2343) (-39.1274, 11.5453) (-39.2862, 11.1982) (-39.1923, 11.1305) (-38.4121, 11.0828) (-38.1039, 10.7555) (-34.3627, 10.7555) (-34.0343, 10.9505) (-33.6368, 10.9441) (-33.3379, 10.7407) (-33.0143, 10.9505) (-32.6168, 10.9441) (-32.3373, 10.7555) (-29.4671, 10.7555) (-29.15, 10.8608) (-28.8968, 10.7785) (-28.7403, 10.5631) (-28.7403, 10.2969) (-28.8968, 10.0815) (-29.15, 9.9992) (-29.4671, 10.1045) (-32.3373, 10.1045) (-32.6168, 9.9159) (-33.0143, 9.9095) (-33.3621, 10.1193) (-33.6368, 9.9159) (-34.0343, 9.9095) (-34.3627, 10.1045) (-38.1039, 10.1045) (-38.2988, 9.8633) (-38.2505, 9.7106) (-30.1651, 9.7055) (-29.848, 9.8108) (-29.5749, 9.7305) (-28.0207, 9.7341) (-27.8317, 9.6604) (-27.7055, 9.4672) (-27.6806, 8.7413) (-27.149, 8.7005) (-27.05, 8.7995) (-27.0689, 9.9592) (-28.35, 10) (-28.35, 14.901) (-28.449, 15) (-29.15, 15) (-29.15, 21.7604) (-29.2556, 22.1) (-29.15, 22.4396) (-29.1689, 33.3592) (-37.25, 33.4) (-37.25, 39.3) (-10.25, 39.3) (-10.25, 33.4) (-18.251, 33.4) (-18.35, 33.301) (-18.35, 22.4396) (-18.2444, 22.1) (-18.35, 21.7604) (-18.35, 16.0957) (-17.8724, 15.742) (-17.422, 16.0005) (-17.1399, 15.96) (-16.8724, 15.742) (-16.422, 16.0005) (-16.0189, 15.8821) (-15.8444, 15.5) (-15.9587, 15.1585) (-15.8444, 14.8) (-15.9448, 14.3989) (-15.8115, 14.3472) (-15.422, 14.6005) (-15.0189, 14.4821) (-14.8648, 14.2425) (-14.8648, 13.9575) (-14.9587, 13.7585) (-14.8724, 13.642) (-14.422, 13.9005) (-14.1399, 13.86) (-13.8724, 13.642) (-13.422, 13.9005) (-13.1399, 13.86) (-12.8724, 13.642) (-12.5601, 13.86) (-12.278, 13.9005) (-11.9246, 13.6734) (-11.8648, 13.2575) (-12.0189, 13.0179) (-12.278, 12.8995) (-12.5601, 12.94) (-12.8276, 13.158) (-13.278, 12.8995) (-13.5601, 12.94) (-13.8276, 13.158) (-14.278, 12.8995) (-14.5601, 12.94) (-14.8276, 13.158) (-15.278, 12.8995) (-15.5601, 12.94) (-15.8276, 13.158) (-16.278, 12.8995) (-16.5601, 12.94) (-16.8276, 13.158) (-17.278, 12.8995) (-17.5601, 12.94) (-17.8276, 13.158) (-18.1399, 12.94) (-18.422, 12.8995) (-18.6811, 13.0179) (-18.8352, 13.2575) (-18.8352, 13.5425) (-18.7413, 13.7415) (-18.8556, 14.1) (-18.7413, 14.4415) (-18.8536, 14.9472) (-19.1092, 14.9811) (-19.15, 10) (-20.4092, 9.9811) (-20.45, 8.7995) (-20.351, 8.7005) (-19.8413, 8.7194) (-19.7754, 9.1627) (-19.5085, 9.3705) (-17.9251, 9.3705) (-17.652, 9.4508) (-17.3349, 9.3455) (-8.4745, 9.3455) (-8.3803, 9.4139) (-8.3278, 9.9329) (-8.1379, 10.1228) (-6.1403, 10.1676) (-5.9029, 10.0422) (-5.7774, 9.8047) (-5.7774, 9.0853) (-6.0121, 8.7672) (-6.5755, 8.7195) (-6.6697, 8.6511) (-6.6745, 7.3195) (-6.6061, 7.2253) (-6.1403, 7.2176) (-5.9029, 7.0922) (-5.7774, 6.8547) (-5.7774, 6.1353) (-5.9029, 5.8978) (-6.1403, 5.7724) (-8.1379, 5.8172) (-8.3755, 6.1657) (-8.3726, 6.8547) (-8.2138, 7.2018) (-8.3077, 7.2695) (-9.0879, 7.3172) (-9.3961, 7.6445) (-13.1373, 7.6445) (-13.4657, 7.4495) (-13.8632, 7.4559) (-14.1621, 7.6593) (-14.4857, 7.4495) (-14.8832, 7.4559) (-15.1627, 7.6445) (-18.0329, 7.6445) (-18.35, 7.5392) (-18.6032, 7.6215) (-18.7597, 7.8369) (-18.7597, 8.1031) (-18.6032, 8.3185) (-18.35, 8.4008) (-18.0329, 8.2955) (-15.1627, 8.2955) (-14.8832, 8.4841) (-14.4857, 8.4905) (-14.1379, 8.2807) (-13.8632, 8.4841) (-13.4657, 8.4905) (-13.1373, 8.2955) (-9.3961, 8.2955) (-9.1818, 8.5948) (-9.2808, 8.6945) (-17.3349, 8.6945) (-17.652, 8.5892) (-17.9251, 8.6695) (-19.0005, 8.6695) (-19.0947, 8.6011) (-19.1246, 8.2073) (-19.2809, 8.0375) (-20.351, 7.9995) (-20.4452, 7.9311) (-20.45, 6.1995) (-20.351, 6.1005) (-19.4207, 6.1041) (-19.2317, 6.0304) (-19.1055, 5.8372) (-19.0995, 5.1695) (-19.0005, 5.0705) (-17.9251, 5.0705) (-17.652, 5.1508) (-17.3349, 5.0455) (-11.6745, 5.0455) (-11.5803, 5.1139) (-11.5278, 5.6329) (-11.3379, 5.8228) (-9.3403, 5.8676) (-9.1028, 5.7421) (-8.9774, 5.5047) (-8.9975, 4.6705) (-8.9049, 4.6) (-3.949, 4.6) (-3.8548, 4.6684) (-3.8689, 13.0056) (-3.9796, 13.0416) (-4.422, 12.8995) (-4.8276, 13.158) (-5.1399, 12.94) (-5.422, 12.8995) (-5.8276, 13.158) (-6.1399, 12.94) (-6.422, 12.8995) (-6.8276, 13.158) (-7.1399, 12.94) (-7.422, 12.8995) (-7.8276, 13.158) (-8.1399, 12.94) (-8.422, 12.8995)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, closed, covered)
  P34_AC_L4_h0 = polyline(z=-1.44mm, xy in mm: (-30.4831, 30.5153) (-30.6985, 30.6718) (-30.7597, 31.0581) (-30.6032, 31.2735) (-30.2169, 31.3347) (-30.0015, 31.1782) (-29.9192, 30.925) (-30.0015, 30.6718) (-30.35, 30.4942) (-30.4831, 30.5153), closed, covered)
  P34_AC_L4_h1 = polyline(z=-1.44mm, xy in mm: (-17.2831, 30.5153) (-17.4985, 30.6718) (-17.5597, 31.0581) (-17.4032, 31.2735) (-17.0169, 31.3347) (-16.8015, 31.1782) (-16.7192, 30.925) (-16.8015, 30.6718) (-17.15, 30.4942) (-17.2831, 30.5153), closed, covered)
  P34_AC_L4_h2 = polyline(z=-1.44mm, xy in mm: (17.0169, 30.5153) (16.8015, 30.6718) (16.7403, 31.0581) (16.8968, 31.2735) (17.2831, 31.3347) (17.4985, 31.1782) (17.5808, 30.925) (17.4985, 30.6718) (17.15, 30.4942) (17.0169, 30.5153), closed, covered)
  P34_AC_L4_h3 = polyline(z=-1.44mm, xy in mm: (30.2169, 30.5153) (30.0015, 30.6718) (29.9403, 31.0581) (30.0968, 31.2735) (30.4831, 31.3347) (30.6985, 31.1782) (30.7808, 30.925) (30.6985, 30.6718) (30.35, 30.4942) (30.2169, 30.5153), closed, covered)
  P34_AC_L4_h4 = polyline(z=-1.44mm, xy in mm: (-34.7081, 29.9403) (-34.9235, 30.0968) (-34.9847, 30.4831) (-34.8282, 30.6985) (-34.4419, 30.7597) (-34.2265, 30.6032) (-34.1442, 30.35) (-34.2265, 30.0968) (-34.575, 29.9192) (-34.7081, 29.9403), closed, covered)
  P34_AC_L4_h5 = polyline(z=-1.44mm, xy in mm: (-12.8331, 29.9403) (-13.0485, 30.0968) (-13.1097, 30.4831) (-12.9532, 30.6985) (-12.5669, 30.7597) (-12.3515, 30.6032) (-12.2692, 30.35) (-12.3515, 30.0968) (-12.7, 29.9192) (-12.8331, 29.9403), closed, covered)
  P34_AC_L4_h6 = polyline(z=-1.44mm, xy in mm: (12.7919, 29.9403) (12.5765, 30.0968) (12.5153, 30.4831) (12.6718, 30.6985) (13.0581, 30.7597) (13.2735, 30.6032) (13.3558, 30.35) (13.2735, 30.0968) (12.925, 29.9192) (12.7919, 29.9403), closed, covered)
  P34_AC_L4_h7 = polyline(z=-1.44mm, xy in mm: (34.6669, 29.9403) (34.4515, 30.0968) (34.3903, 30.4831) (34.5468, 30.6985) (34.9331, 30.7597) (35.1485, 30.6032) (35.2308, 30.35) (35.1485, 30.0968) (34.8, 29.9192) (34.6669, 29.9403), closed, covered)
  P34_AC_L4_h8 = polyline(z=-1.44mm, xy in mm: (-33.8581, 25.7403) (-34.0735, 25.8968) (-34.1347, 26.2831) (-33.9782, 26.4985) (-33.5919, 26.5597) (-33.3765, 26.4032) (-33.2942, 26.15) (-33.3765, 25.8968) (-33.725, 25.7192) (-33.8581, 25.7403), closed, covered)
  P34_AC_L4_h9 = polyline(z=-1.44mm, xy in mm: (-13.9081, 25.7403) (-14.1235, 25.8968) (-14.1847, 26.2831) (-14.0282, 26.4985) (-13.6419, 26.5597) (-13.4265, 26.4032) (-13.3442, 26.15) (-13.4265, 25.8968) (-13.775, 25.7192) (-13.9081, 25.7403), closed, covered)
  P34_AC_L4_h10 = polyline(z=-1.44mm, xy in mm: (13.6419, 25.7403) (13.4265, 25.8968) (13.3653, 26.2831) (13.5218, 26.4985) (13.9081, 26.5597) (14.1235, 26.4032) (14.2058, 26.15) (14.1235, 25.8968) (13.775, 25.7192) (13.6419, 25.7403), closed, covered)
  P34_AC_L4_h11 = polyline(z=-1.44mm, xy in mm: (33.5919, 25.7403) (33.3765, 25.8968) (33.3153, 26.2831) (33.4718, 26.4985) (33.8581, 26.5597) (34.0735, 26.4032) (34.1558, 26.15) (34.0735, 25.8968) (33.725, 25.7192) (33.5919, 25.7403), closed, covered)
  P34_AC_L4_h12 = polyline(z=-1.44mm, xy in mm: (-37.1559, 23.4047) (-37.5365, 23.5623) (-37.8277, 23.8535) (-37.9853, 24.2341) (-37.9853, 24.6459) (-37.8277, 25.0265) (-37.5365, 25.3177) (-37.1559, 25.4753) (-36.7441, 25.4753) (-36.2036, 25.1864) (-35.9748, 24.844) (-35.8944, 24.44) (-35.9748, 24.036) (-36.2036, 23.6936) (-36.546, 23.4648) (-36.95, 23.3844) (-37.1559, 23.4047), closed, covered)
  P34_AC_L4_h13 = polyline(z=-1.44mm, xy in mm: (10.3441, 23.4047) (9.9635, 23.5623) (9.6723, 23.8535) (9.5147, 24.2341) (9.5147, 24.6459) (9.6723, 25.0265) (9.9635, 25.3177) (10.3441, 25.4753) (10.7559, 25.4753) (11.2964, 25.1864) (11.5252, 24.844) (11.6056, 24.44) (11.5252, 24.036) (11.2964, 23.6936) (10.954, 23.4648) (10.55, 23.3844) (10.3441, 23.4047), closed, covered)
  P34_AC_L4_h14 = polyline(z=-1.44mm, xy in mm: (-11.4198, 23.3895) (-11.6005, 23.5702) (-11.6005, 25.3098) (-11.5446, 25.4346) (-11.4198, 25.4905) (-9.6803, 25.4905) (-9.5554, 25.4346) (-9.4995, 25.3097) (-9.4995, 23.5703) (-9.5554, 23.4454) (-9.6802, 23.3895) (-11.4197, 23.3895) (-11.4198, 23.3895), closed, covered)
  P34_AC_L4_h15 = polyline(z=-1.44mm, xy in mm: (36.0802, 23.3895) (35.8995, 23.5702) (35.8995, 25.3098) (35.9554, 25.4346) (36.0802, 25.4905) (37.8197, 25.4905) (37.9446, 25.4346) (38.0005, 25.3097) (38.0005, 23.5703) (37.9446, 23.4454) (37.8198, 23.3895) (36.0803, 23.3895) (36.0802, 23.3895), closed, covered)
  P34_AC_L4_h16 = polyline(z=-1.44mm, xy in mm: (-10.7559, 20.8647) (-11.1365, 21.0223) (-11.4277, 21.3135) (-11.5853, 21.6941) (-11.5853, 22.1059) (-11.4277, 22.4865) (-11.1365, 22.7777) (-10.7559, 22.9353) (-10.3441, 22.9353) (-9.9635, 22.7777) (-9.6723, 22.4865) (-9.4944, 21.9) (-9.5748, 21.496) (-9.8036, 21.1536) (-10.146, 20.9248) (-10.55, 20.8444) (-10.7559, 20.8647), closed, covered)
  P34_AC_L4_h17 = polyline(z=-1.44mm, xy in mm: (36.7441, 20.8647) (36.3635, 21.0223) (36.0723, 21.3135) (35.9147, 21.6941) (35.9147, 22.1059) (36.0723, 22.4865) (36.3635, 22.7777) (36.7441, 22.9353) (37.1559, 22.9353) (37.5365, 22.7777) (37.8277, 22.4865) (38.0056, 21.9) (37.9252, 21.496) (37.6964, 21.1536) (37.354, 20.9248) (36.95, 20.8444) (36.7441, 20.8647), closed, covered)
  P34_AC_L4_h18 = polyline(z=-1.44mm, xy in mm: (-37.8198, 20.8495) (-38.0005, 21.0302) (-38.0005, 22.7698) (-37.9446, 22.8946) (-37.8198, 22.9505) (-36.0803, 22.9505) (-35.9554, 22.8946) (-35.8995, 22.7697) (-35.8995, 21.0303) (-35.9554, 20.9054) (-36.0802, 20.8495) (-37.8197, 20.8495) (-37.8198, 20.8495), closed, covered)
  P34_AC_L4_h19 = polyline(z=-1.44mm, xy in mm: (9.6802, 20.8495) (9.4995, 21.0302) (9.4995, 22.7698) (9.5554, 22.8946) (9.6802, 22.9505) (11.4197, 22.9505) (11.5446, 22.8946) (11.6005, 22.7697) (11.6005, 21.0303) (11.5446, 20.9054) (11.4198, 20.8495) (9.6803, 20.8495) (9.6802, 20.8495), closed, covered)
  P34_AC_L4_h20 = polyline(z=-1.44mm, xy in mm: (7.1399, 18.54) (6.8648, 18.8575) (6.8648, 19.1425) (6.9803, 19.3665) (6.8444, 19.75) (6.9246, 20.0234) (7.278, 20.2505) (7.5601, 20.21) (7.8276, 19.992) (8.278, 20.2505) (8.5601, 20.21) (8.8276, 19.992) (9.278, 20.2505) (9.5601, 20.21) (9.8276, 19.992) (10.278, 20.2505) (10.5601, 20.21) (10.8276, 19.992) (11.278, 20.2505) (11.5601, 20.21) (11.8276, 19.992) (12.278, 20.2505) (12.5601, 20.21) (12.8276, 19.992) (13.278, 20.2505) (13.5601, 20.21) (13.8276, 19.992) (14.278, 20.2505) (14.5601, 20.21) (14.8276, 19.992) (15.278, 20.2505) (15.5601, 20.21) (15.8276, 19.992) (16.278, 20.2505) (16.5601, 20.21) (16.8276, 19.992) (17.1399, 20.21) (17.422, 20.2505) (17.7754, 20.0234) (17.8556, 19.75) (17.7197, 19.3835) (17.8352, 19.1425) (17.8352, 18.8575) (17.6811, 18.6179) (17.422, 18.4995) (17.1399, 18.54) (16.8724, 18.758) (16.422, 18.4995) (16.1399, 18.54) (15.8724, 18.758) (15.422, 18.4995) (15.1399, 18.54) (14.8724, 18.758) (14.422, 18.4995) (14.1399, 18.54) (13.8724, 18.758) (13.422, 18.4995) (13.1399, 18.54) (12.8724, 18.758) (12.422, 18.4995) (12.1399, 18.54) (11.8724, 18.758) (11.422, 18.4995) (11.1399, 18.54) (10.8724, 18.758) (10.422, 18.4995) (10.1399, 18.54) (9.8724, 18.758) (9.422, 18.4995) (9.1399, 18.54) (8.8724, 18.758) (8.422, 18.4995) (8.1399, 18.54) (7.8724, 18.758) (7.5601, 18.54) (7.278, 18.4995) (7.1399, 18.54), closed, covered)
  P34_AC_L4_h21 = polyline(z=-1.44mm, xy in mm: (29.9399, 18.54) (29.6648, 18.8575) (29.6648, 19.1425) (29.7803, 19.3665) (29.6444, 19.75) (29.7944, 20.104) (30.078, 20.2505) (30.3601, 20.21) (30.6276, 19.992) (31.078, 20.2505) (31.3601, 20.21) (31.6276, 19.992) (32.078, 20.2505) (32.3601, 20.21) (32.6276, 19.992) (33.078, 20.2505) (33.3601, 20.21) (33.6276, 19.992) (34.078, 20.2505) (34.3601, 20.21) (34.6276, 19.992) (35.078, 20.2505) (35.3601, 20.21) (35.6276, 19.992) (36.078, 20.2505) (36.3601, 20.21) (36.6276, 19.992) (37.078, 20.2505) (37.3601, 20.21) (37.6276, 19.992) (38.078, 20.2505) (38.3601, 20.21) (38.6276, 19.992) (39.078, 20.2505) (39.3601, 20.21) (39.6276, 19.992) (39.9399, 20.21) (40.222, 20.2505) (40.5754, 20.0234) (40.6556, 19.75) (40.5197, 19.3835) (40.6352, 19.1425) (40.6352, 18.8575) (40.4811, 18.6179) (40.222, 18.4995) (39.9399, 18.54) (39.6724, 18.758) (39.222, 18.4995) (38.9399, 18.54) (38.6724, 18.758) (38.222, 18.4995) (37.9399, 18.54) (37.6724, 18.758) (37.222, 18.4995) (36.9399, 18.54) (36.6724, 18.758) (36.222, 18.4995) (35.9399, 18.54) (35.6724, 18.758) (35.222, 18.4995) (34.9399, 18.54) (34.6724, 18.758) (34.222, 18.4995) (33.9399, 18.54) (33.6724, 18.758) (33.222, 18.4995) (32.9399, 18.54) (32.6724, 18.758) (32.222, 18.4995) (31.9399, 18.54) (31.6724, 18.758) (31.222, 18.4995) (30.9399, 18.54) (30.6724, 18.758) (30.3601, 18.54) (30.078, 18.4995) (29.9399, 18.54), closed, covered)
  P34_AC_L4_h22 = polyline(z=-1.44mm, xy in mm: (10.0649, 11.34) (9.7898, 11.6575) (9.8745, 12.139) (9.8745, 12.6005) (9.8061, 12.6947) (9.2121, 12.7472) (9.0222, 12.9371) (8.9061, 13.2017) (8.422, 12.8995) (8.1399, 12.94) (7.8724, 13.158) (7.422, 12.8995) (7.1399, 12.94) (6.9246, 13.1266) (6.8444, 13.4) (6.9587, 13.7415) (6.8444, 14.1) (6.9587, 14.4415) (6.8444, 14.8) (6.9587, 15.1415) (6.8648, 15.3575) (6.8648, 15.6425) (7.0189, 15.8821) (7.278, 16.0005) (7.5601, 15.96) (7.8276, 15.742) (8.1399, 15.96) (8.422, 16.0005) (8.6811, 15.8821) (8.8352, 15.6425) (8.7752, 15.0736) (8.8885, 15.0472) (9.278, 15.3005) (9.814, 15.1332) (9.8745, 15.2244) (9.8556, 15.6087) (9.3403, 15.6524) (9.0222, 15.8871) (9.0222, 16.8629) (9.3403, 17.0976) (11.2097, 17.0976) (11.4471, 16.9721) (11.5726, 16.7347) (11.5726, 16.0153) (11.4133, 15.7294) (11.4501, 15.619) (12.1597, 15.5976) (12.3972, 15.4721) (12.5961, 15.2255) (13.1373, 15.2255) (13.4168, 15.4141) (13.8632, 15.4141) (14.1041, 15.1732) (14.1041, 14.6268) (13.9704, 14.4359) (13.8143, 14.3795) (13.4168, 14.3859) (13.1373, 14.5745) (12.5961, 14.5745) (12.3972, 14.3278) (12.1597, 14.2024) (11.4495, 14.1806) (11.4136, 14.0699) (11.5755, 13.7543) (11.5278, 12.9371) (11.2097, 12.7024) (10.7163, 12.6806) (10.6755, 12.139) (10.7602, 11.6575) (10.4851, 11.34) (10.203, 11.2995) (10.0649, 11.34), closed, covered)
  P34_AC_L4_h23 = polyline(z=-1.44mm, xy in mm: (37.0149, 11.34) (36.7398, 11.6575) (36.7398, 11.9425) (36.8241, 12.1305) (36.8056, 12.6587) (36.1621, 12.7472) (35.9274, 13.0653) (35.9274, 13.7847) (36.0867, 14.0706) (36.0499, 14.181) (35.3403, 14.2024) (35.1029, 14.3278) (34.9039, 14.5745) (34.3627, 14.5745) (34.0832, 14.3859) (33.6368, 14.3859) (33.3959, 14.6268) (33.3959, 15.1732) (33.5296, 15.3641) (33.6857, 15.4205) (34.0832, 15.4141) (34.3627, 15.2255) (34.9039, 15.2255) (35.1029, 15.4722) (35.3403, 15.5976) (36.0505, 15.6194) (36.0864, 15.7301) (35.9274, 16.0153) (35.9245, 16.7043) (36.1621, 17.0528) (38.1597, 17.0976) (38.3972, 16.9721) (38.5226, 16.7347) (38.5226, 16.0153) (38.2879, 15.6972) (37.6663, 15.6306) (37.6444, 15.1662) (37.7551, 15.1303) (37.9399, 15.26) (38.222, 15.3005) (38.6885, 15.0472) (38.7587, 15.1415) (38.6648, 15.3575) (38.6648, 15.6425) (38.9399, 15.96) (39.3601, 15.96) (39.6276, 15.742) (39.9399, 15.96) (40.3601, 15.96) (40.5754, 15.7734) (40.6556, 15.5) (40.5413, 15.1585) (40.6556, 14.8) (40.5413, 14.4585) (40.6556, 14.1) (40.5413, 13.7585) (40.6352, 13.5425) (40.6352, 13.2575) (40.4811, 13.0179) (40.222, 12.8995) (39.9399, 12.94) (39.6724, 13.158) (39.3601, 12.94) (39.078, 12.8995) (38.6132, 13.2059) (38.2879, 12.7472) (37.6663, 12.6806) (37.6255, 12.139) (37.7102, 11.6575) (37.4351, 11.34) (37.153, 11.2995) (37.0149, 11.34), closed, covered)
  P34_AC_L4_h24 = polyline(z=-1.44mm, xy in mm: (-35.3601, 12.94) (-35.5754, 13.1266) (-35.6556, 13.4) (-35.5754, 13.6734) (-35.3601, 13.86) (-34.9399, 13.86) (-34.6724, 13.642) (-34.3601, 13.86) (-34.078, 13.9005) (-33.6724, 13.642) (-33.3601, 13.86) (-33.078, 13.9005) (-32.6115, 13.6472) (-32.5413, 13.7415) (-32.6352, 13.9575) (-32.6352, 14.2425) (-32.4811, 14.4821) (-32.078, 14.6005) (-31.6724, 14.342) (-31.5752, 14.3736) (-31.6556, 14.8) (-31.5413, 15.1415) (-31.6556, 15.5) (-31.5754, 15.7734) (-31.3601, 15.96) (-30.9399, 15.96) (-30.6724, 15.742) (-30.3601, 15.96) (-30.078, 16.0005) (-29.7246, 15.7734) (-29.6444, 15.5) (-29.7587, 15.1585) (-29.6444, 14.8) (-29.7587, 14.4585) (-29.6444, 14.1) (-29.7587, 13.7585) (-29.6444, 13.4) (-29.7246, 13.1266) (-29.9399, 12.94) (-30.3601, 12.94) (-30.6276, 13.158) (-30.9399, 12.94) (-31.222, 12.8995) (-31.6276, 13.158) (-31.9399, 12.94) (-32.222, 12.8995) (-32.6276, 13.158) (-32.9399, 12.94) (-33.222, 12.8995) (-33.6276, 13.158) (-33.9399, 12.94) (-34.222, 12.8995) (-34.6276, 13.158) (-34.9399, 12.94) (-35.222, 12.8995) (-35.3601, 12.94), closed, covered)
  P34_AC_L4_h25 = polyline(z=-1.44mm, xy in mm: (12.1399, 12.94) (11.9246, 13.1266) (11.8444, 13.4) (11.9246, 13.6734) (12.1399, 13.86) (12.5601, 13.86) (12.8276, 13.642) (13.1399, 13.86) (13.422, 13.9005) (13.8276, 13.642) (14.1399, 13.86) (14.422, 13.9005) (14.8885, 13.6472) (14.9587, 13.7415) (14.8648, 13.9575) (14.8648, 14.2425) (15.0189, 14.4821) (15.422, 14.6005) (15.8276, 14.342) (15.9248, 14.3736) (15.8444, 14.8) (15.9587, 15.1415) (15.8444, 15.5) (15.9246, 15.7734) (16.1399, 15.96) (16.5601, 15.96) (16.8276, 15.742) (17.1399, 15.96) (17.422, 16.0005) (17.7754, 15.7734) (17.8556, 15.5) (17.7413, 15.1585) (17.8556, 14.8) (17.7413, 14.4585) (17.8556, 14.1) (17.7413, 13.7585) (17.8556, 13.4) (17.7754, 13.1266) (17.5601, 12.94) (17.1399, 12.94) (16.8724, 13.158) (16.5601, 12.94) (16.278, 12.8995) (15.8724, 13.158) (15.5601, 12.94) (15.278, 12.8995) (14.8724, 13.158) (14.5601, 12.94) (14.278, 12.8995) (13.8724, 13.158) (13.5601, 12.94) (13.278, 12.8995) (12.8724, 13.158) (12.5601, 12.94) (12.278, 12.8995) (12.1399, 12.94), closed, covered)
  P34_AC_L4.subtract(P34_AC_L4_h0..P34_AC_L4_h25)
  P34_AC_L4.sweep_along_vector((0mm, 0mm, 0.07mm))
  V0_DCP = cylinder(axis=Z, base_centre=(-31.9mm, 2.5mm, -1.44mm), radius=0.15mm, height=1.68mm)
  V1_DCP = cylinder(axis=Z, base_centre=(-29.2mm, 2.5mm, -1.44mm), radius=0.15mm, height=1.68mm)
  V2_DCP = cylinder(axis=Z, base_centre=(16.5mm, 2.5mm, -1.44mm), radius=0.15mm, height=1.68mm)
  V3_DCP = cylinder(axis=Z, base_centre=(-12mm, 2.5mm, -1.44mm), radius=0.15mm, height=1.68mm)
  V4_DCP = cylinder(axis=Z, base_centre=(12mm, 2.5mm, -1.44mm), radius=0.15mm, height=1.68mm)
  V5_DCP = cylinder(axis=Z, base_centre=(29.2mm, 2.5mm, -1.44mm), radius=0.15mm, height=1.68mm)
  V6_DCP = cylinder(axis=Z, base_centre=(31mm, 2.5mm, -1.44mm), radius=0.15mm, height=1.68mm)
  V7_DCP = cylinder(axis=Z, base_centre=(17.4mm, 2.5mm, -1.44mm), radius=0.15mm, height=1.68mm)
  V8_DCP = cylinder(axis=Z, base_centre=(30.1mm, 2.5mm, -1.44mm), radius=0.15mm, height=1.68mm)
  V9_DCP = cylinder(axis=Z, base_centre=(-18.3mm, 2.5mm, -1.44mm), radius=0.15mm, height=1.68mm)
  V10_DCP = cylinder(axis=Z, base_centre=(-17.4mm, 2.5mm, -1.44mm), radius=0.15mm, height=1.68mm)
  V11_DCP = cylinder(axis=Z, base_centre=(35.5mm, 2.5mm, -1.44mm), radius=0.15mm, height=1.68mm)
  V12_DCP = cylinder(axis=Z, base_centre=(-15.6mm, 2.5mm, -1.44mm), radius=0.15mm, height=1.68mm)
  V13_DCP = cylinder(axis=Z, base_centre=(12.9mm, 2.5mm, -1.44mm), radius=0.15mm, height=1.68mm)
  V14_DCP = cylinder(axis=Z, base_centre=(14.7mm, 2.5mm, -1.44mm), radius=0.15mm, height=1.68mm)
  V15_DCP = cylinder(axis=Z, base_centre=(-32.8mm, 2.5mm, -1.44mm), radius=0.15mm, height=1.68mm)
  V16_DCP = cylinder(axis=Z, base_centre=(31.9mm, 2.5mm, -1.44mm), radius=0.15mm, height=1.68mm)
  V17_DCP = cylinder(axis=Z, base_centre=(-31mm, 2.5mm, -1.44mm), radius=0.15mm, height=1.68mm)
  V18_DCP = cylinder(axis=Z, base_centre=(-34.6mm, 2.5mm, -1.44mm), radius=0.15mm, height=1.68mm)
  V19_DCP = cylinder(axis=Z, base_centre=(18.3mm, 2.5mm, -1.44mm), radius=0.15mm, height=1.68mm)
  V20_DCP = cylinder(axis=Z, base_centre=(-13.8mm, 2.5mm, -1.44mm), radius=0.15mm, height=1.68mm)
  V21_DCP = cylinder(axis=Z, base_centre=(-33.7mm, 2.5mm, -1.44mm), radius=0.15mm, height=1.68mm)
  V22_DCP = cylinder(axis=Z, base_centre=(-30.1mm, 2.5mm, -1.44mm), radius=0.15mm, height=1.68mm)
  V23_DCP = cylinder(axis=Z, base_centre=(13.8mm, 2.5mm, -1.44mm), radius=0.15mm, height=1.68mm)
  V24_DCP = cylinder(axis=Z, base_centre=(-12.9mm, 2.5mm, -1.44mm), radius=0.15mm, height=1.68mm)
  V25_DCP = cylinder(axis=Z, base_centre=(32.8mm, 2.5mm, -1.44mm), radius=0.15mm, height=1.68mm)
  V26_DCP = cylinder(axis=Z, base_centre=(-35.5mm, 2.5mm, -1.44mm), radius=0.15mm, height=1.68mm)
  V27_DCP = cylinder(axis=Z, base_centre=(33.7mm, 2.5mm, -1.44mm), radius=0.15mm, height=1.68mm)
  V28_DCP = cylinder(axis=Z, base_centre=(15.6mm, 2.5mm, -1.44mm), radius=0.15mm, height=1.68mm)
  V29_DCP = cylinder(axis=Z, base_centre=(34.6mm, 2.5mm, -1.44mm), radius=0.15mm, height=1.68mm)
  V30_DCP = cylinder(axis=Z, base_centre=(-14.7mm, 2.5mm, -1.44mm), radius=0.15mm, height=1.68mm)
  V31_DCP = cylinder(axis=Z, base_centre=(-16.5mm, 2.5mm, -1.44mm), radius=0.15mm, height=1.68mm)
  V32_DCN = cylinder(axis=Z, base_centre=(-18.35mm, 13.4mm, -1.44mm), radius=0.15mm, height=1.68mm)
  V33_DCN = cylinder(axis=Z, base_centre=(36.7808mm, -0.5mm, -1.44mm), radius=0.15mm, height=1.68mm)
  V34_DCN = cylinder(axis=Z, base_centre=(-16.35mm, 14.1mm, -1.44mm), radius=0.15mm, height=1.68mm)
  V35_DCN = cylinder(axis=Z, base_centre=(32.0423mm, -0.5mm, -1.44mm), radius=0.15mm, height=1.68mm)
  V36_DCN = cylinder(axis=Z, base_centre=(-41.15mm, 19mm, -1.44mm), radius=0.15mm, height=1.68mm)
  V37_DCN = cylinder(axis=Z, base_centre=(31.15mm, 19mm, -1.44mm), radius=0.15mm, height=1.68mm)
  V38_DCN = cylinder(axis=Z, base_centre=(-6.35mm, 19.75mm, -1.44mm), radius=0.15mm, height=1.68mm)
  V39_DCN = cylinder(axis=Z, base_centre=(29.6731mm, -0.5mm, -1.44mm), radius=0.15mm, height=1.68mm)
  V40_DCN = cylinder(axis=Z, base_centre=(15.4577mm, -0.5mm, -1.44mm), radius=0.15mm, height=1.68mm)
  V41_DCN = cylinder(axis=Z, base_centre=(-7.35mm, 15.5mm, -1.44mm), radius=0.15mm, height=1.68mm)
  V42_DCN = cylinder(axis=Z, base_centre=(-6.35mm, 14.1mm, -1.44mm), radius=0.15mm, height=1.68mm)
  V43_DCN = cylinder(axis=Z, base_centre=(-30.15mm, 14.8mm, -1.44mm), radius=0.15mm, height=1.68mm)
  V44_DCN = cylinder(axis=Z, base_centre=(35.5962mm, -0.5mm, -1.44mm), radius=0.15mm, height=1.68mm)
  V45_DCN = cylinder(axis=Z, base_centre=(31.15mm, 13.4mm, -1.44mm), radius=0.15mm, height=1.68mm)
  V46_DCN = cylinder(axis=Z, base_centre=(30.15mm, 19mm, -1.44mm), radius=0.15mm, height=1.68mm)
  V47_DCN = cylinder(axis=Z, base_centre=(29.15mm, 15.5mm, -1.44mm), radius=0.15mm, height=1.68mm)
  V48_DCN = cylinder(axis=Z, base_centre=(4.35mm, 14.8mm, -1.44mm), radius=0.15mm, height=1.68mm)
  V49_DCN = cylinder(axis=Z, base_centre=(-8.35mm, 13.4mm, -1.44mm), radius=0.15mm, height=1.68mm)
  V50_DCN = cylinder(axis=Z, base_centre=(-40.15mm, 15.5mm, -1.44mm), radius=0.15mm, height=1.68mm)
  V51_DCN = cylinder(axis=Z, base_centre=(11.35mm, 19mm, -1.44mm), radius=0.15mm, height=1.68mm)
  V52_DCN = cylinder(axis=Z, base_centre=(43.15mm, 13.4mm, -1.44mm), radius=0.15mm, height=1.68mm)
  V53_DCN = cylinder(axis=Z, base_centre=(31.15mm, 15.5mm, -1.44mm), radius=0.15mm, height=1.68mm)
  V54_DCN = cylinder(axis=Z, base_centre=(-23.75mm, -0.5mm, -1.44mm), radius=0.15mm, height=1.68mm)
  V55_DCN = cylinder(axis=Z, base_centre=(-27.3038mm, -0.5mm, -1.44mm), radius=0.15mm, height=1.68mm)
  V56_DCN = cylinder(axis=Z, base_centre=(7.35mm, 19mm, -1.44mm), radius=0.15mm, height=1.68mm)
  V57_DCN = cylinder(axis=Z, base_centre=(-11.35mm, 19mm, -1.44mm), radius=0.15mm, height=1.68mm)
  V58_DCN = cylinder(axis=Z, base_centre=(-22.5654mm, -0.5mm, -1.44mm), radius=0.15mm, height=1.68mm)
  V59_DCN = cylinder(axis=Z, base_centre=(-15.4577mm, -0.5mm, -1.44mm), radius=0.15mm, height=1.68mm)
  V60_DCN = cylinder(axis=Z, base_centre=(9.35mm, 14.8mm, -1.44mm), radius=0.15mm, height=1.68mm)
  V61_DCN = cylinder(axis=Z, base_centre=(16.35mm, 19.75mm, -1.44mm), radius=0.15mm, height=1.68mm)
  V62_DCN = cylinder(axis=Z, base_centre=(-16.35mm, 15.5mm, -1.44mm), radius=0.15mm, height=1.68mm)
  V63_DCN = cylinder(axis=Z, base_centre=(-7.35mm, 14.8mm, -1.44mm), radius=0.15mm, height=1.68mm)
  V64_DCN = cylinder(axis=Z, base_centre=(-30.15mm, 19mm, -1.44mm), radius=0.15mm, height=1.68mm)
  V65_DCN = cylinder(axis=Z, base_centre=(-18.35mm, 14.1mm, -1.44mm), radius=0.15mm, height=1.68mm)
  V66_DCN = cylinder(axis=Z, base_centre=(-18.35mm, 15.5mm, -1.44mm), radius=0.15mm, height=1.68mm)
  V67_DCN = cylinder(axis=Z, base_centre=(-19.0115mm, -0.5mm, -1.44mm), radius=0.15mm, height=1.68mm)
  V68_DCN = cylinder(axis=Z, base_centre=(-16.35mm, 13.4mm, -1.44mm), radius=0.15mm, height=1.68mm)
  V69_DCN = cylinder(axis=Z, base_centre=(-35.5962mm, -0.5mm, -1.44mm), radius=0.15mm, height=1.68mm)
  V70_DCN = cylinder(axis=Z, base_centre=(-42.15mm, 13.4mm, -1.44mm), radius=0.15mm, height=1.68mm)
  V71_DCN = cylinder(axis=Z, base_centre=(-6.35mm, 15.5mm, -1.44mm), radius=0.15mm, height=1.68mm)
  V72_DCN = cylinder(axis=Z, base_centre=(0.05mm, -0.5mm, -1.44mm), radius=0.15mm, height=1.68mm)
  V73_DCN = cylinder(axis=Z, base_centre=(32.15mm, 19.75mm, -1.44mm), radius=0.15mm, height=1.68mm)
  V74_DCN = cylinder(axis=Z, base_centre=(-43.15mm, 13.4mm, -1.44mm), radius=0.15mm, height=1.68mm)
  V75_DCN = cylinder(axis=Z, base_centre=(39.15mm, 19mm, -1.44mm), radius=0.15mm, height=1.68mm)
  V76_DCN = cylinder(axis=Z, base_centre=(-10.35mm, 19mm, -1.44mm), radius=0.15mm, height=1.68mm)
  V77_DCN = cylinder(axis=Z, base_centre=(34.15mm, 19.75mm, -1.44mm), radius=0.15mm, height=1.68mm)
  V78_DCN = cylinder(axis=Z, base_centre=(-13.0885mm, -0.5mm, -1.44mm), radius=0.15mm, height=1.68mm)
  V79_DCN = cylinder(axis=Z, base_centre=(-12.35mm, 19.75mm, -1.44mm), radius=0.15mm, height=1.68mm)
  V80_DCN = cylinder(axis=Z, base_centre=(-7.35mm, 14.1mm, -1.44mm), radius=0.15mm, height=1.68mm)
  V81_DCN = cylinder(axis=Z, base_centre=(43.15mm, 14.1mm, -1.44mm), radius=0.15mm, height=1.68mm)
  V82_DCN = cylinder(axis=Z, base_centre=(-35.15mm, 19.75mm, -1.44mm), radius=0.15mm, height=1.68mm)
  V83_DCN = cylinder(axis=Z, base_centre=(-5.35mm, 14.8mm, -1.44mm), radius=0.15mm, height=1.68mm)
  V84_DCN = cylinder(axis=Z, base_centre=(33.15mm, 19mm, -1.44mm), radius=0.15mm, height=1.68mm)
  V85_DCN = cylinder(axis=Z, base_centre=(-11.9038mm, -0.5mm, -1.44mm), radius=0.15mm, height=1.68mm)
  V86_DCN = cylinder(axis=Z, base_centre=(-8.35mm, 14.1mm, -1.44mm), radius=0.15mm, height=1.68mm)
  V87_DCN = cylinder(axis=Z, base_centre=(35.15mm, 19.75mm, -1.44mm), radius=0.15mm, height=1.68mm)
  V88_DCN = cylinder(axis=Z, base_centre=(33.2269mm, -0.5mm, -1.44mm), radius=0.15mm, height=1.68mm)
  V89_DCN = cylinder(axis=Z, base_centre=(-17.35mm, 15.5mm, -1.44mm), radius=0.15mm, height=1.68mm)
  V90_DCN = cylinder(axis=Z, base_centre=(-14.35mm, 19mm, -1.44mm), radius=0.15mm, height=1.68mm)
  V91_DCN = cylinder(axis=Z, base_centre=(13.35mm, 19.75mm, -1.44mm), radius=0.15mm, height=1.68mm)
  V92_DCN = cylinder(axis=Z, base_centre=(-12.35mm, 13.4mm, -1.44mm), radius=0.15mm, height=1.68mm)
  V93_DCN = cylinder(axis=Z, base_centre=(-33.15mm, 13.4mm, -1.44mm), radius=0.15mm, height=1.68mm)
  V94_DCN = cylinder(axis=Z, base_centre=(-6.35mm, 13.4mm, -1.44mm), radius=0.15mm, height=1.68mm)
  V95_DCN = cylinder(axis=Z, base_centre=(33.15mm, 13.4mm, -1.44mm), radius=0.15mm, height=1.68mm)
  V96_DCN = cylinder(axis=Z, base_centre=(-41.15mm, 14.1mm, -1.44mm), radius=0.15mm, height=1.68mm)
  V97_DCN = cylinder(axis=Z, base_centre=(40.15mm, 15.5mm, -1.44mm), radius=0.15mm, height=1.68mm)
  V98_DCN = cylinder(axis=Z, base_centre=(-5.35mm, 19mm, -1.44mm), radius=0.15mm, height=1.68mm)
  V99_DCN = cylinder(axis=Z, base_centre=(-13.35mm, 19.75mm, -1.44mm), radius=0.15mm, height=1.68mm)
  V100_DCN = cylinder(axis=Z, base_centre=(-16.35mm, 19.75mm, -1.44mm), radius=0.15mm, height=1.68mm)
  V101_DCN = cylinder(axis=Z, base_centre=(-21.3808mm, -0.5mm, -1.44mm), radius=0.15mm, height=1.68mm)
  V102_DCN = cylinder(axis=Z, base_centre=(8.35mm, 19.75mm, -1.44mm), radius=0.15mm, height=1.68mm)
  V103_DCN = cylinder(axis=Z, base_centre=(-4.35mm, 19mm, -1.44mm), radius=0.15mm, height=1.68mm)
  V104_DCN = cylinder(axis=Z, base_centre=(16.35mm, 14.8mm, -1.44mm), radius=0.15mm, height=1.68mm)
  V105_DCN = cylinder(axis=Z, base_centre=(16.35mm, 15.5mm, -1.44mm), radius=0.15mm, height=1.68mm)
  V106_DCN = cylinder(axis=Z, base_centre=(34.4115mm, -0.5mm, -1.44mm), radius=0.15mm, height=1.68mm)
  V107_DCN = cylinder(axis=Z, base_centre=(15.35mm, 13.4mm, -1.44mm), radius=0.15mm, height=1.68mm)
  V108_DCN = cylinder(axis=Z, base_centre=(15.35mm, 19.75mm, -1.44mm), radius=0.15mm, height=1.68mm)
  V109_DCN = cylinder(axis=Z, base_centre=(17.8269mm, -0.5mm, -1.44mm), radius=0.15mm, height=1.68mm)
  V110_DCN = cylinder(axis=Z, base_centre=(-34.15mm, 19mm, -1.44mm), radius=0.15mm, height=1.68mm)
  V111_DCN = cylinder(axis=Z, base_centre=(8.35mm, 14.1mm, -1.44mm), radius=0.15mm, height=1.68mm)
  V112_DCN = cylinder(axis=Z, base_centre=(4.35mm, 19mm, -1.44mm), radius=0.15mm, height=1.68mm)
  V113_DCN = cylinder(axis=Z, base_centre=(7.35mm, 14.8mm, -1.44mm), radius=0.15mm, height=1.68mm)
  V114_DCN = cylinder(axis=Z, base_centre=(-32.15mm, 19mm, -1.44mm), radius=0.15mm, height=1.68mm)
  V115_DCN = cylinder(axis=Z, base_centre=(-42.15mm, 14.8mm, -1.44mm), radius=0.15mm, height=1.68mm)
  V116_DCN = cylinder(axis=Z, base_centre=(36.15mm, 19.75mm, -1.44mm), radius=0.15mm, height=1.68mm)
  V117_DCN = cylinder(axis=Z, base_centre=(-2.35mm, -0.5mm, -1.44mm), radius=0.15mm, height=1.68mm)
  V118_DCN = cylinder(axis=Z, base_centre=(-5.35mm, 13.4mm, -1.44mm), radius=0.15mm, height=1.68mm)
  V119_DCN = cylinder(axis=Z, base_centre=(30.15mm, 14.1mm, -1.44mm), radius=0.15mm, height=1.68mm)
  V120_DCN = cylinder(axis=Z, base_centre=(33.15mm, 19.75mm, -1.44mm), radius=0.15mm, height=1.68mm)
  V121_DCN = cylinder(axis=Z, base_centre=(-30.15mm, 19.75mm, -1.44mm), radius=0.15mm, height=1.68mm)
  V122_DCN = cylinder(axis=Z, base_centre=(-9.5346mm, -0.5mm, -1.44mm), radius=0.15mm, height=1.68mm)
  V123_DCN = cylinder(axis=Z, base_centre=(34.15mm, 13.4mm, -1.44mm), radius=0.15mm, height=1.68mm)
  V124_DCN = cylinder(axis=Z, base_centre=(38.15mm, 19.75mm, -1.44mm), radius=0.15mm, height=1.68mm)
  V125_DCN = cylinder(axis=Z, base_centre=(30.15mm, 19.75mm, -1.44mm), radius=0.15mm, height=1.68mm)
  V126_DCN = cylinder(axis=Z, base_centre=(-30.15mm, 15.5mm, -1.44mm), radius=0.15mm, height=1.68mm)
  V127_DCN = cylinder(axis=Z, base_centre=(31.15mm, 19.75mm, -1.44mm), radius=0.15mm, height=1.68mm)
  V128_DCN = cylinder(axis=Z, base_centre=(-34.4115mm, -0.5mm, -1.44mm), radius=0.15mm, height=1.68mm)
  V129_DCN = cylinder(axis=Z, base_centre=(-5.95mm, -0.5mm, -1.44mm), radius=0.15mm, height=1.68mm)
  V130_DCN = cylinder(axis=Z, base_centre=(14.35mm, 19mm, -1.44mm), radius=0.15mm, height=1.68mm)
  V131_DCN = cylinder(axis=Z, base_centre=(-9.35mm, 19.75mm, -1.44mm), radius=0.15mm, height=1.68mm)
  V132_DCN = cylinder(axis=Z, base_centre=(-33.15mm, 19.75mm, -1.44mm), radius=0.15mm, height=1.68mm)
  V133_DCN = cylinder(axis=Z, base_centre=(3.65mm, -0.5mm, -1.44mm), radius=0.15mm, height=1.68mm)
  V134_DCN = cylinder(axis=Z, base_centre=(32.15mm, 19mm, -1.44mm), radius=0.15mm, height=1.68mm)
  V135_DCN = cylinder(axis=Z, base_centre=(-14.35mm, 19.75mm, -1.44mm), radius=0.15mm, height=1.68mm)
  V136_DCN = cylinder(axis=Z, base_centre=(16.6423mm, -0.5mm, -1.44mm), radius=0.15mm, height=1.68mm)
  V137_DCN = cylinder(axis=Z, base_centre=(17.35mm, 13.4mm, -1.44mm), radius=0.15mm, height=1.68mm)
  V138_DCN = cylinder(axis=Z, base_centre=(-42.15mm, 19mm, -1.44mm), radius=0.15mm, height=1.68mm)
  V139_DCN = cylinder(axis=Z, base_centre=(43.15mm, 19.75mm, -1.44mm), radius=0.15mm, height=1.68mm)
  V140_DCN = cylinder(axis=Z, base_centre=(-29.6731mm, -0.5mm, -1.44mm), radius=0.15mm, height=1.68mm)
  V141_DCN = cylinder(axis=Z, base_centre=(-15.35mm, 19mm, -1.44mm), radius=0.15mm, height=1.68mm)
  V142_DCN = cylinder(axis=Z, base_centre=(-4.35mm, 14.1mm, -1.44mm), radius=0.15mm, height=1.68mm)
  V143_DCN = cylinder(axis=Z, base_centre=(-32.15mm, 13.4mm, -1.44mm), radius=0.15mm, height=1.68mm)
  V144_DCN = cylinder(axis=Z, base_centre=(-7.35mm, 13.4mm, -1.44mm), radius=0.15mm, height=1.68mm)
  V145_DCN = cylinder(axis=Z, base_centre=(-4.75mm, -0.5mm, -1.44mm), radius=0.15mm, height=1.68mm)
  V146_DCN = cylinder(axis=Z, base_centre=(38.15mm, 19mm, -1.44mm), radius=0.15mm, height=1.68mm)
  V147_DCN = cylinder(axis=Z, base_centre=(7.35mm, 19.75mm, -1.44mm), radius=0.15mm, height=1.68mm)
  V148_DCN = cylinder(axis=Z, base_centre=(40.15mm, 14.8mm, -1.44mm), radius=0.15mm, height=1.68mm)
  V149_DCN = cylinder(axis=Z, base_centre=(-39.15mm, 19.75mm, -1.44mm), radius=0.15mm, height=1.68mm)
  V150_DCN = cylinder(axis=Z, base_centre=(-38.15mm, 19mm, -1.44mm), radius=0.15mm, height=1.68mm)
  V151_DCN = cylinder(axis=Z, base_centre=(-26.1192mm, -0.5mm, -1.44mm), radius=0.15mm, height=1.68mm)
  V152_DCN = cylinder(axis=Z, base_centre=(8.35mm, 13.4mm, -1.44mm), radius=0.15mm, height=1.68mm)
  V153_DCN = cylinder(axis=Z, base_centre=(-31.15mm, 19mm, -1.44mm), radius=0.15mm, height=1.68mm)
  V154_DCN = cylinder(axis=Z, base_centre=(8.35mm, 15.5mm, -1.44mm), radius=0.15mm, height=1.68mm)
  V155_DCN = cylinder(axis=Z, base_centre=(12.35mm, 19mm, -1.44mm), radius=0.15mm, height=1.68mm)
  V156_DCN = cylinder(axis=Z, base_centre=(-13.35mm, 13.4mm, -1.44mm), radius=0.15mm, height=1.68mm)
  V157_DCN = cylinder(axis=Z, base_centre=(-43.15mm, 19.75mm, -1.44mm), radius=0.15mm, height=1.68mm)
  V158_DCN = cylinder(axis=Z, base_centre=(-4.35mm, 14.8mm, -1.44mm), radius=0.15mm, height=1.68mm)
  V159_DCN = cylinder(axis=Z, base_centre=(-16.6423mm, -0.5mm, -1.44mm), radius=0.15mm, height=1.68mm)
  V160_DCN = cylinder(axis=Z, base_centre=(-7.35mm, 19.75mm, -1.44mm), radius=0.15mm, height=1.68mm)
  V161_DCN = cylinder(axis=Z, base_centre=(-38.15mm, 19.75mm, -1.44mm), radius=0.15mm, height=1.68mm)
  V162_DCN = cylinder(axis=Z, base_centre=(-28.4885mm, -0.5mm, -1.44mm), radius=0.15mm, height=1.68mm)
  V163_DCN = cylinder(axis=Z, base_centre=(17.35mm, 14.8mm, -1.44mm), radius=0.15mm, height=1.68mm)
  V164_DCN = cylinder(axis=Z, base_centre=(28.4885mm, -0.5mm, -1.44mm), radius=0.15mm, height=1.68mm)
  V165_DCN = cylinder(axis=Z, base_centre=(32.15mm, 14.1mm, -1.44mm), radius=0.15mm, height=1.68mm)
  V166_DCN = cylinder(axis=Z, base_centre=(4.35mm, 15.5mm, -1.44mm), radius=0.15mm, height=1.68mm)
  V167_DCN = cylinder(axis=Z, base_centre=(-41.15mm, 13.4mm, -1.44mm), radius=0.15mm, height=1.68mm)
  V168_DCN = cylinder(axis=Z, base_centre=(30.15mm, 15.5mm, -1.44mm), radius=0.15mm, height=1.68mm)
  V169_DCN = cylinder(axis=Z, base_centre=(23.75mm, -0.5mm, -1.44mm), radius=0.15mm, height=1.68mm)
  V170_DCN = cylinder(axis=Z, base_centre=(17.35mm, 14.1mm, -1.44mm), radius=0.15mm, height=1.68mm)
  V171_DCN = cylinder(axis=Z, base_centre=(29.15mm, 14.8mm, -1.44mm), radius=0.15mm, height=1.68mm)
  V172_DCN = cylinder(axis=Z, base_centre=(11.9038mm, -0.5mm, -1.44mm), radius=0.15mm, height=1.68mm)
  V173_DCN = cylinder(axis=Z, base_centre=(9.5346mm, -0.5mm, -1.44mm), radius=0.15mm, height=1.68mm)
  V174_DCN = cylinder(axis=Z, base_centre=(-20.1962mm, -0.5mm, -1.44mm), radius=0.15mm, height=1.68mm)
  V175_DCN = cylinder(axis=Z, base_centre=(-17.35mm, 14.1mm, -1.44mm), radius=0.15mm, height=1.68mm)
  V176_DCN = cylinder(axis=Z, base_centre=(-5.35mm, 15.5mm, -1.44mm), radius=0.15mm, height=1.68mm)
  V177_DCN = cylinder(axis=Z, base_centre=(12.35mm, 13.4mm, -1.44mm), radius=0.15mm, height=1.68mm)
  V178_DCN = cylinder(axis=Z, base_centre=(1.25mm, -0.5mm, -1.44mm), radius=0.15mm, height=1.68mm)
  V179_DCN = cylinder(axis=Z, base_centre=(13.35mm, 19mm, -1.44mm), radius=0.15mm, height=1.68mm)
  V180_DCN = cylinder(axis=Z, base_centre=(15.35mm, 14.1mm, -1.44mm), radius=0.15mm, height=1.68mm)
  V181_DCN = cylinder(axis=Z, base_centre=(37.9654mm, -0.5mm, -1.44mm), radius=0.15mm, height=1.68mm)
  V182_DCN = cylinder(axis=Z, base_centre=(30.8577mm, -0.5mm, -1.44mm), radius=0.15mm, height=1.68mm)
  V183_DCN = cylinder(axis=Z, base_centre=(40.15mm, 14.1mm, -1.44mm), radius=0.15mm, height=1.68mm)
  V184_DCN = cylinder(axis=Z, base_centre=(-32.0423mm, -0.5mm, -1.44mm), radius=0.15mm, height=1.68mm)
  V185_DCN = cylinder(axis=Z, base_centre=(14.35mm, 13.4mm, -1.44mm), radius=0.15mm, height=1.68mm)
  V186_DCN = cylinder(axis=Z, base_centre=(-14.2731mm, -0.5mm, -1.44mm), radius=0.15mm, height=1.68mm)
  V187_DCN = cylinder(axis=Z, base_centre=(-17.8269mm, -0.5mm, -1.44mm), radius=0.15mm, height=1.68mm)
  V188_DCN = cylinder(axis=Z, base_centre=(14.2731mm, -0.5mm, -1.44mm), radius=0.15mm, height=1.68mm)
  V189_DCN = cylinder(axis=Z, base_centre=(10.35mm, 19mm, -1.44mm), radius=0.15mm, height=1.68mm)
  V190_DCN = cylinder(axis=Z, base_centre=(-42.15mm, 19.75mm, -1.44mm), radius=0.15mm, height=1.68mm)
  V191_DCN = cylinder(axis=Z, base_centre=(-7.15mm, -0.5mm, -1.44mm), radius=0.15mm, height=1.68mm)
  V192_DCN = cylinder(axis=Z, base_centre=(16.35mm, 14.1mm, -1.44mm), radius=0.15mm, height=1.68mm)
  V193_DCN = cylinder(axis=Z, base_centre=(-34.15mm, 19.75mm, -1.44mm), radius=0.15mm, height=1.68mm)
  V194_DCN = cylinder(axis=Z, base_centre=(27.3038mm, -0.5mm, -1.44mm), radius=0.15mm, height=1.68mm)
  V195_DCN = cylinder(axis=Z, base_centre=(-16.35mm, 19mm, -1.44mm), radius=0.15mm, height=1.68mm)
  V196_DCN = cylinder(axis=Z, base_centre=(14.35mm, 19.75mm, -1.44mm), radius=0.15mm, height=1.68mm)
  V197_DCN = cylinder(axis=Z, base_centre=(-41.15mm, 14.8mm, -1.44mm), radius=0.15mm, height=1.68mm)
  V198_DCN = cylinder(axis=Z, base_centre=(-32.15mm, 19.75mm, -1.44mm), radius=0.15mm, height=1.68mm)
  V199_DCN = cylinder(axis=Z, base_centre=(29.15mm, 14.1mm, -1.44mm), radius=0.15mm, height=1.68mm)
  V200_DCN = cylinder(axis=Z, base_centre=(39.15mm, 15.5mm, -1.44mm), radius=0.15mm, height=1.68mm)
  V201_DCN = cylinder(axis=Z, base_centre=(-30.15mm, 14.1mm, -1.44mm), radius=0.15mm, height=1.68mm)
  V202_DCN = cylinder(axis=Z, base_centre=(-4.35mm, 15.5mm, -1.44mm), radius=0.15mm, height=1.68mm)
  V203_DCN = cylinder(axis=Z, base_centre=(10.35mm, 19.75mm, -1.44mm), radius=0.15mm, height=1.68mm)
  V204_DCN = cylinder(axis=Z, base_centre=(-24.9346mm, -0.5mm, -1.44mm), radius=0.15mm, height=1.68mm)
  V205_DCN = cylinder(axis=Z, base_centre=(-5.35mm, 19.75mm, -1.44mm), radius=0.15mm, height=1.68mm)
  V206_DCN = cylinder(axis=Z, base_centre=(-37.9654mm, -0.5mm, -1.44mm), radius=0.15mm, height=1.68mm)
  V207_DCN = cylinder(axis=Z, base_centre=(4.85mm, -0.5mm, -1.44mm), radius=0.15mm, height=1.68mm)
  V208_DCN = cylinder(axis=Z, base_centre=(40.15mm, 19.75mm, -1.44mm), radius=0.15mm, height=1.68mm)
  V209_DCN = cylinder(axis=Z, base_centre=(31.15mm, 14.1mm, -1.44mm), radius=0.15mm, height=1.68mm)
  V210_DCN = cylinder(axis=Z, base_centre=(-39.15mm, -0.5mm, -1.44mm), radius=0.15mm, height=1.68mm)
  V211_DCN = cylinder(axis=Z, base_centre=(19.0115mm, -0.5mm, -1.44mm), radius=0.15mm, height=1.68mm)
  V212_DCN = cylinder(axis=Z, base_centre=(-5.35mm, 14.1mm, -1.44mm), radius=0.15mm, height=1.68mm)
  V213_DCN = cylinder(axis=Z, base_centre=(17.35mm, 15.5mm, -1.44mm), radius=0.15mm, height=1.68mm)
  V214_DCN = cylinder(axis=Z, base_centre=(-18.35mm, 14.8mm, -1.44mm), radius=0.15mm, height=1.68mm)
  V215_DCN = cylinder(axis=Z, base_centre=(-17.35mm, 19mm, -1.44mm), radius=0.15mm, height=1.68mm)
  V216_DCN = cylinder(axis=Z, base_centre=(-16.35mm, 14.8mm, -1.44mm), radius=0.15mm, height=1.68mm)
  V217_DCN = cylinder(axis=Z, base_centre=(-39.15mm, 13.4mm, -1.44mm), radius=0.15mm, height=1.68mm)
  V218_DCN = cylinder(axis=Z, base_centre=(22.5654mm, -0.5mm, -1.44mm), radius=0.15mm, height=1.68mm)
  V219_DCN = cylinder(axis=Z, base_centre=(4.35mm, 19.75mm, -1.44mm), radius=0.15mm, height=1.68mm)
  V220_DCN = cylinder(axis=Z, base_centre=(-30.15mm, 13.4mm, -1.44mm), radius=0.15mm, height=1.68mm)
  V221_DCN = cylinder(axis=Z, base_centre=(-14.35mm, 13.4mm, -1.44mm), radius=0.15mm, height=1.68mm)
  V222_DCN = cylinder(axis=Z, base_centre=(-6.35mm, 14.8mm, -1.44mm), radius=0.15mm, height=1.68mm)
  V223_DCN = cylinder(axis=Z, base_centre=(-37.15mm, 19mm, -1.44mm), radius=0.15mm, height=1.68mm)
  V224_DCN = cylinder(axis=Z, base_centre=(35.15mm, 19mm, -1.44mm), radius=0.15mm, height=1.68mm)
  V225_DCN = cylinder(axis=Z, base_centre=(-31.15mm, 15.5mm, -1.44mm), radius=0.15mm, height=1.68mm)
  V226_DCN = cylinder(axis=Z, base_centre=(2.45mm, -0.5mm, -1.44mm), radius=0.15mm, height=1.68mm)
  V227_DCN = cylinder(axis=Z, base_centre=(-40.15mm, 14.8mm, -1.44mm), radius=0.15mm, height=1.68mm)
  V228_DCN = cylinder(axis=Z, base_centre=(-11.35mm, 19.75mm, -1.44mm), radius=0.15mm, height=1.68mm)
  V229_DCN = cylinder(axis=Z, base_centre=(-8.35mm, -0.5mm, -1.44mm), radius=0.15mm, height=1.68mm)
  V230_DCN = cylinder(axis=Z, base_centre=(-10.7192mm, -0.5mm, -1.44mm), radius=0.15mm, height=1.68mm)
  V231_DCN = cylinder(axis=Z, base_centre=(-15.35mm, 14.1mm, -1.44mm), radius=0.15mm, height=1.68mm)
  V232_DCN = cylinder(axis=Z, base_centre=(-15.35mm, 19.75mm, -1.44mm), radius=0.15mm, height=1.68mm)
  V233_DCN = cylinder(axis=Z, base_centre=(8.35mm, 14.8mm, -1.44mm), radius=0.15mm, height=1.68mm)
  V234_DCN = cylinder(axis=Z, base_centre=(21.3808mm, -0.5mm, -1.44mm), radius=0.15mm, height=1.68mm)
  V235_DCN = cylinder(axis=Z, base_centre=(-4.35mm, 19.75mm, -1.44mm), radius=0.15mm, height=1.68mm)
  V236_DCN = cylinder(axis=Z, base_centre=(-41.15mm, 15.5mm, -1.44mm), radius=0.15mm, height=1.68mm)
  V237_DCN = cylinder(axis=Z, base_centre=(-12.35mm, 19mm, -1.44mm), radius=0.15mm, height=1.68mm)
  V238_DCN = cylinder(axis=Z, base_centre=(4.35mm, 13.4mm, -1.44mm), radius=0.15mm, height=1.68mm)
  V239_DCN = cylinder(axis=Z, base_centre=(39.15mm, 14.8mm, -1.44mm), radius=0.15mm, height=1.68mm)
  V240_DCN = cylinder(axis=Z, base_centre=(-42.15mm, 15.5mm, -1.44mm), radius=0.15mm, height=1.68mm)
  V241_DCN = cylinder(axis=Z, base_centre=(26.1192mm, -0.5mm, -1.44mm), radius=0.15mm, height=1.68mm)
  V242_DCN = cylinder(axis=Z, base_centre=(-8.35mm, 19mm, -1.44mm), radius=0.15mm, height=1.68mm)
  V243_DCN = cylinder(axis=Z, base_centre=(30.15mm, 13.4mm, -1.44mm), radius=0.15mm, height=1.68mm)
  V244_DCN = cylinder(axis=Z, base_centre=(9.35mm, 19mm, -1.44mm), radius=0.15mm, height=1.68mm)
  V245_DCN = cylinder(axis=Z, base_centre=(16.35mm, 19mm, -1.44mm), radius=0.15mm, height=1.68mm)
  V246_DCN = cylinder(axis=Z, base_centre=(29.15mm, 13.4mm, -1.44mm), radius=0.15mm, height=1.68mm)
  V247_DCN = cylinder(axis=Z, base_centre=(-10.35mm, 19.75mm, -1.44mm), radius=0.15mm, height=1.68mm)
  V248_DCN = cylinder(axis=Z, base_centre=(7mm, 4mm, -1.44mm), radius=0.15mm, height=1.68mm)
  V249_DCN = cylinder(axis=Z, base_centre=(-32.15mm, 14.1mm, -1.44mm), radius=0.15mm, height=1.68mm)
  V250_DCN = cylinder(axis=Z, base_centre=(-35.15mm, 19mm, -1.44mm), radius=0.15mm, height=1.68mm)
  V251_DCN = cylinder(axis=Z, base_centre=(-39.15mm, 14.8mm, -1.44mm), radius=0.15mm, height=1.68mm)
  V252_DCN = cylinder(axis=Z, base_centre=(17.35mm, 19.75mm, -1.44mm), radius=0.15mm, height=1.68mm)
  V253_DCN = cylinder(axis=Z, base_centre=(-3.55mm, -0.5mm, -1.44mm), radius=0.15mm, height=1.68mm)
  V254_DCN = cylinder(axis=Z, base_centre=(9.35mm, 19.75mm, -1.44mm), radius=0.15mm, height=1.68mm)
  V255_DCN = cylinder(axis=Z, base_centre=(24.9346mm, -0.5mm, -1.44mm), radius=0.15mm, height=1.68mm)
  V256_DCN = cylinder(axis=Z, base_centre=(43.15mm, 15.5mm, -1.44mm), radius=0.15mm, height=1.68mm)
  V257_DCN = cylinder(axis=Z, base_centre=(15.35mm, 19mm, -1.44mm), radius=0.15mm, height=1.68mm)
  V258_DCN = cylinder(axis=Z, base_centre=(39.15mm, 19.75mm, -1.44mm), radius=0.15mm, height=1.68mm)
  V259_DCN = cylinder(axis=Z, base_centre=(-39.15mm, 15.5mm, -1.44mm), radius=0.15mm, height=1.68mm)
  V260_DCN = cylinder(axis=Z, base_centre=(-31.15mm, 13.4mm, -1.44mm), radius=0.15mm, height=1.68mm)
  V261_DCN = cylinder(axis=Z, base_centre=(12.35mm, 19.75mm, -1.44mm), radius=0.15mm, height=1.68mm)
  V262_DCN = cylinder(axis=Z, base_centre=(13.0885mm, -0.5mm, -1.44mm), radius=0.15mm, height=1.68mm)
  V263_DCN = cylinder(axis=Z, base_centre=(7.35mm, 13.4mm, -1.44mm), radius=0.15mm, height=1.68mm)
  V264_DCN = cylinder(axis=Z, base_centre=(32.15mm, 13.4mm, -1.44mm), radius=0.15mm, height=1.68mm)
  V265_DCN = cylinder(axis=Z, base_centre=(-40.15mm, 13.4mm, -1.44mm), radius=0.15mm, height=1.68mm)
  V266_DCN = cylinder(axis=Z, base_centre=(40.15mm, 13.4mm, -1.44mm), radius=0.15mm, height=1.68mm)
  V267_DCN = cylinder(axis=Z, base_centre=(-40.15mm, 14.1mm, -1.44mm), radius=0.15mm, height=1.68mm)
  V268_DCN = cylinder(axis=Z, base_centre=(-37.15mm, 19.75mm, -1.44mm), radius=0.15mm, height=1.68mm)
  V269_DCN = cylinder(axis=Z, base_centre=(-15.35mm, 13.4mm, -1.44mm), radius=0.15mm, height=1.68mm)
  V270_DCN = cylinder(axis=Z, base_centre=(-43.15mm, 15.5mm, -1.44mm), radius=0.15mm, height=1.68mm)
  V271_DCN = cylinder(axis=Z, base_centre=(-17.35mm, 13.4mm, -1.44mm), radius=0.15mm, height=1.68mm)
  V272_DCN = cylinder(axis=Z, base_centre=(-36.15mm, 19.75mm, -1.44mm), radius=0.15mm, height=1.68mm)
  V273_DCN = cylinder(axis=Z, base_centre=(36.15mm, 19mm, -1.44mm), radius=0.15mm, height=1.68mm)
  V274_DCN = cylinder(axis=Z, base_centre=(6.05mm, -0.5mm, -1.44mm), radius=0.15mm, height=1.68mm)
  V275_DCN = cylinder(axis=Z, base_centre=(-8.35mm, 14.8mm, -1.44mm), radius=0.15mm, height=1.68mm)
  V276_DCN = cylinder(axis=Z, base_centre=(-17.35mm, 19.75mm, -1.44mm), radius=0.15mm, height=1.68mm)
  V277_DCN = cylinder(axis=Z, base_centre=(-7.35mm, 19mm, -1.44mm), radius=0.15mm, height=1.68mm)
  V278_DCN = cylinder(axis=Z, base_centre=(40.15mm, 19mm, -1.44mm), radius=0.15mm, height=1.68mm)
  V279_DCN = cylinder(axis=Z, base_centre=(17.35mm, 19mm, -1.44mm), radius=0.15mm, height=1.68mm)
  V280_DCN = cylinder(axis=Z, base_centre=(39.15mm, -0.5mm, -1.44mm), radius=0.15mm, height=1.68mm)
  V281_DCN = cylinder(axis=Z, base_centre=(31.15mm, 14.8mm, -1.44mm), radius=0.15mm, height=1.68mm)
  V282_DCN = cylinder(axis=Z, base_centre=(-42.15mm, 14.1mm, -1.44mm), radius=0.15mm, height=1.68mm)
  V283_DCN = cylinder(axis=Z, base_centre=(-17.35mm, 14.8mm, -1.44mm), radius=0.15mm, height=1.68mm)
  V284_DCN = cylinder(axis=Z, base_centre=(4.35mm, 14.1mm, -1.44mm), radius=0.15mm, height=1.68mm)
  V285_DCN = cylinder(axis=Z, base_centre=(-4.35mm, 13.4mm, -1.44mm), radius=0.15mm, height=1.68mm)
  V286_DCN = cylinder(axis=Z, base_centre=(20.1962mm, -0.5mm, -1.44mm), radius=0.15mm, height=1.68mm)
  V287_DCN = cylinder(axis=Z, base_centre=(-41.15mm, 19.75mm, -1.44mm), radius=0.15mm, height=1.68mm)
  V288_DCN = cylinder(axis=Z, base_centre=(8.35mm, 19mm, -1.44mm), radius=0.15mm, height=1.68mm)
  V289_DCN = cylinder(axis=Z, base_centre=(-43.15mm, 14.1mm, -1.44mm), radius=0.15mm, height=1.68mm)
  V290_DCN = cylinder(axis=Z, base_centre=(-36.15mm, 19mm, -1.44mm), radius=0.15mm, height=1.68mm)
  V291_DCN = cylinder(axis=Z, base_centre=(-9.35mm, 19mm, -1.44mm), radius=0.15mm, height=1.68mm)
  V292_DCN = cylinder(axis=Z, base_centre=(-36.7808mm, -0.5mm, -1.44mm), radius=0.15mm, height=1.68mm)
  V293_DCN = cylinder(axis=Z, base_centre=(7.35mm, 14.1mm, -1.44mm), radius=0.15mm, height=1.68mm)
  V294_DCN = cylinder(axis=Z, base_centre=(13.35mm, 13.4mm, -1.44mm), radius=0.15mm, height=1.68mm)
  V295_DCN = cylinder(axis=Z, base_centre=(11.35mm, 19.75mm, -1.44mm), radius=0.15mm, height=1.68mm)
  V296_DCN = cylinder(axis=Z, base_centre=(30.15mm, 14.8mm, -1.44mm), radius=0.15mm, height=1.68mm)
  V297_DCN = cylinder(axis=Z, base_centre=(8.35mm, -0.5mm, -1.44mm), radius=0.15mm, height=1.68mm)
  V298_DCN = cylinder(axis=Z, base_centre=(-31.15mm, 14.1mm, -1.44mm), radius=0.15mm, height=1.68mm)
  V299_DCN = cylinder(axis=Z, base_centre=(-40.15mm, 19.75mm, -1.44mm), radius=0.15mm, height=1.68mm)
  V300_DCN = cylinder(axis=Z, base_centre=(10.7192mm, -0.5mm, -1.44mm), radius=0.15mm, height=1.68mm)
  V301_DCN = cylinder(axis=Z, base_centre=(-8.35mm, 19.75mm, -1.44mm), radius=0.15mm, height=1.68mm)
  V302_DCN = cylinder(axis=Z, base_centre=(-43.15mm, 14.8mm, -1.44mm), radius=0.15mm, height=1.68mm)
  V303_DCN = cylinder(axis=Z, base_centre=(34.15mm, 19mm, -1.44mm), radius=0.15mm, height=1.68mm)
  V304_DCN = cylinder(axis=Z, base_centre=(-33.15mm, 19mm, -1.44mm), radius=0.15mm, height=1.68mm)
  V305_DCN = cylinder(axis=Z, base_centre=(16.35mm, 13.4mm, -1.44mm), radius=0.15mm, height=1.68mm)
  V306_DCN = cylinder(axis=Z, base_centre=(43.15mm, 14.8mm, -1.44mm), radius=0.15mm, height=1.68mm)
  V307_DCN = cylinder(axis=Z, base_centre=(-34.15mm, 13.4mm, -1.44mm), radius=0.15mm, height=1.68mm)
  V308_DCN = cylinder(axis=Z, base_centre=(-6.35mm, 19mm, -1.44mm), radius=0.15mm, height=1.68mm)
  V309_DCN = cylinder(axis=Z, base_centre=(-33.2269mm, -0.5mm, -1.44mm), radius=0.15mm, height=1.68mm)
  V310_DCN = cylinder(axis=Z, base_centre=(37.15mm, 19.75mm, -1.44mm), radius=0.15mm, height=1.68mm)
  V311_DCN = cylinder(axis=Z, base_centre=(-38.15mm, 14.8mm, -1.44mm), radius=0.15mm, height=1.68mm)
  V312_DCN = cylinder(axis=Z, base_centre=(-40.15mm, 19mm, -1.44mm), radius=0.15mm, height=1.68mm)
  V313_DCN = cylinder(axis=Z, base_centre=(-31.15mm, 19.75mm, -1.44mm), radius=0.15mm, height=1.68mm)
  V314_DCN = cylinder(axis=Z, base_centre=(-9.35mm, 14.8mm, -1.44mm), radius=0.15mm, height=1.68mm)
  V315_DCN = cylinder(axis=Z, base_centre=(39.15mm, 14.1mm, -1.44mm), radius=0.15mm, height=1.68mm)
  V316_DCN = cylinder(axis=Z, base_centre=(-35.15mm, 13.4mm, -1.44mm), radius=0.15mm, height=1.68mm)
  V317_DCN = cylinder(axis=Z, base_centre=(-30.8577mm, -0.5mm, -1.44mm), radius=0.15mm, height=1.68mm)
  V318_DCN = cylinder(axis=Z, base_centre=(43.15mm, 19mm, -1.44mm), radius=0.15mm, height=1.68mm)
  V319_DCN = cylinder(axis=Z, base_centre=(38.15mm, 14.8mm, -1.44mm), radius=0.15mm, height=1.68mm)
  V320_DCN = cylinder(axis=Z, base_centre=(35.15mm, 13.4mm, -1.44mm), radius=0.15mm, height=1.68mm)
  V321_DCN = cylinder(axis=Z, base_centre=(-43.15mm, 19mm, -1.44mm), radius=0.15mm, height=1.68mm)
  V322_DCN = cylinder(axis=Z, base_centre=(-39.15mm, 14.1mm, -1.44mm), radius=0.15mm, height=1.68mm)
  V323_DCN = cylinder(axis=Z, base_centre=(7.35mm, 15.5mm, -1.44mm), radius=0.15mm, height=1.68mm)
  V324_DCN = cylinder(axis=Z, base_centre=(-8.35mm, 15.5mm, -1.44mm), radius=0.15mm, height=1.68mm)
  V325_DCN = cylinder(axis=Z, base_centre=(37.15mm, 19mm, -1.44mm), radius=0.15mm, height=1.68mm)
  V326_DCN = cylinder(axis=Z, base_centre=(39.15mm, 13.4mm, -1.44mm), radius=0.15mm, height=1.68mm)
  V327_DCN = cylinder(axis=Z, base_centre=(-31.15mm, 14.8mm, -1.44mm), radius=0.15mm, height=1.68mm)
  V328_DCN = cylinder(axis=Z, base_centre=(-13.35mm, 19mm, -1.44mm), radius=0.15mm, height=1.68mm)
  V329_DCN = cylinder(axis=Z, base_centre=(-39.15mm, 19mm, -1.44mm), radius=0.15mm, height=1.68mm)
  V330_DCN = cylinder(axis=Z, base_centre=(-1.15mm, -0.5mm, -1.44mm), radius=0.15mm, height=1.68mm)
  V331_AC = cylinder(axis=Z, base_centre=(-43.05mm, 26.4mm, -1.44mm), radius=0.15mm, height=1.68mm)
  V332_AC = cylinder(axis=Z, base_centre=(-6.05mm, 26.4mm, -1.44mm), radius=0.15mm, height=1.68mm)
  V333_AC = cylinder(axis=Z, base_centre=(-41.85mm, 24mm, -1.44mm), radius=0.15mm, height=1.68mm)
  V334_AC = cylinder(axis=Z, base_centre=(-6.05mm, 24mm, -1.44mm), radius=0.15mm, height=1.68mm)
  V335_AC = cylinder(axis=Z, base_centre=(-40.65mm, 26.4mm, -1.44mm), radius=0.15mm, height=1.68mm)
  V336_AC = cylinder(axis=Z, base_centre=(-39.45mm, 27.6mm, -1.44mm), radius=0.15mm, height=1.68mm)
  V337_AC = cylinder(axis=Z, base_centre=(-43.05mm, 24mm, -1.44mm), radius=0.15mm, height=1.68mm)
  V338_AC = cylinder(axis=Z, base_centre=(-40.65mm, 27.6mm, -1.44mm), radius=0.15mm, height=1.68mm)
  V339_AC = cylinder(axis=Z, base_centre=(-39.45mm, 21.6mm, -1.44mm), radius=0.15mm, height=1.68mm)
  V340_AC = cylinder(axis=Z, base_centre=(9.25mm, 30mm, -1.44mm), radius=0.15mm, height=1.68mm)
  V341_AC = cylinder(axis=Z, base_centre=(-7.25mm, 27.6mm, -1.44mm), radius=0.15mm, height=1.68mm)
  V342_AC = cylinder(axis=Z, base_centre=(9.25mm, 27.6mm, -1.44mm), radius=0.15mm, height=1.68mm)
  V343_AC = cylinder(axis=Z, base_centre=(40.25mm, 30mm, -1.44mm), radius=0.15mm, height=1.68mm)
  V344_AC = cylinder(axis=Z, base_centre=(-40.65mm, 25.2mm, -1.44mm), radius=0.15mm, height=1.68mm)
  V345_AC = cylinder(axis=Z, base_centre=(-7.25mm, 26.4mm, -1.44mm), radius=0.15mm, height=1.68mm)
  V346_AC = cylinder(axis=Z, base_centre=(6.85mm, 24mm, -1.44mm), radius=0.15mm, height=1.68mm)
  V347_AC = cylinder(axis=Z, base_centre=(-39.45mm, 26.4mm, -1.44mm), radius=0.15mm, height=1.68mm)
  V348_AC = cylinder(axis=Z, base_centre=(42.65mm, 27.6mm, -1.44mm), radius=0.15mm, height=1.68mm)
  V349_AC = cylinder(axis=Z, base_centre=(41.45mm, 28.8mm, -1.44mm), radius=0.15mm, height=1.68mm)
  V350_AC = cylinder(axis=Z, base_centre=(39.05mm, 30mm, -1.44mm), radius=0.15mm, height=1.68mm)
  V351_AC = cylinder(axis=Z, base_centre=(-39.45mm, 25.2mm, -1.44mm), radius=0.15mm, height=1.68mm)
  V352_AC = cylinder(axis=Z, base_centre=(8.05mm, 28.8mm, -1.44mm), radius=0.15mm, height=1.68mm)
  V353_AC = cylinder(axis=Z, base_centre=(40.25mm, 26.4mm, -1.44mm), radius=0.15mm, height=1.68mm)
  V354_AC = cylinder(axis=Z, base_centre=(42.65mm, 22.8mm, -1.44mm), radius=0.15mm, height=1.68mm)
  V355_AC = cylinder(axis=Z, base_centre=(6.85mm, 21.6mm, -1.44mm), radius=0.15mm, height=1.68mm)
  V356_AC = cylinder(axis=Z, base_centre=(-38.25mm, 30mm, -1.44mm), radius=0.15mm, height=1.68mm)
  V357_AC = cylinder(axis=Z, base_centre=(40.25mm, 28.8mm, -1.44mm), radius=0.15mm, height=1.68mm)
  V358_AC = cylinder(axis=Z, base_centre=(-6.05mm, 25.2mm, -1.44mm), radius=0.15mm, height=1.68mm)
  V359_AC = cylinder(axis=Z, base_centre=(42.65mm, 24mm, -1.44mm), radius=0.15mm, height=1.68mm)
  V360_AC = cylinder(axis=Z, base_centre=(-41.85mm, 30mm, -1.44mm), radius=0.15mm, height=1.68mm)
  V361_AC = cylinder(axis=Z, base_centre=(-39.45mm, 28.8mm, -1.44mm), radius=0.15mm, height=1.68mm)
  V362_AC = cylinder(axis=Z, base_centre=(6.85mm, 25.2mm, -1.44mm), radius=0.15mm, height=1.68mm)
  V363_AC = cylinder(axis=Z, base_centre=(5.65mm, 28.8mm, -1.44mm), radius=0.15mm, height=1.68mm)
  V364_AC = cylinder(axis=Z, base_centre=(8.05mm, 22.8mm, -1.44mm), radius=0.15mm, height=1.68mm)
  V365_AC = cylinder(axis=Z, base_centre=(6.85mm, 22.8mm, -1.44mm), radius=0.15mm, height=1.68mm)
  V366_AC = cylinder(axis=Z, base_centre=(40.25mm, 21.6mm, -1.44mm), radius=0.15mm, height=1.68mm)
  V367_AC = cylinder(axis=Z, base_centre=(-6.05mm, 22.8mm, -1.44mm), radius=0.15mm, height=1.68mm)
  V368_AC = cylinder(axis=Z, base_centre=(-7.25mm, 24mm, -1.44mm), radius=0.15mm, height=1.68mm)
  V369_AC = cylinder(axis=Z, base_centre=(6.85mm, 27.6mm, -1.44mm), radius=0.15mm, height=1.68mm)
  V370_AC = cylinder(axis=Z, base_centre=(-4.85mm, 30mm, -1.44mm), radius=0.15mm, height=1.68mm)
  V371_AC = cylinder(axis=Z, base_centre=(9.25mm, 28.8mm, -1.44mm), radius=0.15mm, height=1.68mm)
  V372_AC = cylinder(axis=Z, base_centre=(-7.25mm, 28.8mm, -1.44mm), radius=0.15mm, height=1.68mm)
  V373_AC = cylinder(axis=Z, base_centre=(6.85mm, 26.4mm, -1.44mm), radius=0.15mm, height=1.68mm)
  V374_AC = cylinder(axis=Z, base_centre=(-43.05mm, 25.2mm, -1.44mm), radius=0.15mm, height=1.68mm)
  V375_AC = cylinder(axis=Z, base_centre=(-41.85mm, 25.2mm, -1.44mm), radius=0.15mm, height=1.68mm)
  V376_AC = cylinder(axis=Z, base_centre=(42.65mm, 28.8mm, -1.44mm), radius=0.15mm, height=1.68mm)
  V377_AC = cylinder(axis=Z, base_centre=(42.65mm, 25.2mm, -1.44mm), radius=0.15mm, height=1.68mm)
  V378_AC = cylinder(axis=Z, base_centre=(-7.25mm, 21.6mm, -1.44mm), radius=0.15mm, height=1.68mm)
  V379_AC = cylinder(axis=Z, base_centre=(-8.45mm, 25.2mm, -1.44mm), radius=0.15mm, height=1.68mm)
  V380_AC = cylinder(axis=Z, base_centre=(37.85mm, 28.8mm, -1.44mm), radius=0.15mm, height=1.68mm)
  V381_AC = cylinder(axis=Z, base_centre=(-41.85mm, 26.4mm, -1.44mm), radius=0.15mm, height=1.68mm)
  V382_AC = cylinder(axis=Z, base_centre=(42.65mm, 26.4mm, -1.44mm), radius=0.15mm, height=1.68mm)
  V383_AC = cylinder(axis=Z, base_centre=(41.45mm, 26.4mm, -1.44mm), radius=0.15mm, height=1.68mm)
  V384_AC = cylinder(axis=Z, base_centre=(39.05mm, 28.8mm, -1.44mm), radius=0.15mm, height=1.68mm)
  V385_AC = cylinder(axis=Z, base_centre=(41.45mm, 27.6mm, -1.44mm), radius=0.15mm, height=1.68mm)
  V386_AC = cylinder(axis=Z, base_centre=(-38.25mm, 28.8mm, -1.44mm), radius=0.15mm, height=1.68mm)
  V387_AC = cylinder(axis=Z, base_centre=(39.05mm, 21.6mm, -1.44mm), radius=0.15mm, height=1.68mm)
  V388_AC = cylinder(axis=Z, base_centre=(-6.05mm, 30mm, -1.44mm), radius=0.15mm, height=1.68mm)
  V389_AC = cylinder(axis=Z, base_centre=(8.05mm, 24mm, -1.44mm), radius=0.15mm, height=1.68mm)
  V390_AC = cylinder(axis=Z, base_centre=(4.45mm, 22.8mm, -1.44mm), radius=0.15mm, height=1.68mm)
  V391_AC = cylinder(axis=Z, base_centre=(-8.45mm, 30mm, -1.44mm), radius=0.15mm, height=1.68mm)
  V392_AC = cylinder(axis=Z, base_centre=(5.65mm, 24mm, -1.44mm), radius=0.15mm, height=1.68mm)
  V393_AC = cylinder(axis=Z, base_centre=(-4.85mm, 22.8mm, -1.44mm), radius=0.15mm, height=1.68mm)
  V394_AC = cylinder(axis=Z, base_centre=(8.05mm, 30mm, -1.44mm), radius=0.15mm, height=1.68mm)
  V395_AC = cylinder(axis=Z, base_centre=(-7.25mm, 30mm, -1.44mm), radius=0.15mm, height=1.68mm)
  V396_AC = cylinder(axis=Z, base_centre=(4.45mm, 28.8mm, -1.44mm), radius=0.15mm, height=1.68mm)
  V397_AC = cylinder(axis=Z, base_centre=(40.25mm, 22.8mm, -1.44mm), radius=0.15mm, height=1.68mm)
  V398_AC = cylinder(axis=Z, base_centre=(41.45mm, 25.2mm, -1.44mm), radius=0.15mm, height=1.68mm)
  V399_AC = cylinder(axis=Z, base_centre=(8.05mm, 21.6mm, -1.44mm), radius=0.15mm, height=1.68mm)
  V400_AC = cylinder(axis=Z, base_centre=(-29.2mm, 7.05mm, -1.44mm), radius=0.15mm, height=1.68mm)
  V401_AC = cylinder(axis=Z, base_centre=(-8.45mm, 27.6mm, -1.44mm), radius=0.15mm, height=1.68mm)
  V402_AC = cylinder(axis=Z, base_centre=(-9.65mm, 26.4mm, -1.44mm), radius=0.15mm, height=1.68mm)
  V403_AC = cylinder(axis=Z, base_centre=(40.25mm, 24mm, -1.44mm), radius=0.15mm, height=1.68mm)
  V404_AC = cylinder(axis=Z, base_centre=(-4.85mm, 27.6mm, -1.44mm), radius=0.15mm, height=1.68mm)
  V405_AC = cylinder(axis=Z, base_centre=(8.05mm, 26.4mm, -1.44mm), radius=0.15mm, height=1.68mm)
  V406_AC = cylinder(axis=Z, base_centre=(-41.85mm, 28.8mm, -1.44mm), radius=0.15mm, height=1.68mm)
  V407_AC = cylinder(axis=Z, base_centre=(-4.85mm, 26.4mm, -1.44mm), radius=0.15mm, height=1.68mm)
  V408_AC = cylinder(axis=Z, base_centre=(5.65mm, 26.4mm, -1.44mm), radius=0.15mm, height=1.68mm)
  V409_AC = cylinder(axis=Z, base_centre=(-7.25mm, 22.8mm, -1.44mm), radius=0.15mm, height=1.68mm)
  V410_AC = cylinder(axis=Z, base_centre=(-43.05mm, 28.8mm, -1.44mm), radius=0.15mm, height=1.68mm)
  V411_AC = cylinder(axis=Z, base_centre=(-6.05mm, 27.6mm, -1.44mm), radius=0.15mm, height=1.68mm)
  V412_AC = cylinder(axis=Z, base_centre=(-40.65mm, 28.8mm, -1.44mm), radius=0.15mm, height=1.68mm)
  V413_AC = cylinder(axis=Z, base_centre=(-39.45mm, 22.8mm, -1.44mm), radius=0.15mm, height=1.68mm)
  V414_AC = cylinder(axis=Z, base_centre=(-9.65mm, 27.6mm, -1.44mm), radius=0.15mm, height=1.68mm)
  V415_AC = cylinder(axis=Z, base_centre=(-8.45mm, 24mm, -1.44mm), radius=0.15mm, height=1.68mm)
  V416_AC = cylinder(axis=Z, base_centre=(-9.65mm, 28.8mm, -1.44mm), radius=0.15mm, height=1.68mm)
  V417_AC = cylinder(axis=Z, base_centre=(4.45mm, 24mm, -1.44mm), radius=0.15mm, height=1.68mm)
  V418_AC = cylinder(axis=Z, base_centre=(-41.85mm, 21.6mm, -1.44mm), radius=0.15mm, height=1.68mm)
  V419_AC = cylinder(axis=Z, base_centre=(-8.45mm, 28.8mm, -1.44mm), radius=0.15mm, height=1.68mm)
  V420_AC = cylinder(axis=Z, base_centre=(6.85mm, 28.8mm, -1.44mm), radius=0.15mm, height=1.68mm)
  V421_AC = cylinder(axis=Z, base_centre=(41.45mm, 21.6mm, -1.44mm), radius=0.15mm, height=1.68mm)
  V422_AC = cylinder(axis=Z, base_centre=(5.65mm, 22.8mm, -1.44mm), radius=0.15mm, height=1.68mm)
  V423_AC = cylinder(axis=Z, base_centre=(4.45mm, 30mm, -1.44mm), radius=0.15mm, height=1.68mm)
  V424_AC = cylinder(axis=Z, base_centre=(-9.65mm, 30mm, -1.44mm), radius=0.15mm, height=1.68mm)
  V425_AC = cylinder(axis=Z, base_centre=(18.3mm, 7.05mm, -1.44mm), radius=0.15mm, height=1.68mm)
  V426_AC = cylinder(axis=Z, base_centre=(4.45mm, 26.4mm, -1.44mm), radius=0.15mm, height=1.68mm)
  V427_AC = cylinder(axis=Z, base_centre=(-40.65mm, 30mm, -1.44mm), radius=0.15mm, height=1.68mm)
  V428_AC = cylinder(axis=Z, base_centre=(-4.85mm, 21.6mm, -1.44mm), radius=0.15mm, height=1.68mm)
  V429_AC = cylinder(axis=Z, base_centre=(39.05mm, 24mm, -1.44mm), radius=0.15mm, height=1.68mm)
  V430_AC = cylinder(axis=Z, base_centre=(39.05mm, 26.4mm, -1.44mm), radius=0.15mm, height=1.68mm)
  V431_AC = cylinder(axis=Z, base_centre=(40.25mm, 27.6mm, -1.44mm), radius=0.15mm, height=1.68mm)
  V432_AC = cylinder(axis=Z, base_centre=(6.85mm, 30mm, -1.44mm), radius=0.15mm, height=1.68mm)
  V433_AC = cylinder(axis=Z, base_centre=(-38.25mm, 26.4mm, -1.44mm), radius=0.15mm, height=1.68mm)
  V434_AC = cylinder(axis=Z, base_centre=(8.05mm, 27.6mm, -1.44mm), radius=0.15mm, height=1.68mm)
  V435_AC = cylinder(axis=Z, base_centre=(-4.85mm, 28.8mm, -1.44mm), radius=0.15mm, height=1.68mm)
  V436_AC = cylinder(axis=Z, base_centre=(42.65mm, 21.6mm, -1.44mm), radius=0.15mm, height=1.68mm)
  V437_AC = cylinder(axis=Z, base_centre=(41.45mm, 30mm, -1.44mm), radius=0.15mm, height=1.68mm)
  V438_AC = cylinder(axis=Z, base_centre=(-38.25mm, 27.6mm, -1.44mm), radius=0.15mm, height=1.68mm)
  V439_AC = cylinder(axis=Z, base_centre=(29.2mm, 7.05mm, -1.44mm), radius=0.15mm, height=1.68mm)
  V440_AC = cylinder(axis=Z, base_centre=(5.65mm, 30mm, -1.44mm), radius=0.15mm, height=1.68mm)
  V441_AC = cylinder(axis=Z, base_centre=(-40.65mm, 24mm, -1.44mm), radius=0.15mm, height=1.68mm)
  V442_AC = cylinder(axis=Z, base_centre=(8.05mm, 25.2mm, -1.44mm), radius=0.15mm, height=1.68mm)
  V443_AC = cylinder(axis=Z, base_centre=(4.45mm, 25.2mm, -1.44mm), radius=0.15mm, height=1.68mm)
  V444_AC = cylinder(axis=Z, base_centre=(5.65mm, 27.6mm, -1.44mm), radius=0.15mm, height=1.68mm)
  V445_AC = cylinder(axis=Z, base_centre=(-6.05mm, 28.8mm, -1.44mm), radius=0.15mm, height=1.68mm)
  V446_AC = cylinder(axis=Z, base_centre=(-8.45mm, 26.4mm, -1.44mm), radius=0.15mm, height=1.68mm)
  V447_AC = cylinder(axis=Z, base_centre=(37.85mm, 26.4mm, -1.44mm), radius=0.15mm, height=1.68mm)
  V448_AC = cylinder(axis=Z, base_centre=(-8.45mm, 21.6mm, -1.44mm), radius=0.15mm, height=1.68mm)
  V449_AC = cylinder(axis=Z, base_centre=(37.85mm, 27.6mm, -1.44mm), radius=0.15mm, height=1.68mm)
  V450_AC = cylinder(axis=Z, base_centre=(-6.05mm, 21.6mm, -1.44mm), radius=0.15mm, height=1.68mm)
  V451_AC = cylinder(axis=Z, base_centre=(5.65mm, 25.2mm, -1.44mm), radius=0.15mm, height=1.68mm)
  V452_AC = cylinder(axis=Z, base_centre=(-7.25mm, 25.2mm, -1.44mm), radius=0.15mm, height=1.68mm)
  V453_AC = cylinder(axis=Z, base_centre=(-39.45mm, 24mm, -1.44mm), radius=0.15mm, height=1.68mm)
  V454_AC = cylinder(axis=Z, base_centre=(39.05mm, 27.6mm, -1.44mm), radius=0.15mm, height=1.68mm)
  V455_AC = cylinder(axis=Z, base_centre=(42.65mm, 30mm, -1.44mm), radius=0.15mm, height=1.68mm)
  V456_AC = cylinder(axis=Z, base_centre=(-4.85mm, 24mm, -1.44mm), radius=0.15mm, height=1.68mm)
  V457_AC = cylinder(axis=Z, base_centre=(39.05mm, 22.8mm, -1.44mm), radius=0.15mm, height=1.68mm)
  V458_AC = cylinder(axis=Z, base_centre=(41.45mm, 22.8mm, -1.44mm), radius=0.15mm, height=1.68mm)
  V459_AC = cylinder(axis=Z, base_centre=(-43.05mm, 21.6mm, -1.44mm), radius=0.15mm, height=1.68mm)
  V460_AC = cylinder(axis=Z, base_centre=(41.45mm, 24mm, -1.44mm), radius=0.15mm, height=1.68mm)
  V461_AC = cylinder(axis=Z, base_centre=(9.25mm, 26.4mm, -1.44mm), radius=0.15mm, height=1.68mm)
  V462_AC = cylinder(axis=Z, base_centre=(-40.65mm, 22.8mm, -1.44mm), radius=0.15mm, height=1.68mm)
  V463_AC = cylinder(axis=Z, base_centre=(-8.45mm, 22.8mm, -1.44mm), radius=0.15mm, height=1.68mm)
  V464_AC = cylinder(axis=Z, base_centre=(39.05mm, 25.2mm, -1.44mm), radius=0.15mm, height=1.68mm)
  V465_AC = cylinder(axis=Z, base_centre=(-41.85mm, 27.6mm, -1.44mm), radius=0.15mm, height=1.68mm)
  V466_AC = cylinder(axis=Z, base_centre=(37.85mm, 30mm, -1.44mm), radius=0.15mm, height=1.68mm)
  V467_AC = cylinder(axis=Z, base_centre=(-41.85mm, 22.8mm, -1.44mm), radius=0.15mm, height=1.68mm)
  V468_AC = cylinder(axis=Z, base_centre=(-40.65mm, 21.6mm, -1.44mm), radius=0.15mm, height=1.68mm)
  V469_AC = cylinder(axis=Z, base_centre=(-39.45mm, 30mm, -1.44mm), radius=0.15mm, height=1.68mm)
  V470_AC = cylinder(axis=Z, base_centre=(4.45mm, 27.6mm, -1.44mm), radius=0.15mm, height=1.68mm)
  V471_AC = cylinder(axis=Z, base_centre=(-43.05mm, 22.8mm, -1.44mm), radius=0.15mm, height=1.68mm)
  V472_AC = cylinder(axis=Z, base_centre=(-4.85mm, 25.2mm, -1.44mm), radius=0.15mm, height=1.68mm)
  V473_AC = cylinder(axis=Z, base_centre=(-43.05mm, 30mm, -1.44mm), radius=0.15mm, height=1.68mm)
  V474_AC = cylinder(axis=Z, base_centre=(40.25mm, 25.2mm, -1.44mm), radius=0.15mm, height=1.68mm)
  V475_AC = cylinder(axis=Z, base_centre=(-18.3mm, 7.05mm, -1.44mm), radius=0.15mm, height=1.68mm)
  V476_AC = cylinder(axis=Z, base_centre=(-43.05mm, 27.6mm, -1.44mm), radius=0.15mm, height=1.68mm)
  V477_LSRC1 = cylinder(axis=Z, base_centre=(-37.225mm, 11.8mm, -1.44mm), radius=0.15mm, height=1.68mm)
  V478_LSRC2 = cylinder(axis=Z, base_centre=(-10.275mm, 11.8mm, -1.44mm), radius=0.15mm, height=1.68mm)
  V479_LSRC3 = cylinder(axis=Z, base_centre=(10.275mm, 11.8mm, -1.44mm), radius=0.15mm, height=1.68mm)
  V480_LSRC4 = cylinder(axis=Z, base_centre=(37.225mm, 11.8mm, -1.44mm), radius=0.15mm, height=1.68mm)
  V481_AC = cylinder(axis=Z, base_centre=(6.85mm, 34.8mm, -1.44mm), radius=0.15mm, height=1.68mm)
  V482_AC = cylinder(axis=Z, base_centre=(-33.55mm, 44.8mm, -1.44mm), radius=0.15mm, height=1.68mm)
  V483_AC = cylinder(axis=Z, base_centre=(-43.05mm, 31.2mm, -1.44mm), radius=0.15mm, height=1.68mm)
  V484_AC = cylinder(axis=Z, base_centre=(-25.55mm, 43.2mm, -1.44mm), radius=0.15mm, height=1.68mm)
  V485_AC = cylinder(axis=Z, base_centre=(16.05mm, 40mm, -1.44mm), radius=0.15mm, height=1.68mm)
  V486_AC = cylinder(axis=Z, base_centre=(-9.55mm, 48mm, -1.44mm), radius=0.15mm, height=1.68mm)
  V487_AC = cylinder(axis=Z, base_centre=(-11.15mm, 48mm, -1.44mm), radius=0.15mm, height=1.68mm)
  V488_AC = cylinder(axis=Z, base_centre=(9.65mm, 44.8mm, -1.44mm), radius=0.15mm, height=1.68mm)
  V489_AC = cylinder(axis=Z, base_centre=(-4.75mm, 40mm, -1.44mm), radius=0.15mm, height=1.68mm)
  V490_AC = cylinder(axis=Z, base_centre=(27.25mm, 43.2mm, -1.44mm), radius=0.15mm, height=1.68mm)
  V491_AC = cylinder(axis=Z, base_centre=(9.25mm, 33.6mm, -1.44mm), radius=0.15mm, height=1.68mm)
  V492_AC = cylinder(axis=Z, base_centre=(-30.35mm, 46.4mm, -1.44mm), radius=0.15mm, height=1.68mm)
  V493_AC = cylinder(axis=Z, base_centre=(-4.85mm, 36mm, -1.44mm), radius=0.15mm, height=1.68mm)
  V494_AC = cylinder(axis=Z, base_centre=(-6.05mm, 31.2mm, -1.44mm), radius=0.15mm, height=1.68mm)
  V495_AC = cylinder(axis=Z, base_centre=(42.65mm, 31.2mm, -1.44mm), radius=0.15mm, height=1.68mm)
  V496_AC = cylinder(axis=Z, base_centre=(22.45mm, 51.2mm, -1.44mm), radius=0.15mm, height=1.68mm)
  V497_AC = cylinder(axis=Z, base_centre=(-17.55mm, 51.2mm, -1.44mm), radius=0.15mm, height=1.68mm)
  V498_AC = cylinder(axis=Z, base_centre=(-9.55mm, 52.8mm, -1.44mm), radius=0.15mm, height=1.68mm)
  V499_AC = cylinder(axis=Z, base_centre=(-43.05mm, 38.4mm, -1.44mm), radius=0.15mm, height=1.68mm)
  V500_AC = cylinder(axis=Z, base_centre=(-14.35mm, 44.8mm, -1.44mm), radius=0.15mm, height=1.68mm)
  V501_AC = cylinder(axis=Z, base_centre=(24.05mm, 44.8mm, -1.44mm), radius=0.15mm, height=1.68mm)
  V502_AC = cylinder(axis=Z, base_centre=(38.45mm, 43.2mm, -1.44mm), radius=0.15mm, height=1.68mm)
  V503_AC = cylinder(axis=Z, base_centre=(-20.75mm, 46.4mm, -1.44mm), radius=0.15mm, height=1.68mm)
  V504_AC = cylinder(axis=Z, base_centre=(30.45mm, 48mm, -1.44mm), radius=0.15mm, height=1.68mm)
  V505_AC = cylinder(axis=Z, base_centre=(36.85mm, 43.2mm, -1.44mm), radius=0.15mm, height=1.68mm)
  V506_AC = cylinder(axis=Z, base_centre=(-12.75mm, 48mm, -1.44mm), radius=0.15mm, height=1.68mm)
  V507_AC = cylinder(axis=Z, base_centre=(-41.55mm, 49.6mm, -1.44mm), radius=0.15mm, height=1.68mm)
  V508_AC = cylinder(axis=Z, base_centre=(19.25mm, 43.2mm, -1.44mm), radius=0.15mm, height=1.68mm)
  V509_AC = cylinder(axis=Z, base_centre=(12.85mm, 49.6mm, -1.44mm), radius=0.15mm, height=1.68mm)
  V510_AC = cylinder(axis=Z, base_centre=(-33.55mm, 51.2mm, -1.44mm), radius=0.15mm, height=1.68mm)
  V511_AC = cylinder(axis=Z, base_centre=(41.45mm, 37.2mm, -1.44mm), radius=0.15mm, height=1.68mm)
  V512_AC = cylinder(axis=Z, base_centre=(8.05mm, 31.2mm, -1.44mm), radius=0.15mm, height=1.68mm)
  V513_AC = cylinder(axis=Z, base_centre=(-9.55mm, 49.6mm, -1.44mm), radius=0.15mm, height=1.68mm)
  V514_AC = cylinder(axis=Z, base_centre=(-27.15mm, 52.8mm, -1.44mm), radius=0.15mm, height=1.68mm)
  V515_AC = cylinder(axis=Z, base_centre=(14.45mm, 49.6mm, -1.44mm), radius=0.15mm, height=1.68mm)
  V516_AC = cylinder(axis=Z, base_centre=(-22.35mm, 48mm, -1.44mm), radius=0.15mm, height=1.68mm)
  V517_AC = cylinder(axis=Z, base_centre=(-12.75mm, 52.8mm, -1.44mm), radius=0.15mm, height=1.68mm)
  V518_AC = cylinder(axis=Z, base_centre=(40.05mm, 43.2mm, -1.44mm), radius=0.15mm, height=1.68mm)
  V519_AC = cylinder(axis=Z, base_centre=(-31.95mm, 49.6mm, -1.44mm), radius=0.15mm, height=1.68mm)
  V520_AC = cylinder(axis=Z, base_centre=(19.25mm, 40mm, -1.44mm), radius=0.15mm, height=1.68mm)
  V521_AC = cylinder(axis=Z, base_centre=(6.45mm, 41.6mm, -1.44mm), radius=0.15mm, height=1.68mm)
  V522_AC = cylinder(axis=Z, base_centre=(-20.75mm, 51.2mm, -1.44mm), radius=0.15mm, height=1.68mm)
  V523_AC = cylinder(axis=Z, base_centre=(32.05mm, 44.8mm, -1.44mm), radius=0.15mm, height=1.68mm)
  V524_AC = cylinder(axis=Z, base_centre=(24.05mm, 41.6mm, -1.44mm), radius=0.15mm, height=1.68mm)
  V525_AC = cylinder(axis=Z, base_centre=(4.85mm, 40mm, -1.44mm), radius=0.15mm, height=1.68mm)
  V526_AC = cylinder(axis=Z, base_centre=(-15.95mm, 49.6mm, -1.44mm), radius=0.15mm, height=1.68mm)
  V527_AC = cylinder(axis=Z, base_centre=(-38.25mm, 37.2mm, -1.44mm), radius=0.15mm, height=1.68mm)
  V528_AC = cylinder(axis=Z, base_centre=(-15.95mm, 46.4mm, -1.44mm), radius=0.15mm, height=1.68mm)
  V529_AC = cylinder(axis=Z, base_centre=(4.45mm, 32.4mm, -1.44mm), radius=0.15mm, height=1.68mm)
  V530_AC = cylinder(axis=Z, base_centre=(-9.55mm, 46.4mm, -1.44mm), radius=0.15mm, height=1.68mm)
  V531_AC = cylinder(axis=Z, base_centre=(27.25mm, 41.6mm, -1.44mm), radius=0.15mm, height=1.68mm)
  V532_AC = cylinder(axis=Z, base_centre=(42.65mm, 34.8mm, -1.44mm), radius=0.15mm, height=1.68mm)
  V533_AC = cylinder(axis=Z, base_centre=(-31.95mm, 52.8mm, -1.44mm), radius=0.15mm, height=1.68mm)
  V534_AC = cylinder(axis=Z, base_centre=(-15.95mm, 51.2mm, -1.44mm), radius=0.15mm, height=1.68mm)
  V535_AC = cylinder(axis=Z, base_centre=(16.05mm, 48mm, -1.44mm), radius=0.15mm, height=1.68mm)
  V536_AC = cylinder(axis=Z, base_centre=(9.65mm, 46.4mm, -1.44mm), radius=0.15mm, height=1.68mm)
  V537_AC = cylinder(axis=Z, base_centre=(28.85mm, 52.8mm, -1.44mm), radius=0.15mm, height=1.68mm)
  V538_AC = cylinder(axis=Z, base_centre=(4.45mm, 38.4mm, -1.44mm), radius=0.15mm, height=1.68mm)
  V539_AC = cylinder(axis=Z, base_centre=(-41.85mm, 36mm, -1.44mm), radius=0.15mm, height=1.68mm)
  V540_AC = cylinder(axis=Z, base_centre=(39.05mm, 34.8mm, -1.44mm), radius=0.15mm, height=1.68mm)
  V541_AC = cylinder(axis=Z, base_centre=(20.85mm, 46.4mm, -1.44mm), radius=0.15mm, height=1.68mm)
  V542_AC = cylinder(axis=Z, base_centre=(-20.75mm, 44.8mm, -1.44mm), radius=0.15mm, height=1.68mm)
  V543_AC = cylinder(axis=Z, base_centre=(11.25mm, 40mm, -1.44mm), radius=0.15mm, height=1.68mm)
  V544_AC = cylinder(axis=Z, base_centre=(-39.95mm, 52.8mm, -1.44mm), radius=0.15mm, height=1.68mm)
  V545_AC = cylinder(axis=Z, base_centre=(20.85mm, 44.8mm, -1.44mm), radius=0.15mm, height=1.68mm)
  V546_AC = cylinder(axis=Z, base_centre=(-7.95mm, 51.2mm, -1.44mm), radius=0.15mm, height=1.68mm)
  V547_AC = cylinder(axis=Z, base_centre=(-8.45mm, 36mm, -1.44mm), radius=0.15mm, height=1.68mm)
  V548_AC = cylinder(axis=Z, base_centre=(5.65mm, 31.2mm, -1.44mm), radius=0.15mm, height=1.68mm)
  V549_AC = cylinder(axis=Z, base_centre=(40.05mm, 40mm, -1.44mm), radius=0.15mm, height=1.68mm)
  V550_AC = cylinder(axis=Z, base_centre=(40.25mm, 31.2mm, -1.44mm), radius=0.15mm, height=1.68mm)
  V551_AC = cylinder(axis=Z, base_centre=(-14.35mm, 48mm, -1.44mm), radius=0.15mm, height=1.68mm)
  V552_AC = cylinder(axis=Z, base_centre=(-23.95mm, 43.2mm, -1.44mm), radius=0.15mm, height=1.68mm)
  V553_AC = cylinder(axis=Z, base_centre=(-22.35mm, 49.6mm, -1.44mm), radius=0.15mm, height=1.68mm)
  V554_AC = cylinder(axis=Z, base_centre=(30.45mm, 51.2mm, -1.44mm), radius=0.15mm, height=1.68mm)
  V555_AC = cylinder(axis=Z, base_centre=(32.05mm, 52.8mm, -1.44mm), radius=0.15mm, height=1.68mm)
  V556_AC = cylinder(axis=Z, base_centre=(-39.95mm, 40mm, -1.44mm), radius=0.15mm, height=1.68mm)
  V557_AC = cylinder(axis=Z, base_centre=(-23.95mm, 46.4mm, -1.44mm), radius=0.15mm, height=1.68mm)
  V558_AC = cylinder(axis=Z, base_centre=(-9.65mm, 33.6mm, -1.44mm), radius=0.15mm, height=1.68mm)
  V559_AC = cylinder(axis=Z, base_centre=(27.25mm, 40mm, -1.44mm), radius=0.15mm, height=1.68mm)
  V560_AC = cylinder(axis=Z, base_centre=(-41.55mm, 46.4mm, -1.44mm), radius=0.15mm, height=1.68mm)
  V561_AC = cylinder(axis=Z, base_centre=(-7.95mm, 46.4mm, -1.44mm), radius=0.15mm, height=1.68mm)
  V562_AC = cylinder(axis=Z, base_centre=(16.05mm, 41.6mm, -1.44mm), radius=0.15mm, height=1.68mm)
  V563_AC = cylinder(axis=Z, base_centre=(-19.15mm, 43.2mm, -1.44mm), radius=0.15mm, height=1.68mm)
  V564_AC = cylinder(axis=Z, base_centre=(-40.65mm, 32.4mm, -1.44mm), radius=0.15mm, height=1.68mm)
  V565_AC = cylinder(axis=Z, base_centre=(-15.95mm, 43.2mm, -1.44mm), radius=0.15mm, height=1.68mm)
  V566_AC = cylinder(axis=Z, base_centre=(-41.55mm, 43.2mm, -1.44mm), radius=0.15mm, height=1.68mm)
  V567_AC = cylinder(axis=Z, base_centre=(-35.15mm, 49.6mm, -1.44mm), radius=0.15mm, height=1.68mm)
  V568_AC = cylinder(axis=Z, base_centre=(-41.85mm, 31.2mm, -1.44mm), radius=0.15mm, height=1.68mm)
  V569_AC = cylinder(axis=Z, base_centre=(17.65mm, 52.8mm, -1.44mm), radius=0.15mm, height=1.68mm)
  V570_AC = cylinder(axis=Z, base_centre=(-8.45mm, 32.4mm, -1.44mm), radius=0.15mm, height=1.68mm)
  V571_AC = cylinder(axis=Z, base_centre=(19.25mm, 52.8mm, -1.44mm), radius=0.15mm, height=1.68mm)
  V572_AC = cylinder(axis=Z, base_centre=(5.65mm, 38.4mm, -1.44mm), radius=0.15mm, height=1.68mm)
  V573_AC = cylinder(axis=Z, base_centre=(-23.95mm, 40mm, -1.44mm), radius=0.15mm, height=1.68mm)
  V574_AC = cylinder(axis=Z, base_centre=(42.65mm, 37.2mm, -1.44mm), radius=0.15mm, height=1.68mm)
  V575_AC = cylinder(axis=Z, base_centre=(5.65mm, 37.2mm, -1.44mm), radius=0.15mm, height=1.68mm)
  V576_AC = cylinder(axis=Z, base_centre=(-20.75mm, 40mm, -1.44mm), radius=0.15mm, height=1.68mm)
  V577_AC = cylinder(axis=Z, base_centre=(-19.15mm, 48mm, -1.44mm), radius=0.15mm, height=1.68mm)
  V578_AC = cylinder(axis=Z, base_centre=(-17.55mm, 41.6mm, -1.44mm), radius=0.15mm, height=1.68mm)
  V579_AC = cylinder(axis=Z, base_centre=(33.65mm, 49.6mm, -1.44mm), radius=0.15mm, height=1.68mm)
  V580_AC = cylinder(axis=Z, base_centre=(-40.65mm, 38.4mm, -1.44mm), radius=0.15mm, height=1.68mm)
  V581_AC = cylinder(axis=Z, base_centre=(-8.45mm, 33.6mm, -1.44mm), radius=0.15mm, height=1.68mm)
  V582_AC = cylinder(axis=Z, base_centre=(36.85mm, 48mm, -1.44mm), radius=0.15mm, height=1.68mm)
  V583_AC = cylinder(axis=Z, base_centre=(40.25mm, 37.2mm, -1.44mm), radius=0.15mm, height=1.68mm)
  V584_AC = cylinder(axis=Z, base_centre=(39.05mm, 37.2mm, -1.44mm), radius=0.15mm, height=1.68mm)
  V585_AC = cylinder(axis=Z, base_centre=(16.05mm, 51.2mm, -1.44mm), radius=0.15mm, height=1.68mm)
  V586_AC = cylinder(axis=Z, base_centre=(-38.25mm, 32.4mm, -1.44mm), radius=0.15mm, height=1.68mm)
  V587_AC = cylinder(axis=Z, base_centre=(-20.75mm, 48mm, -1.44mm), radius=0.15mm, height=1.68mm)
  V588_AC = cylinder(axis=Z, base_centre=(-3.15mm, 40mm, -1.44mm), radius=0.15mm, height=1.68mm)
  V589_AC = cylinder(axis=Z, base_centre=(11.25mm, 41.6mm, -1.44mm), radius=0.15mm, height=1.68mm)
  V590_AC = cylinder(axis=Z, base_centre=(32.05mm, 46.4mm, -1.44mm), radius=0.15mm, height=1.68mm)
  V591_AC = cylinder(axis=Z, base_centre=(-40.65mm, 36mm, -1.44mm), radius=0.15mm, height=1.68mm)
  V592_AC = cylinder(axis=Z, base_centre=(-4.85mm, 37.2mm, -1.44mm), radius=0.15mm, height=1.68mm)
  V593_AC = cylinder(axis=Z, base_centre=(28.85mm, 49.6mm, -1.44mm), radius=0.15mm, height=1.68mm)
  V594_AC = cylinder(axis=Z, base_centre=(24.05mm, 48mm, -1.44mm), radius=0.15mm, height=1.68mm)
  V595_AC = cylinder(axis=Z, base_centre=(-11.15mm, 51.2mm, -1.44mm), radius=0.15mm, height=1.68mm)
  V596_AC = cylinder(axis=Z, base_centre=(40.05mm, 51.2mm, -1.44mm), radius=0.15mm, height=1.68mm)
  V597_AC = cylinder(axis=Z, base_centre=(-9.55mm, 43.2mm, -1.44mm), radius=0.15mm, height=1.68mm)
  V598_AC = cylinder(axis=Z, base_centre=(-7.25mm, 32.4mm, -1.44mm), radius=0.15mm, height=1.68mm)
  V599_AC = cylinder(axis=Z, base_centre=(6.85mm, 38.4mm, -1.44mm), radius=0.15mm, height=1.68mm)
  V600_AC = cylinder(axis=Z, base_centre=(11.25mm, 43.2mm, -1.44mm), radius=0.15mm, height=1.68mm)
  V601_AC = cylinder(axis=Z, base_centre=(4.45mm, 37.2mm, -1.44mm), radius=0.15mm, height=1.68mm)
  V602_AC = cylinder(axis=Z, base_centre=(-11.15mm, 44.8mm, -1.44mm), radius=0.15mm, height=1.68mm)
  V603_AC = cylinder(axis=Z, base_centre=(41.45mm, 34.8mm, -1.44mm), radius=0.15mm, height=1.68mm)
  V604_AC = cylinder(axis=Z, base_centre=(41.65mm, 48mm, -1.44mm), radius=0.15mm, height=1.68mm)
  V605_AC = cylinder(axis=Z, base_centre=(-28.75mm, 52.8mm, -1.44mm), radius=0.15mm, height=1.68mm)
  V606_AC = cylinder(axis=Z, base_centre=(-39.45mm, 36mm, -1.44mm), radius=0.15mm, height=1.68mm)
  V607_AC = cylinder(axis=Z, base_centre=(3.25mm, 40mm, -1.44mm), radius=0.15mm, height=1.68mm)
  V608_AC = cylinder(axis=Z, base_centre=(11.25mm, 51.2mm, -1.44mm), radius=0.15mm, height=1.68mm)
  V609_AC = cylinder(axis=Z, base_centre=(24.05mm, 43.2mm, -1.44mm), radius=0.15mm, height=1.68mm)
  V610_AC = cylinder(axis=Z, base_centre=(-38.25mm, 31.2mm, -1.44mm), radius=0.15mm, height=1.68mm)
  V611_AC = cylinder(axis=Z, base_centre=(-30.35mm, 48mm, -1.44mm), radius=0.15mm, height=1.68mm)
  V612_AC = cylinder(axis=Z, base_centre=(-9.55mm, 40mm, -1.44mm), radius=0.15mm, height=1.68mm)
  V613_AC = cylinder(axis=Z, base_centre=(-22.35mm, 51.2mm, -1.44mm), radius=0.15mm, height=1.68mm)
  V614_AC = cylinder(axis=Z, base_centre=(-12.75mm, 49.6mm, -1.44mm), radius=0.15mm, height=1.68mm)
  V615_AC = cylinder(axis=Z, base_centre=(-7.25mm, 31.2mm, -1.44mm), radius=0.15mm, height=1.68mm)
  V616_AC = cylinder(axis=Z, base_centre=(-33.55mm, 46.4mm, -1.44mm), radius=0.15mm, height=1.68mm)
  V617_AC = cylinder(axis=Z, base_centre=(41.45mm, 36mm, -1.44mm), radius=0.15mm, height=1.68mm)
  V618_AC = cylinder(axis=Z, base_centre=(35.25mm, 52.8mm, -1.44mm), radius=0.15mm, height=1.68mm)
  V619_AC = cylinder(axis=Z, base_centre=(-15.95mm, 52.8mm, -1.44mm), radius=0.15mm, height=1.68mm)
  V620_AC = cylinder(axis=Z, base_centre=(35.25mm, 46.4mm, -1.44mm), radius=0.15mm, height=1.68mm)
  V621_AC = cylinder(axis=Z, base_centre=(-38.35mm, 40mm, -1.44mm), radius=0.15mm, height=1.68mm)
  V622_AC = cylinder(axis=Z, base_centre=(-25.55mm, 49.6mm, -1.44mm), radius=0.15mm, height=1.68mm)
  V623_AC = cylinder(axis=Z, base_centre=(-12.75mm, 41.6mm, -1.44mm), radius=0.15mm, height=1.68mm)
  V624_AC = cylinder(axis=Z, base_centre=(42.65mm, 38.4mm, -1.44mm), radius=0.15mm, height=1.68mm)
  V625_AC = cylinder(axis=Z, base_centre=(-9.65mm, 31.2mm, -1.44mm), radius=0.15mm, height=1.68mm)
  V626_AC = cylinder(axis=Z, base_centre=(-7.95mm, 44.8mm, -1.44mm), radius=0.15mm, height=1.68mm)
  V627_AC = cylinder(axis=Z, base_centre=(-7.25mm, 34.8mm, -1.44mm), radius=0.15mm, height=1.68mm)
  V628_AC = cylinder(axis=Z, base_centre=(5.65mm, 36mm, -1.44mm), radius=0.15mm, height=1.68mm)
  V629_AC = cylinder(axis=Z, base_centre=(11.25mm, 46.4mm, -1.44mm), radius=0.15mm, height=1.68mm)
  V630_AC = cylinder(axis=Z, base_centre=(-6.05mm, 38.4mm, -1.44mm), radius=0.15mm, height=1.68mm)
  V631_AC = cylinder(axis=Z, base_centre=(20.85mm, 40mm, -1.44mm), radius=0.15mm, height=1.68mm)
  V632_AC = cylinder(axis=Z, base_centre=(8.05mm, 32.4mm, -1.44mm), radius=0.15mm, height=1.68mm)
  V633_AC = cylinder(axis=Z, base_centre=(-38.25mm, 33.6mm, -1.44mm), radius=0.15mm, height=1.68mm)
  V634_AC = cylinder(axis=Z, base_centre=(-27.15mm, 51.2mm, -1.44mm), radius=0.15mm, height=1.68mm)
  V635_AC = cylinder(axis=Z, base_centre=(-14.35mm, 49.6mm, -1.44mm), radius=0.15mm, height=1.68mm)
  V636_AC = cylinder(axis=Z, base_centre=(33.65mm, 41.6mm, -1.44mm), radius=0.15mm, height=1.68mm)
  V637_AC = cylinder(axis=Z, base_centre=(17.65mm, 46.4mm, -1.44mm), radius=0.15mm, height=1.68mm)
  V638_AC = cylinder(axis=Z, base_centre=(-22.35mm, 46.4mm, -1.44mm), radius=0.15mm, height=1.68mm)
  V639_AC = cylinder(axis=Z, base_centre=(-40.65mm, 31.2mm, -1.44mm), radius=0.15mm, height=1.68mm)
  V640_AC = cylinder(axis=Z, base_centre=(8.05mm, 43.2mm, -1.44mm), radius=0.15mm, height=1.68mm)
  V641_AC = cylinder(axis=Z, base_centre=(19.25mm, 51.2mm, -1.44mm), radius=0.15mm, height=1.68mm)
  V642_AC = cylinder(axis=Z, base_centre=(-38.25mm, 38.4mm, -1.44mm), radius=0.15mm, height=1.68mm)
  V643_AC = cylinder(axis=Z, base_centre=(-9.65mm, 38.4mm, -1.44mm), radius=0.15mm, height=1.68mm)
  V644_AC = cylinder(axis=Z, base_centre=(-25.55mm, 46.4mm, -1.44mm), radius=0.15mm, height=1.68mm)
  V645_AC = cylinder(axis=Z, base_centre=(9.65mm, 40mm, -1.44mm), radius=0.15mm, height=1.68mm)
  V646_AC = cylinder(axis=Z, base_centre=(6.45mm, 40mm, -1.44mm), radius=0.15mm, height=1.68mm)
  V647_AC = cylinder(axis=Z, base_centre=(-31.95mm, 43.2mm, -1.44mm), radius=0.15mm, height=1.68mm)
  V648_AC = cylinder(axis=Z, base_centre=(-43.15mm, 49.6mm, -1.44mm), radius=0.15mm, height=1.68mm)
  V649_AC = cylinder(axis=Z, base_centre=(-12.75mm, 51.2mm, -1.44mm), radius=0.15mm, height=1.68mm)
  V650_AC = cylinder(axis=Z, base_centre=(-30.35mm, 44.8mm, -1.44mm), radius=0.15mm, height=1.68mm)
  V651_AC = cylinder(axis=Z, base_centre=(-17.55mm, 49.6mm, -1.44mm), radius=0.15mm, height=1.68mm)
  V652_AC = cylinder(axis=Z, base_centre=(-14.35mm, 41.6mm, -1.44mm), radius=0.15mm, height=1.68mm)
  V653_AC = cylinder(axis=Z, base_centre=(38.45mm, 46.4mm, -1.44mm), radius=0.15mm, height=1.68mm)
  V654_AC = cylinder(axis=Z, base_centre=(24.05mm, 46.4mm, -1.44mm), radius=0.15mm, height=1.68mm)
  V655_AC = cylinder(axis=Z, base_centre=(41.65mm, 40mm, -1.44mm), radius=0.15mm, height=1.68mm)
  V656_AC = cylinder(axis=Z, base_centre=(-11.15mm, 40mm, -1.44mm), radius=0.15mm, height=1.68mm)
  V657_AC = cylinder(axis=Z, base_centre=(8.05mm, 51.2mm, -1.44mm), radius=0.15mm, height=1.68mm)
  V658_AC = cylinder(axis=Z, base_centre=(-23.95mm, 51.2mm, -1.44mm), radius=0.15mm, height=1.68mm)
  V659_AC = cylinder(axis=Z, base_centre=(40.25mm, 33.6mm, -1.44mm), radius=0.15mm, height=1.68mm)
  V660_AC = cylinder(axis=Z, base_centre=(-4.85mm, 32.4mm, -1.44mm), radius=0.15mm, height=1.68mm)
  V661_AC = cylinder(axis=Z, base_centre=(-22.35mm, 52.8mm, -1.44mm), radius=0.15mm, height=1.68mm)
  V662_AC = cylinder(axis=Z, base_centre=(16.05mm, 44.8mm, -1.44mm), radius=0.15mm, height=1.68mm)
  V663_AC = cylinder(axis=Z, base_centre=(28.85mm, 43.2mm, -1.44mm), radius=0.15mm, height=1.68mm)
  V664_AC = cylinder(axis=Z, base_centre=(8.05mm, 48mm, -1.44mm), radius=0.15mm, height=1.68mm)
  Q5_3 = box(corner=(15.2mm, 3.1mm, 0.17mm), size=(0.65mm, 3.6mm, 0.105mm))
  Q5_4 = box(corner=(14.35mm, 3.1mm, 0.17mm), size=(0.65mm, 3.6mm, 0.105mm))
  Q5_5 = box(corner=(13.5mm, 3.1mm, 0.17mm), size=(0.65mm, 3.6mm, 0.105mm))
  Q5_6 = box(corner=(12.65mm, 3.1mm, 0.17mm), size=(0.65mm, 3.6mm, 0.105mm))
  Q5_7 = box(corner=(11.347mm, 3.1mm, 0.17mm), size=(1.102mm, 3.6mm, 0.105mm))
  Q3_3 = box(corner=(-32.3mm, 7.4mm, 0.17mm), size=(0.65mm, 3.6mm, 0.105mm))
  Q3_4 = box(corner=(-33.15mm, 7.4mm, 0.17mm), size=(0.65mm, 3.6mm, 0.105mm))
  Q3_5 = box(corner=(-34mm, 7.4mm, 0.17mm), size=(0.65mm, 3.6mm, 0.105mm))
  Q3_6 = box(corner=(-34.85mm, 7.4mm, 0.17mm), size=(0.65mm, 3.6mm, 0.105mm))
  Q3_7 = box(corner=(-36.153mm, 7.4mm, 0.17mm), size=(1.102mm, 3.6mm, 0.105mm))
  Q4_3 = box(corner=(-15.85mm, 7.4mm, 0.17mm), size=(0.65mm, 3.6mm, 0.105mm))
  Q4_4 = box(corner=(-15mm, 7.4mm, 0.17mm), size=(0.65mm, 3.6mm, 0.105mm))
  Q4_5 = box(corner=(-14.15mm, 7.4mm, 0.17mm), size=(0.65mm, 3.6mm, 0.105mm))
  Q4_6 = box(corner=(-13.3mm, 7.4mm, 0.17mm), size=(0.65mm, 3.6mm, 0.105mm))
  Q4_7 = box(corner=(-12.449mm, 7.4mm, 0.17mm), size=(1.102mm, 3.6mm, 0.105mm))
  Q7_3 = box(corner=(15.2mm, 7.4mm, 0.17mm), size=(0.65mm, 3.6mm, 0.105mm))
  Q7_4 = box(corner=(14.35mm, 7.4mm, 0.17mm), size=(0.65mm, 3.6mm, 0.105mm))
  Q7_5 = box(corner=(13.5mm, 7.4mm, 0.17mm), size=(0.65mm, 3.6mm, 0.105mm))
  Q7_6 = box(corner=(12.65mm, 7.4mm, 0.17mm), size=(0.65mm, 3.6mm, 0.105mm))
  Q7_7 = box(corner=(11.347mm, 7.4mm, 0.17mm), size=(1.102mm, 3.6mm, 0.105mm))
  Q6_3 = box(corner=(31.65mm, 3.1mm, 0.17mm), size=(0.65mm, 3.6mm, 0.105mm))
  Q6_4 = box(corner=(32.5mm, 3.1mm, 0.17mm), size=(0.65mm, 3.6mm, 0.105mm))
  Q6_5 = box(corner=(33.35mm, 3.1mm, 0.17mm), size=(0.65mm, 3.6mm, 0.105mm))
  Q6_6 = box(corner=(34.2mm, 3.1mm, 0.17mm), size=(0.65mm, 3.6mm, 0.105mm))
  Q6_7 = box(corner=(35.051mm, 3.1mm, 0.17mm), size=(1.102mm, 3.6mm, 0.105mm))
  Q8_3 = box(corner=(31.65mm, 7.4mm, 0.17mm), size=(0.65mm, 3.6mm, 0.105mm))
  Q8_4 = box(corner=(32.5mm, 7.4mm, 0.17mm), size=(0.65mm, 3.6mm, 0.105mm))
  Q8_5 = box(corner=(33.35mm, 7.4mm, 0.17mm), size=(0.65mm, 3.6mm, 0.105mm))
  Q8_6 = box(corner=(34.2mm, 7.4mm, 0.17mm), size=(0.65mm, 3.6mm, 0.105mm))
  Q8_7 = box(corner=(35.051mm, 7.4mm, 0.17mm), size=(1.102mm, 3.6mm, 0.105mm))
  Q1_3 = box(corner=(-32.3mm, 3.1mm, 0.17mm), size=(0.65mm, 3.6mm, 0.105mm))
  Q1_4 = box(corner=(-33.15mm, 3.1mm, 0.17mm), size=(0.65mm, 3.6mm, 0.105mm))
  Q1_5 = box(corner=(-34mm, 3.1mm, 0.17mm), size=(0.65mm, 3.6mm, 0.105mm))
  Q1_6 = box(corner=(-34.85mm, 3.1mm, 0.17mm), size=(0.65mm, 3.6mm, 0.105mm))
  Q1_7 = box(corner=(-36.153mm, 3.1mm, 0.17mm), size=(1.102mm, 3.6mm, 0.105mm))
  Q2_3 = box(corner=(-15.85mm, 3.1mm, 0.17mm), size=(0.65mm, 3.6mm, 0.105mm))
  Q2_4 = box(corner=(-15mm, 3.1mm, 0.17mm), size=(0.65mm, 3.6mm, 0.105mm))
  Q2_5 = box(corner=(-14.15mm, 3.1mm, 0.17mm), size=(0.65mm, 3.6mm, 0.105mm))
  Q2_6 = box(corner=(-13.3mm, 3.1mm, 0.17mm), size=(0.65mm, 3.6mm, 0.105mm))
  Q2_7 = box(corner=(-12.449mm, 3.1mm, 0.17mm), size=(1.102mm, 3.6mm, 0.105mm))
  C7_1 = box(corner=(-18.975mm, 1.65mm, 0.17mm), size=(1.45mm, 1mm, 0.105mm))
  C7_2 = box(corner=(-18.975mm, -0.25mm, 0.17mm), size=(1.45mm, 1mm, 0.105mm))
  RS1_1 = box(corner=(-43.65mm, 11.2mm, 0.17mm), size=(15mm, 1.2mm, 0.105mm))
  RS1_2 = box(corner=(-43.65mm, 12.9mm, 0.17mm), size=(15mm, 3mm, 0.105mm))
  C37_1 = box(corner=(12.725mm, 1.65mm, 0.17mm), size=(1.45mm, 1mm, 0.105mm))
  C37_2 = box(corner=(12.725mm, -0.25mm, 0.17mm), size=(1.45mm, 1mm, 0.105mm))
  C2_1 = box(corner=(-36.375mm, 1.65mm, 0.17mm), size=(1.45mm, 1mm, 0.105mm))
  C2_2 = box(corner=(-36.375mm, -0.25mm, 0.17mm), size=(1.45mm, 1mm, 0.105mm))
  C44_1 = box(corner=(33.325mm, 1.65mm, 0.17mm), size=(1.45mm, 1mm, 0.105mm))
  C44_2 = box(corner=(33.325mm, -0.25mm, 0.17mm), size=(1.45mm, 1mm, 0.105mm))
  C4_1 = box(corner=(-33.175mm, 1.65mm, 0.17mm), size=(1.45mm, 1mm, 0.105mm))
  C4_2 = box(corner=(-33.175mm, -0.25mm, 0.17mm), size=(1.45mm, 1mm, 0.105mm))
  C9_1 = box(corner=(-15.775mm, 1.65mm, 0.17mm), size=(1.45mm, 1mm, 0.105mm))
  C9_2 = box(corner=(-15.775mm, -0.25mm, 0.17mm), size=(1.45mm, 1mm, 0.105mm))
  C1_1 = box(corner=(-37.975mm, 1.65mm, 0.17mm), size=(1.45mm, 1mm, 0.105mm))
  C1_2 = box(corner=(-37.975mm, -0.25mm, 0.17mm), size=(1.45mm, 1mm, 0.105mm))
  C12_1 = box(corner=(-10.975mm, 1.65mm, 0.17mm), size=(1.45mm, 1mm, 0.105mm))
  C12_2 = box(corner=(-10.975mm, -0.25mm, 0.17mm), size=(1.45mm, 1mm, 0.105mm))
  RS4_1 = box(corner=(28.65mm, 11.2mm, 0.17mm), size=(15mm, 1.2mm, 0.105mm))
  RS4_2 = box(corner=(28.65mm, 12.9mm, 0.17mm), size=(15mm, 3mm, 0.105mm))
  C45_1 = box(corner=(34.925mm, 1.65mm, 0.17mm), size=(1.45mm, 1mm, 0.105mm))
  C45_2 = box(corner=(34.925mm, -0.25mm, 0.17mm), size=(1.45mm, 1mm, 0.105mm))
  C43_1 = box(corner=(31.725mm, 1.65mm, 0.17mm), size=(1.45mm, 1mm, 0.105mm))
  C43_2 = box(corner=(31.725mm, -0.25mm, 0.17mm), size=(1.45mm, 1mm, 0.105mm))
  C39_1 = box(corner=(15.925mm, 1.65mm, 0.17mm), size=(1.45mm, 1mm, 0.105mm))
  C39_2 = box(corner=(15.925mm, -0.25mm, 0.17mm), size=(1.45mm, 1mm, 0.105mm))
  C11_1 = box(corner=(-12.575mm, 1.65mm, 0.17mm), size=(1.45mm, 1mm, 0.105mm))
  C11_2 = box(corner=(-12.575mm, -0.25mm, 0.17mm), size=(1.45mm, 1mm, 0.105mm))
  RS3_1 = box(corner=(3.85mm, 11.2mm, 0.17mm), size=(15mm, 1.2mm, 0.105mm))
  RS3_2 = box(corner=(3.85mm, 12.9mm, 0.17mm), size=(15mm, 3mm, 0.105mm))
  C36_1 = box(corner=(11.125mm, 1.65mm, 0.17mm), size=(1.45mm, 1mm, 0.105mm))
  C36_2 = box(corner=(11.125mm, -0.25mm, 0.17mm), size=(1.45mm, 1mm, 0.105mm))
  C38_1 = box(corner=(14.325mm, 1.65mm, 0.17mm), size=(1.45mm, 1mm, 0.105mm))
  C38_2 = box(corner=(14.325mm, -0.25mm, 0.17mm), size=(1.45mm, 1mm, 0.105mm))
  C8_1 = box(corner=(-17.375mm, 1.65mm, 0.17mm), size=(1.45mm, 1mm, 0.105mm))
  C8_2 = box(corner=(-17.375mm, -0.25mm, 0.17mm), size=(1.45mm, 1mm, 0.105mm))
  C40_1 = box(corner=(17.525mm, 1.65mm, 0.17mm), size=(1.45mm, 1mm, 0.105mm))
  C40_2 = box(corner=(17.525mm, -0.25mm, 0.17mm), size=(1.45mm, 1mm, 0.105mm))
  C42_1 = box(corner=(30.125mm, 1.65mm, 0.17mm), size=(1.45mm, 1mm, 0.105mm))
  C42_2 = box(corner=(30.125mm, -0.25mm, 0.17mm), size=(1.45mm, 1mm, 0.105mm))
  C5_1 = box(corner=(-31.575mm, 1.65mm, 0.17mm), size=(1.45mm, 1mm, 0.105mm))
  C5_2 = box(corner=(-31.575mm, -0.25mm, 0.17mm), size=(1.45mm, 1mm, 0.105mm))
  C3_1 = box(corner=(-34.775mm, 1.65mm, 0.17mm), size=(1.45mm, 1mm, 0.105mm))
  C3_2 = box(corner=(-34.775mm, -0.25mm, 0.17mm), size=(1.45mm, 1mm, 0.105mm))
  C10_1 = box(corner=(-14.175mm, 1.65mm, 0.17mm), size=(1.45mm, 1mm, 0.105mm))
  C10_2 = box(corner=(-14.175mm, -0.25mm, 0.17mm), size=(1.45mm, 1mm, 0.105mm))
  C41_1 = box(corner=(28.525mm, 1.65mm, 0.17mm), size=(1.45mm, 1mm, 0.105mm))
  C41_2 = box(corner=(28.525mm, -0.25mm, 0.17mm), size=(1.45mm, 1mm, 0.105mm))
  RS2_1 = box(corner=(-18.85mm, 11.2mm, 0.17mm), size=(15mm, 1.2mm, 0.105mm))
  RS2_2 = box(corner=(-18.85mm, 12.9mm, 0.17mm), size=(15mm, 3mm, 0.105mm))
  C6_1 = box(corner=(-29.975mm, 1.65mm, 0.17mm), size=(1.45mm, 1mm, 0.105mm))
  C6_2 = box(corner=(-29.975mm, -0.25mm, 0.17mm), size=(1.45mm, 1mm, 0.105mm))
  C35_1 = box(corner=(9.525mm, 1.65mm, 0.17mm), size=(1.45mm, 1mm, 0.105mm))
  C35_2 = box(corner=(9.525mm, -0.25mm, 0.17mm), size=(1.45mm, 1mm, 0.105mm))
  C46_1 = box(corner=(36.525mm, 1.65mm, 0.17mm), size=(1.45mm, 1mm, 0.105mm))
  C46_2 = box(corner=(36.525mm, -0.25mm, 0.17mm), size=(1.45mm, 1mm, 0.105mm))
  C27_1 = box(corner=(-34.775mm, -0.25mm, -1.475mm), size=(1.45mm, 1mm, 0.105mm))
  C27_2 = box(corner=(-34.775mm, 1.65mm, -1.475mm), size=(1.45mm, 1mm, 0.105mm))
  C34_1 = box(corner=(-18.975mm, -0.25mm, -1.475mm), size=(1.45mm, 1mm, 0.105mm))
  C34_2 = box(corner=(-18.975mm, 1.65mm, -1.475mm), size=(1.45mm, 1mm, 0.105mm))
  C61_1 = box(corner=(12.725mm, -0.25mm, -1.475mm), size=(1.45mm, 1mm, 0.105mm))
  C61_2 = box(corner=(12.725mm, 1.65mm, -1.475mm), size=(1.45mm, 1mm, 0.105mm))
  C28_1 = box(corner=(-33.175mm, -0.25mm, -1.475mm), size=(1.45mm, 1mm, 0.105mm))
  C28_2 = box(corner=(-33.175mm, 1.65mm, -1.475mm), size=(1.45mm, 1mm, 0.105mm))
  C32_1 = box(corner=(-15.775mm, -0.25mm, -1.475mm), size=(1.45mm, 1mm, 0.105mm))
  C32_2 = box(corner=(-15.775mm, 1.65mm, -1.475mm), size=(1.45mm, 1mm, 0.105mm))
  C63_1 = box(corner=(15.925mm, -0.25mm, -1.475mm), size=(1.45mm, 1mm, 0.105mm))
  C63_2 = box(corner=(15.925mm, 1.65mm, -1.475mm), size=(1.45mm, 1mm, 0.105mm))
  C31_1 = box(corner=(-14.175mm, -0.25mm, -1.475mm), size=(1.45mm, 1mm, 0.105mm))
  C31_2 = box(corner=(-14.175mm, 1.65mm, -1.475mm), size=(1.45mm, 1mm, 0.105mm))
  C65_1 = box(corner=(33.325mm, -0.25mm, -1.475mm), size=(1.45mm, 1mm, 0.105mm))
  C65_2 = box(corner=(33.325mm, 1.65mm, -1.475mm), size=(1.45mm, 1mm, 0.105mm))
  C67_1 = box(corner=(30.125mm, -0.25mm, -1.475mm), size=(1.45mm, 1mm, 0.105mm))
  C67_2 = box(corner=(30.125mm, 1.65mm, -1.475mm), size=(1.45mm, 1mm, 0.105mm))
  C68_1 = box(corner=(28.525mm, -0.25mm, -1.475mm), size=(1.45mm, 1mm, 0.105mm))
  C68_2 = box(corner=(28.525mm, 1.65mm, -1.475mm), size=(1.45mm, 1mm, 0.105mm))
  C29_1 = box(corner=(-31.575mm, -0.25mm, -1.475mm), size=(1.45mm, 1mm, 0.105mm))
  C29_2 = box(corner=(-31.575mm, 1.65mm, -1.475mm), size=(1.45mm, 1mm, 0.105mm))
  C33_1 = box(corner=(-17.375mm, -0.25mm, -1.475mm), size=(1.45mm, 1mm, 0.105mm))
  C33_2 = box(corner=(-17.375mm, 1.65mm, -1.475mm), size=(1.45mm, 1mm, 0.105mm))
  C62_1 = box(corner=(14.325mm, -0.25mm, -1.475mm), size=(1.45mm, 1mm, 0.105mm))
  C62_2 = box(corner=(14.325mm, 1.65mm, -1.475mm), size=(1.45mm, 1mm, 0.105mm))
  C66_1 = box(corner=(31.725mm, -0.25mm, -1.475mm), size=(1.45mm, 1mm, 0.105mm))
  C66_2 = box(corner=(31.725mm, 1.65mm, -1.475mm), size=(1.45mm, 1mm, 0.105mm))
  C64_1 = box(corner=(17.525mm, -0.25mm, -1.475mm), size=(1.45mm, 1mm, 0.105mm))
  C64_2 = box(corner=(17.525mm, 1.65mm, -1.475mm), size=(1.45mm, 1mm, 0.105mm))
  C30_1 = box(corner=(-29.975mm, -0.25mm, -1.475mm), size=(1.45mm, 1mm, 0.105mm))
  C30_2 = box(corner=(-29.975mm, 1.65mm, -1.475mm), size=(1.45mm, 1mm, 0.105mm))
  P27_AC_L1.unite(P28_AC_L1, P29_AC_L1, P30_AC_L1, P31_AC_L1, P32_AC_L2, P33_AC_L3, P34_AC_L4, V331_AC, V332_AC, V333_AC, V334_AC, V335_AC, V336_AC, V337_AC, V338_AC, V339_AC, V340_AC, V341_AC, V342_AC, V343_AC, V344_AC, V345_AC, V346_AC, V347_AC, V348_AC, V349_AC, V350_AC, V351_AC, V352_AC, V353_AC, V354_AC, V355_AC, V356_AC, V357_AC, V358_AC, V359_AC, V360_AC, V361_AC, V362_AC, V363_AC, V364_AC, V365_AC, V366_AC, V367_AC, V368_AC, V369_AC, V370_AC, V371_AC, V372_AC, V373_AC, V374_AC, V375_AC, V376_AC, V377_AC, V378_AC, V379_AC, V380_AC, V381_AC, V382_AC, V383_AC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)
  P27_AC_L1.separate_bodies()
  P23_LSRC3_L1.unite(P24_LSRC3_L4, V479_LSRC3, Q7_4, Q7_6, RS3_1)
  P23_LSRC3_L1.separate_bodies()
  P21_LSRC2_L1.unite(P22_LSRC2_L4, V478_LSRC2, Q4_4, Q4_6, RS2_1)
  P21_LSRC2_L1.separate_bodies()
  P19_LSRC1_L1.unite(P20_LSRC1_L4, V477_LSRC1, Q3_4, Q3_6, RS1_1)
  P19_LSRC1_L1.separate_bodies()
  P25_LSRC4_L1.unite(P26_LSRC4_L4, V480_LSRC4, Q8_4, Q8_6, RS4_1)
  P25_LSRC4_L1.separate_bodies()
  P0_DCN_L1.unite(P1_DCN_L1, P2_DCN_L1, P3_DCN_L1, P4_DCN_L1, P5_DCN_L2, P6_DCN_L4, P7_DCN_L4, P8_DCN_L4, P9_DCN_L4, V32_DCN, V33_DCN, V34_DCN, V35_DCN, V36_DCN, V37_DCN, V38_DCN, V39_DCN, V40_DCN, V41_DCN, V42_DCN, V43_DCN, V44_DCN, V45_DCN, V46_DCN, V47_DCN, V48_DCN, V49_DCN, V50_DCN, V51_DCN, V52_DCN, V53_DCN, V54_DCN, V55_DCN, V56_DCN, V57_DCN, V58_DCN, V59_DCN, V60_DCN, V61_DCN, V62_DCN, V63_DCN, V64_DCN, V65_DCN, V66_DCN, V67_DCN, V68_DCN, V69_DCN, V70_DCN, V71_DCN, V72_DCN, V73_DCN, V74_DCN, V75_DCN, V76_DCN, V77_DCN, V78_DCN, V79_DCN, V80_DCN, V81_DCN, V82_DCN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)
  P0_DCN_L1.separate_bodies()
  P10_DCP_L1.unite(P11_DCP_L1, P12_DCP_L1, P13_DCP_L1, P14_DCP_L3, P15_DCP_L4, P16_DCP_L4, P17_DCP_L4, P18_DCP_L4, V0_DCP, V1_DCP, V2_DCP, V3_DCP, V4_DCP, V5_DCP, V6_DCP, V7_DCP, V8_DCP, V9_DCP, V10_DCP, V11_DCP, V12_DCP, V13_DCP, V14_DCP, V15_DCP, V16_DCP, V17_DCP, V18_DCP, V19_DCP, V20_DCP, V21_DCP, V22_DCP, V23_DCP, V24_DCP, V25_DCP, V26_DCP, V27_DCP, V28_DCP, V29_DCP, V30_DCP, V31_DCP, Q5_3, Q5_5, Q5_7, Q6_3, Q6_5, Q6_7, Q1_3, Q1_5, Q1_7, Q2_3, Q2_5, Q2_7, C7_1, C37_1, C2_1, C44_1, C4_1, C9_1, C1_1, C12_1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)
  P10_DCP_L1.separate_bodies()
boundaries and excitations:
  AC: SignalNet Objects=P27_AC_L1
  LSRC3: SignalNet Objects=P23_LSRC3_L1
  LSRC2: SignalNet Objects=P21_LSRC2_L1
  LSRC1: SignalNet Objects=P19_LSRC1_L1
  LSRC4: SignalNet Objects=P25_LSRC4_L1
  DCN: SignalNet Objects=P0_DCN_L1
  DCP: SignalNet Objects=P10_DCP_L1
  CapN_2: Source Faces=P0_DCN_L1.face(at (-18.25, 0.25, 0.275), at (-15.05, 0.25, 0.275), at (-10.25, 0.25, 0.275), at (-11.85, 0.25, 0.275), at (-16.65, 0.25, 0.275), at (-13.45, 0.25, 0.275)) TerminalType=ConstantVoltage Net=DCN
  CapN_3: Source Faces=P0_DCN_L1.face(at (13.45, 0.25, 0.275), at (16.65, 0.25, 0.275), at (11.85, 0.25, 0.275), at (15.05, 0.25, 0.275), at (18.25, 0.25, 0.275), at (10.25, 0.25, 0.275)) TerminalType=ConstantVoltage Net=DCN
  CapN_4: Source Faces=P0_DCN_L1.face(at (34.05, 0.25, 0.275), at (35.65, 0.25, 0.275), at (32.45, 0.25, 0.275), at (30.85, 0.25, 0.275), at (29.25, 0.25, 0.275), at (37.25, 0.25, 0.275)) TerminalType=ConstantVoltage Net=DCN
  CapNb_1: Source Faces=P0_DCN_L1.face(at (-34.05, 0.25, -1.475), at (-32.45, 0.25, -1.475), at (-30.85, 0.25, -1.475), at (-29.25, 0.25, -1.475)) TerminalType=ConstantVoltage Net=DCN
  CapNb_2: Source Faces=P0_DCN_L1.face(at (-18.25, 0.25, -1.475), at (-15.05, 0.25, -1.475), at (-13.45, 0.25, -1.475), at (-16.65, 0.25, -1.475)) TerminalType=ConstantVoltage Net=DCN
  CapNb_3: Source Faces=P0_DCN_L1.face(at (13.45, 0.25, -1.475), at (16.65, 0.25, -1.475), at (15.05, 0.25, -1.475), at (18.25, 0.25, -1.475)) TerminalType=ConstantVoltage Net=DCN
  CapNb_4: Source Faces=P0_DCN_L1.face(at (34.05, 0.25, -1.475), at (30.85, 0.25, -1.475), at (29.25, 0.25, -1.475), at (32.45, 0.25, -1.475)) TerminalType=ConstantVoltage Net=DCN
  CapP_2: Source Faces=P10_DCP_L1.face(at (-18.25, 2.15, 0.275), at (-15.05, 2.15, 0.275), at (-10.25, 2.15, 0.275), at (-11.85, 2.15, 0.275), at (-16.65, 2.15, 0.275), at (-13.45, 2.15, 0.275)) TerminalType=ConstantVoltage Net=DCP
  CapP_3: Source Faces=P10_DCP_L1.face(at (13.45, 2.15, 0.275), at (16.65, 2.15, 0.275), at (11.85, 2.15, 0.275), at (15.05, 2.15, 0.275), at (18.25, 2.15, 0.275), at (10.25, 2.15, 0.275)) TerminalType=ConstantVoltage Net=DCP
  CapP_4: Source Faces=P10_DCP_L1.face(at (34.05, 2.15, 0.275), at (35.65, 2.15, 0.275), at (32.45, 2.15, 0.275), at (30.85, 2.15, 0.275), at (29.25, 2.15, 0.275), at (37.25, 2.15, 0.275)) TerminalType=ConstantVoltage Net=DCP
  CapPb_1: Source Faces=P10_DCP_L1.face(at (-34.05, 2.15, -1.475), at (-32.45, 2.15, -1.475), at (-30.85, 2.15, -1.475), at (-29.25, 2.15, -1.475)) TerminalType=ConstantVoltage Net=DCP
  CapPb_2: Source Faces=P10_DCP_L1.face(at (-18.25, 2.15, -1.475), at (-15.05, 2.15, -1.475), at (-13.45, 2.15, -1.475), at (-16.65, 2.15, -1.475)) TerminalType=ConstantVoltage Net=DCP
  CapPb_3: Source Faces=P10_DCP_L1.face(at (13.45, 2.15, -1.475), at (16.65, 2.15, -1.475), at (15.05, 2.15, -1.475), at (18.25, 2.15, -1.475)) TerminalType=ConstantVoltage Net=DCP
  CapPb_4: Source Faces=P10_DCP_L1.face(at (34.05, 2.15, -1.475), at (30.85, 2.15, -1.475), at (29.25, 2.15, -1.475), at (32.45, 2.15, -1.475)) TerminalType=ConstantVoltage Net=DCP
  QH_D_1: Source Faces=P10_DCP_L1.face(at (-31.975, 4.9, 0.275), at (-33.675, 4.9, 0.275), at (-35.602, 4.9, 0.275)) TerminalType=ConstantVoltage Net=DCP
  QH_D_2: Source Faces=P10_DCP_L1.face(at (-15.525, 4.9, 0.275), at (-13.825, 4.9, 0.275), at (-11.898, 4.9, 0.275)) TerminalType=ConstantVoltage Net=DCP
  QH_D_3: Source Faces=P10_DCP_L1.face(at (15.525, 4.9, 0.275), at (13.825, 4.9, 0.275), at (11.898, 4.9, 0.275)) TerminalType=ConstantVoltage Net=DCP
  QH_D_4: Source Faces=P10_DCP_L1.face(at (31.975, 4.9, 0.275), at (33.675, 4.9, 0.275), at (35.602, 4.9, 0.275)) TerminalType=ConstantVoltage Net=DCP
  QH_S_2: Source Faces=P27_AC_L1.face(at (-14.675, 4.9, 0.275), at (-12.975, 4.9, 0.275)) TerminalType=ConstantVoltage Net=AC
  QH_S_3: Source Faces=P27_AC_L1.face(at (14.675, 4.9, 0.275), at (12.975, 4.9, 0.275)) TerminalType=ConstantVoltage Net=AC
  QH_S_4: Source Faces=P27_AC_L1.face(at (32.825, 4.9, 0.275), at (34.525, 4.9, 0.275)) TerminalType=ConstantVoltage Net=AC
  QL_D_1: Source Faces=P27_AC_L1.face(at (-31.975, 9.2, 0.275), at (-33.675, 9.2, 0.275), at (-35.602, 9.2, 0.275)) TerminalType=ConstantVoltage Net=AC
  QL_D_2: Source Faces=P27_AC_L1.face(at (-15.525, 9.2, 0.275), at (-13.825, 9.2, 0.275), at (-11.898, 9.2, 0.275)) TerminalType=ConstantVoltage Net=AC
  QL_D_3: Source Faces=P27_AC_L1.face(at (15.525, 9.2, 0.275), at (13.825, 9.2, 0.275), at (11.898, 9.2, 0.275)) TerminalType=ConstantVoltage Net=AC
  QL_D_4: Source Faces=P27_AC_L1.face(at (31.975, 9.2, 0.275), at (33.675, 9.2, 0.275), at (35.602, 9.2, 0.275)) TerminalType=ConstantVoltage Net=AC
  QL_S_1: Source Faces=P19_LSRC1_L1.face(at (-32.825, 9.2, 0.275), at (-34.525, 9.2, 0.275)) TerminalType=ConstantVoltage Net=LSRC1
  QL_S_2: Source Faces=P21_LSRC2_L1.face(at (-14.675, 9.2, 0.275), at (-12.975, 9.2, 0.275)) TerminalType=ConstantVoltage Net=LSRC2
  QL_S_3: Source Faces=P23_LSRC3_L1.face(at (14.675, 9.2, 0.275), at (12.975, 9.2, 0.275)) TerminalType=ConstantVoltage Net=LSRC3
  QL_S_4: Source Faces=P25_LSRC4_L1.face(at (32.825, 9.2, 0.275), at (34.525, 9.2, 0.275)) TerminalType=ConstantVoltage Net=LSRC4
  RSN_1: Source Faces=P0_DCN_L1.face(at (-36.15, 14.4, 0.275)) TerminalType=ConstantVoltage Net=DCN
  RSN_2: Source Faces=P0_DCN_L1.face(at (-11.35, 14.4, 0.275)) TerminalType=ConstantVoltage Net=DCN
  RSN_3: Source Faces=P0_DCN_L1.face(at (11.35, 14.4, 0.275)) TerminalType=ConstantVoltage Net=DCN
  RSN_4: Source Faces=P0_DCN_L1.face(at (36.15, 14.4, 0.275)) TerminalType=ConstantVoltage Net=DCN
  CapN_1: Sink Faces=P0_DCN_L1.face(at (-35.65, 0.25, 0.275), at (-32.45, 0.25, 0.275), at (-37.25, 0.25, 0.275), at (-30.85, 0.25, 0.275), at (-34.05, 0.25, 0.275), at (-29.25, 0.25, 0.275)) TerminalType=ConstantVoltage Net=DCN
  CapP_1: Sink Faces=P10_DCP_L1.face(at (-35.65, 2.15, 0.275), at (-32.45, 2.15, 0.275), at (-37.25, 2.15, 0.275), at (-30.85, 2.15, 0.275), at (-34.05, 2.15, 0.275), at (-29.25, 2.15, 0.275)) TerminalType=ConstantVoltage Net=DCP
  QH_S_1: Sink Faces=P27_AC_L1.face(at (-32.825, 4.9, 0.275), at (-34.525, 4.9, 0.275)) TerminalType=ConstantVoltage Net=AC
  RSI_1: Sink Faces=P19_LSRC1_L1.face(at (-36.15, 11.8, 0.275)) TerminalType=ConstantVoltage Net=LSRC1
  RSI_2: Sink Faces=P21_LSRC2_L1.face(at (-11.35, 11.8, 0.275)) TerminalType=ConstantVoltage Net=LSRC2
  RSI_3: Sink Faces=P23_LSRC3_L1.face(at (11.35, 11.8, 0.275)) TerminalType=ConstantVoltage Net=LSRC3
  RSI_4: Sink Faces=P25_LSRC4_L1.face(at (36.15, 11.8, 0.275)) TerminalType=ConstantVoltage Net=LSRC4
setups:
  Setup1: Matrix AdaptiveFreq=100MHz Cap{MaxPass=1 MinPass=1 MinConvPass=1 PerError=30 PerRefine=30 AutoIncreaseAccuracy AccuracyLevel=High Solver_Type=Iterative} DC{SolveResOnly Cond{MaxPass=3 MinPass=1 MinConvPass=1 PerError=5 PerRefine=30} Mult{MaxPass=1 MinPass=1 MinConvPass=1 PerError=1 PerRefine=30} AccuracyLevel=Normal} AC{MaxPass=8 MinPass=2 MinConvPass=1 PerError=2 PerRefine=30 ACRLSolverType=ACA} ErrorValue=0.1
source amplitudes:
  AC:QH_S_2, AC:QH_S_3, AC:QH_S_4, AC:QL_D_1..AC:QL_D_4, DCN:CapN_3, DCN:CapN_4, DCN:CapNb_1..DCN:CapNb_4, DCN:RSN_1..DCN:RSN_4, DCP:CapP_2, DCP:CapP_3, DCP:CapP_4, DCP:CapPb_1..DCP:CapPb_4, DCP:QH_D_1..DCP:QH_D_4, LSRC1:QL_S_1, LSRC2:QL_S_2, LSRC3:QL_S_3, LSRC4:QL_S_4: AC R/L Fields 0A
  DCN:CapN_2: AC R/L Fields 1A
  AC: CG Fields 1V 0deg
  DCN, DCP, LSRC1..LSRC4: CG Fields 0V 0deg
  AC:QH_S_2, AC:QH_S_3, AC:QH_S_4, AC:QL_D_1..AC:QL_D_4, DCN:CapN_3, DCN:CapN_4, DCN:CapNb_1..DCN:CapNb_4, DCN:RSN_1..DCN:RSN_4, DCP:CapP_2, DCP:CapP_3, DCP:CapP_4, DCP:CapPb_1..DCP:CapPb_4, DCP:QH_D_1..DCP:QH_D_4, LSRC1:QL_S_1, LSRC2:QL_S_2, LSRC3:QL_S_3, LSRC4:QL_S_4: DC R/L Fields 0A
  DCN:CapN_2: DC R/L Fields 1A
