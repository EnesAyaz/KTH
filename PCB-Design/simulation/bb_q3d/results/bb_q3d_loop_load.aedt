# Ansys Electronics Desktop project, version 2024.2
materials:
  vacuum: permittivity=1
  copper: permeability=0.999991 conductivity=58000000

design BB_PL_LOOP_load (Q3D Extractor, model units mm)
options: SParamCalcMethod=EqTransLine Calculate_Lossy_Dielectrics
geometry:
  P0_DCN_L1 [copper] = polyline(z=0.17mm, xy in mm: (-28.6908, 15.5189) (-28.65, 16.701) (-28.7184, 16.7952) (-34.5, 16.8) (-34.5, 20.101) (-34.5684, 20.1952) (-43.551, 20.2) (-43.6452, 20.1316) (-43.65, 15.599) (-43.5816, 15.5048) (-28.749, 15.5) (-28.6908, 15.5189), closed, covered)
  P0_DCN_L1.sweep_along_vector((0mm, 0mm, 0.07mm))
  P1_DCN_L1 = polyline(z=0.17mm, xy in mm: (-3.8908, 15.5189) (-3.85, 20.101) (-3.949, 20.2) (-12.901, 20.2) (-13, 20.101) (-13, 16.8) (-18.751, 16.8) (-18.85, 16.701) (-18.85, 15.599) (-18.751, 15.5) (-3.949, 15.5) (-3.8908, 15.5189), closed, covered)
  P1_DCN_L1.sweep_along_vector((0mm, 0mm, 0.07mm))
  P2_DCN_L1 = polyline(z=0.17mm, xy in mm: (18.8092, 15.5189) (18.85, 16.701) (18.7816, 16.7952) (13, 16.8) (13, 20.101) (12.9316, 20.1952) (3.949, 20.2) (3.8548, 20.1316) (3.85, 15.599) (3.9184, 15.5048) (18.751, 15.5) (18.8092, 15.5189), closed, covered)
  P2_DCN_L1.sweep_along_vector((0mm, 0mm, 0.07mm))
  P3_DCN_L1 = polyline(z=0.17mm, xy in mm: (43.6092, 15.5189) (43.65, 20.101) (43.551, 20.2) (34.599, 20.2) (34.5, 20.101) (34.5, 16.8) (28.749, 16.8) (28.65, 16.701) (28.65, 15.599) (28.749, 15.5) (43.551, 15.5) (43.6092, 15.5189), closed, covered)
  P3_DCN_L1.sweep_along_vector((0mm, 0mm, 0.07mm))
  P4_DCN_L1 = polyline(z=0.17mm, xy in mm: (-36.3943, 9.5189) (-36.3505, 10.9623) (-36.1153, 11.1975) (-35.1146, 11.2005) (-34.9004, 11.0685) (-34.8505, 9.599) (-34.7515, 9.5) (-34.2995, 9.5) (-34.2053, 9.5684) (-34.2005, 10.9612) (-34.0386, 11.1851) (-33.3889, 11.2005) (-33.1649, 11.0386) (-33.1495, 9.599) (-33.0505, 9.5) (-32.5995, 9.5) (-32.5053, 9.5684) (-32.5005, 10.9612) (-32.3386, 11.1851) (-30.4106, 11.2005) (-30.1964, 11.0685) (-30.0781, 10.7853) (-29.4231, 10.7805) (-29.15, 10.8608) (-28.7908, 10.7994) (-28.75, 11.2) (-28.65, 11.299) (-28.6689, 14.9592) (-43.6092, 14.9811) (-43.6311, 11.2408) (-37.75, 11.2) (-37.7311, 9.5408) (-36.4525, 9.5) (-36.3943, 9.5189), closed, covered)
  P4_DCN_L1.sweep_along_vector((0mm, 0mm, 0.07mm))
  P5_DCN_L1 = polyline(z=0.17mm, xy in mm: (-17.3943, 9.5189) (-17.3505, 10.9623) (-17.1153, 11.1975) (-15.2389, 11.2005) (-15.0736, 11.1264) (-14.9995, 10.9611) (-14.9995, 9.599) (-14.9005, 9.5) (-14.4495, 9.5) (-14.3553, 9.5684) (-14.3505, 10.9612) (-14.1886, 11.1851) (-13.5389, 11.2005) (-13.3736, 11.1264) (-13.2995, 10.9611) (-13.2806, 9.5408) (-12.7485, 9.5) (-12.6495, 9.599) (-12.5996, 11.0685) (-12.3854, 11.2005) (-11.3847, 11.1975) (-11.1495, 10.9623) (-11.1276, 9.5408) (-9.849, 9.5) (-9.75, 9.599) (-9.75, 11.2) (-3.8908, 11.2189) (-3.8689, 14.9592) (-18.8092, 14.9811) (-18.85, 11.299) (-18.75, 11.2) (-18.75, 9.599) (-18.651, 9.5) (-17.4525, 9.5) (-17.3943, 9.5189), closed, covered)
  P5_DCN_L1.sweep_along_vector((0mm, 0mm, 0.07mm))
  P6_DCN_L1 = polyline(z=0.17mm, xy in mm: (11.1057, 9.5189) (11.1495, 10.9623) (11.3847, 11.1975) (12.3854, 11.2005) (12.5996, 11.0685) (12.6495, 9.599) (12.7485, 9.5) (13.2005, 9.5) (13.2947, 9.5684) (13.2995, 10.9612) (13.4614, 11.1851) (14.1111, 11.2005) (14.3351, 11.0386) (14.3505, 9.599) (14.4495, 9.5) (14.9005, 9.5) (14.9947, 9.5684) (14.9995, 10.9612) (15.1614, 11.1851) (17.0894, 11.2005) (17.3036, 11.0685) (17.4219, 10.7853) (18.0769, 10.7805) (18.35, 10.8608) (18.7092, 10.7994) (18.75, 11.2) (18.85, 11.299) (18.8311, 14.9592) (3.8908, 14.9811) (3.8689, 11.2408) (9.75, 11.2) (9.7689, 9.5408) (11.0475, 9.5) (11.1057, 9.5189), closed, covered)
  P6_DCN_L1.sweep_along_vector((0mm, 0mm, 0.07mm))
  P7_DCN_L1 = polyline(z=0.17mm, xy in mm: (30.1057, 9.5189) (30.1495, 10.9623) (30.3847, 11.1975) (32.2611, 11.2005) (32.4264, 11.1264) (32.5005, 10.9611) (32.5005, 9.599) (32.5995, 9.5) (33.0505, 9.5) (33.1447, 9.5684) (33.1495, 10.9612) (33.3114, 11.1851) (33.9611, 11.2005) (34.1264, 11.1264) (34.2005, 10.9611) (34.2194, 9.5408) (34.7515, 9.5) (34.8505, 9.599) (34.9004, 11.0685) (35.1146, 11.2005) (36.1153, 11.1975) (36.3505, 10.9623) (36.3724, 9.5408) (37.651, 9.5) (37.75, 9.599) (37.75, 11.2) (43.6092, 11.2189) (43.6311, 14.9592) (28.6908, 14.9811) (28.65, 11.299) (28.75, 11.2) (28.75, 9.599) (28.849, 9.5) (30.0475, 9.5) (30.1057, 9.5189), closed, covered)
  P7_DCN_L1.sweep_along_vector((0mm, 0mm, 0.07mm))
  P8_DCN_L1 = polyline(z=0.17mm, xy in mm: (39.7092, -4.1811) (39.75, 0.801) (39.651, 0.9) (-39.651, 0.9) (-39.75, 0.801) (-39.75, -4.101) (-39.651, -4.2) (39.651, -4.2) (39.7092, -4.1811), closed, covered)
  P8_DCN_L1.sweep_along_vector((0mm, 0mm, 0.07mm))
  P9_DCN_L2 = polyline(z=0mm, xy in mm: (39.75, 11.9) (43.951, 11.9) (44.0452, 11.9684) (44.0311, 20.5592) (33.5408, 20.5756) (33.5, 17.6) (28.749, 17.6) (28.6548, 17.5316) (28.65, 11.9) (28.3548, 11.8316) (28.35, 10) (27.149, 10) (27.05, 9.901) (27.05, 3.3) (20.45, 3.3) (20.45, 9.901) (20.351, 10) (19.15, 10) (19.15, 11.801) (19.0816, 11.8952) (18.85, 11.9) (18.8311, 17.5592) (14, 17.6) (14, 20.4955) (13.9316, 20.5897) (-13.901, 20.5945) (-14, 20.4955) (-14, 17.6) (-18.751, 17.6) (-18.8452, 17.5316) (-18.85, 11.9) (-19.1452, 11.8316) (-19.15, 10) (-20.351, 10) (-20.45, 9.901) (-20.45, 3.3) (-27.05, 3.3) (-27.05, 9.901) (-27.149, 10) (-28.35, 10) (-28.35, 11.801) (-28.4184, 11.8952) (-28.65, 11.9) (-28.6689, 17.5592) (-33.5, 17.6) (-33.5, 20.4955) (-33.5684, 20.5897) (-43.951, 20.6) (-44.05, 20.501) (-44.0311, 11.9408) (-39.75, 11.9) (-39.75, -4.6) (39.75, -4.6) (39.75, 11.9), closed, covered)
  P9_DCN_L2_h0 = polyline(z=0mm, xy in mm: (-29.2831, 10.0203) (-29.4985, 10.1768) (-29.5597, 10.5631) (-29.4032, 10.7785) (-29.0169, 10.8397) (-28.8015, 10.6832) (-28.7192, 10.43) (-28.8015, 10.1768) (-29.15, 9.9992) (-29.2831, 10.0203), closed, covered)
  P9_DCN_L2_h1 = polyline(z=0mm, xy in mm: (18.2169, 10.0203) (18.0015, 10.1768) (17.9403, 10.5631) (18.0968, 10.7785) (18.4831, 10.8397) (18.6985, 10.6832) (18.7808, 10.43) (18.6985, 10.1768) (18.35, 9.9992) (18.2169, 10.0203), closed, covered)
  P9_DCN_L2_h2 = polyline(z=0mm, xy in mm: (-29.9811, 8.9703) (-30.1965, 9.1268) (-30.2577, 9.5131) (-30.1012, 9.7285) (-29.7149, 9.7897) (-29.4995, 9.6332) (-29.4172, 9.38) (-29.4995, 9.1268) (-29.848, 8.9492) (-29.9811, 8.9703), closed, covered)
  P9_DCN_L2_h3 = polyline(z=0mm, xy in mm: (17.5189, 8.9703) (17.3035, 9.1268) (17.2423, 9.5131) (17.3988, 9.7285) (17.7851, 9.7897) (18.0005, 9.6332) (18.0828, 9.38) (18.0005, 9.1268) (17.652, 8.9492) (17.5189, 8.9703), closed, covered)
  P9_DCN_L2_h4 = polyline(z=0mm, xy in mm: (-17.7851, 8.6103) (-18.0005, 8.7668) (-18.0617, 9.1531) (-17.9052, 9.3685) (-17.5189, 9.4297) (-17.3035, 9.2732) (-17.2212, 9.02) (-17.3035, 8.7668) (-17.652, 8.5892) (-17.7851, 8.6103), closed, covered)
  P9_DCN_L2_h5 = polyline(z=0mm, xy in mm: (29.7149, 8.6103) (29.4995, 8.7668) (29.4383, 9.1531) (29.5948, 9.3685) (29.9811, 9.4297) (30.1965, 9.2732) (30.2788, 9.02) (30.1965, 8.7668) (29.848, 8.5892) (29.7149, 8.6103), closed, covered)
  P9_DCN_L2_h6 = polyline(z=0mm, xy in mm: (-18.5101, 6.59) (-18.7852, 6.9075) (-18.7852, 7.1925) (-18.5573, 7.5609) (-18.7808, 7.97) (-18.6985, 8.2232) (-18.35, 8.4008) (-18.0968, 8.3185) (-17.9403, 8.1031) (-17.9403, 7.8369) (-18.1029, 7.5886) (-17.8746, 7.3234) (-17.7944, 7.05) (-17.9689, 6.6679) (-18.372, 6.5495) (-18.5101, 6.59), closed, covered)
  P9_DCN_L2_h7 = polyline(z=0mm, xy in mm: (28.9899, 6.59) (28.7148, 6.9075) (28.7148, 7.1925) (28.9427, 7.5609) (28.7192, 7.97) (28.8015, 8.2232) (29.15, 8.4008) (29.4032, 8.3185) (29.5597, 8.1031) (29.5597, 7.8369) (29.3971, 7.5886) (29.6254, 7.3234) (29.7056, 7.05) (29.5311, 6.6679) (29.128, 6.5495) (28.9899, 6.59), closed, covered)
  P9_DCN_L2_h8 = polyline(z=0mm, xy in mm: (-0.1333, 4.405) (-0.7289, 4.5695) (-1.2988, 5.0563) (-1.5269, 5.5039) (-1.5857, 6.2511) (-1.4305, 6.7289) (-0.9437, 7.2988) (-0.4961, 7.5269) (0.2511, 7.5857) (0.7289, 7.4305) (1.2988, 6.9437) (1.5269, 6.4961) (1.5857, 5.7489) (1.4305, 5.2711) (0.9437, 4.7012) (0.4961, 4.4731) (-0.0629, 4.3995) (-0.1333, 4.405), closed, covered)
  P9_DCN_L2_h9 = polyline(z=0mm, xy in mm: (-29.2831, 5.7203) (-29.5597, 5.9969) (-29.5597, 6.2631) (-29.3971, 6.5114) (-29.6254, 6.7766) (-29.7056, 7.05) (-29.5311, 7.4321) (-29.128, 7.5505) (-28.7746, 7.3234) (-28.6944, 7.05) (-28.9427, 6.5391) (-28.7403, 6.2631) (-28.7403, 5.9969) (-28.8968, 5.7815) (-29.15, 5.6992) (-29.2831, 5.7203), closed, covered)
  P9_DCN_L2_h10 = polyline(z=0mm, xy in mm: (18.2169, 5.7203) (17.9403, 5.9969) (17.9403, 6.2631) (18.1029, 6.5114) (17.8746, 6.7766) (17.7944, 7.05) (17.9689, 7.4321) (18.372, 7.5505) (18.7254, 7.3234) (18.8056, 7.05) (18.5573, 6.5391) (18.7597, 6.2631) (18.7597, 5.9969) (18.6032, 5.7815) (18.35, 5.6992) (18.2169, 5.7203), closed, covered)
  P9_DCN_L2_h11 = polyline(z=0mm, xy in mm: (-29.9811, 4.6703) (-30.1965, 4.8268) (-30.2577, 5.2131) (-30.1012, 5.4285) (-29.7149, 5.4897) (-29.4995, 5.3332) (-29.4172, 5.08) (-29.4995, 4.8268) (-29.848, 4.6492) (-29.9811, 4.6703), closed, covered)
  P9_DCN_L2_h12 = polyline(z=0mm, xy in mm: (17.5189, 4.6703) (17.3035, 4.8268) (17.2423, 5.2131) (17.3988, 5.4285) (17.7851, 5.4897) (18.0005, 5.3332) (18.0828, 5.08) (18.0005, 4.8268) (17.652, 4.6492) (17.5189, 4.6703), closed, covered)
  P9_DCN_L2_h13 = polyline(z=0mm, xy in mm: (-17.7851, 4.3103) (-18.0005, 4.4668) (-18.0617, 4.8531) (-17.9052, 5.0685) (-17.5189, 5.1297) (-17.3035, 4.9732) (-17.2212, 4.72) (-17.3035, 4.4668) (-17.652, 4.2892) (-17.7851, 4.3103), closed, covered)
  P9_DCN_L2_h14 = polyline(z=0mm, xy in mm: (29.7149, 4.3103) (29.4995, 4.4668) (29.4383, 4.8531) (29.5948, 5.0685) (29.9811, 5.1297) (30.1965, 4.9732) (30.2788, 4.72) (30.1965, 4.4668) (29.848, 4.2892) (29.7149, 4.3103), closed, covered)
  P9_DCN_L2_h15 = polyline(z=0mm, xy in mm: (-18.4831, 3.2603) (-18.6985, 3.4168) (-18.7597, 3.8031) (-18.6032, 4.0185) (-18.2169, 4.0797) (-18.0015, 3.9232) (-17.9192, 3.67) (-18.0015, 3.4168) (-18.35, 3.2392) (-18.4831, 3.2603), closed, covered)
  P9_DCN_L2_h16 = polyline(z=0mm, xy in mm: (29.0169, 3.2603) (28.8015, 3.4168) (28.7403, 3.8031) (28.8968, 4.0185) (29.2831, 4.0797) (29.4985, 3.9232) (29.5808, 3.67) (29.4985, 3.4168) (29.15, 3.2392) (29.0169, 3.2603), closed, covered)
  P9_DCN_L2_h17 = polyline(z=0mm, xy in mm: (-35.7101, 2.04) (-35.9852, 2.3575) (-35.9852, 2.6425) (-35.8311, 2.8821) (-35.572, 3.0005) (-35.2899, 2.96) (-35.0724, 2.7997) (-34.672, 3.0005) (-34.3899, 2.96) (-34.1724, 2.7997) (-33.772, 3.0005) (-33.4899, 2.96) (-33.2724, 2.7997) (-32.872, 3.0005) (-32.5899, 2.96) (-32.3724, 2.7997) (-31.972, 3.0005) (-31.6899, 2.96) (-31.4724, 2.7997) (-31.072, 3.0005) (-30.7899, 2.96) (-30.5724, 2.7997) (-30.172, 3.0005) (-29.8899, 2.96) (-29.6724, 2.7997) (-29.4101, 2.96) (-29.128, 3.0005) (-28.7746, 2.7734) (-28.6944, 2.5) (-28.7746, 2.2266) (-29.128, 1.9995) (-29.4101, 2.04) (-29.6276, 2.2003) (-30.028, 1.9995) (-30.3101, 2.04) (-30.5276, 2.2003) (-30.928, 1.9995) (-31.2101, 2.04) (-31.4276, 2.2003) (-31.828, 1.9995) (-32.1101, 2.04) (-32.3276, 2.2003) (-32.728, 1.9995) (-33.0101, 2.04) (-33.2276, 2.2003) (-33.628, 1.9995) (-33.9101, 2.04) (-34.1276, 2.2003) (-34.528, 1.9995) (-34.8101, 2.04) (-35.0276, 2.2003) (-35.2899, 2.04) (-35.572, 1.9995) (-35.7101, 2.04), closed, covered)
  P9_DCN_L2_h18 = polyline(z=0mm, xy in mm: (-18.5101, 2.04) (-18.7852, 2.3575) (-18.7852, 2.6425) (-18.6311, 2.8821) (-18.372, 3.0005) (-18.0899, 2.96) (-17.8724, 2.7997) (-17.472, 3.0005) (-17.1899, 2.96) (-16.9724, 2.7997) (-16.572, 3.0005) (-16.2899, 2.96) (-16.0724, 2.7997) (-15.672, 3.0005) (-15.3899, 2.96) (-15.1724, 2.7997) (-14.772, 3.0005) (-14.4899, 2.96) (-14.2724, 2.7997) (-13.872, 3.0005) (-13.5899, 2.96) (-13.3724, 2.7997) (-12.972, 3.0005) (-12.6899, 2.96) (-12.4724, 2.7997) (-12.2101, 2.96) (-11.928, 3.0005) (-11.5746, 2.7734) (-11.4944, 2.5) (-11.5746, 2.2266) (-11.928, 1.9995) (-12.2101, 2.04) (-12.4276, 2.2003) (-12.828, 1.9995) (-13.1101, 2.04) (-13.3276, 2.2003) (-13.728, 1.9995) (-14.0101, 2.04) (-14.2276, 2.2003) (-14.628, 1.9995) (-14.9101, 2.04) (-15.1276, 2.2003) (-15.528, 1.9995) (-15.8101, 2.04) (-16.0276, 2.2003) (-16.428, 1.9995) (-16.7101, 2.04) (-16.9276, 2.2003) (-17.328, 1.9995) (-17.6101, 2.04) (-17.8276, 2.2003) (-18.0899, 2.04) (-18.372, 1.9995) (-18.5101, 2.04), closed, covered)
  P9_DCN_L2_h19 = polyline(z=0mm, xy in mm: (11.7899, 2.04) (11.5148, 2.3575) (11.5148, 2.6425) (11.6689, 2.8821) (11.928, 3.0005) (12.2101, 2.96) (12.4276, 2.7997) (12.828, 3.0005) (13.1101, 2.96) (13.3276, 2.7997) (13.728, 3.0005) (14.0101, 2.96) (14.2276, 2.7997) (14.628, 3.0005) (14.9101, 2.96) (15.1276, 2.7997) (15.528, 3.0005) (15.8101, 2.96) (16.0276, 2.7997) (16.428, 3.0005) (16.7101, 2.96) (16.9276, 2.7997) (17.328, 3.0005) (17.6101, 2.96) (17.8276, 2.7997) (18.0899, 2.96) (18.372, 3.0005) (18.7254, 2.7734) (18.8056, 2.5) (18.7254, 2.2266) (18.372, 1.9995) (18.0899, 2.04) (17.8724, 2.2003) (17.472, 1.9995) (17.1899, 2.04) (16.9724, 2.2003) (16.572, 1.9995) (16.2899, 2.04) (16.0724, 2.2003) (15.672, 1.9995) (15.3899, 2.04) (15.1724, 2.2003) (14.772, 1.9995) (14.4899, 2.04) (14.2724, 2.2003) (13.872, 1.9995) (13.5899, 2.04) (13.3724, 2.2003) (12.972, 1.9995) (12.6899, 2.04) (12.4724, 2.2003) (12.2101, 2.04) (11.928, 1.9995) (11.7899, 2.04), closed, covered)
  P9_DCN_L2_h20 = polyline(z=0mm, xy in mm: (28.9899, 2.04) (28.7148, 2.3575) (28.7148, 2.6425) (28.8689, 2.8821) (29.128, 3.0005) (29.4101, 2.96) (29.6276, 2.7997) (30.028, 3.0005) (30.3101, 2.96) (30.5276, 2.7997) (30.928, 3.0005) (31.2101, 2.96) (31.4276, 2.7997) (31.828, 3.0005) (32.1101, 2.96) (32.3276, 2.7997) (32.728, 3.0005) (33.0101, 2.96) (33.2276, 2.7997) (33.628, 3.0005) (33.9101, 2.96) (34.1276, 2.7997) (34.528, 3.0005) (34.8101, 2.96) (35.0276, 2.7997) (35.2899, 2.96) (35.572, 3.0005) (35.9254, 2.7734) (36.0056, 2.5) (35.9254, 2.2266) (35.572, 1.9995) (35.2899, 2.04) (35.0724, 2.2003) (34.672, 1.9995) (34.3899, 2.04) (34.1724, 2.2003) (33.772, 1.9995) (33.4899, 2.04) (33.2724, 2.2003) (32.872, 1.9995) (32.5899, 2.04) (32.3724, 2.2003) (31.972, 1.9995) (31.6899, 2.04) (31.4724, 2.2003) (31.072, 1.9995) (30.7899, 2.04) (30.5724, 2.2003) (30.172, 1.9995) (29.8899, 2.04) (29.6724, 2.2003) (29.4101, 2.04) (29.128, 1.9995) (28.9899, 2.04), closed, covered)
  P9_DCN_L2.subtract(P9_DCN_L2_h0..P9_DCN_L2_h20)
  P9_DCN_L2.sweep_along_vector((0mm, 0mm, 0.07mm))
  P10_DCN_L4 = polyline(z=-1.44mm, xy in mm: (-37.025, 13.225) (-37.025, 16.575) (-37.425, 16.575) (-37.425, 12.025) (-37.025, 12.025) (-37.025, 13.225), closed, covered)
  P10_DCN_L4.sweep_along_vector((0mm, 0mm, 0.07mm))
  P11_DCN_L4 = polyline(z=-1.44mm, xy in mm: (-10.075, 13.225) (-10.075, 16.575) (-10.475, 16.575) (-10.475, 12.025) (-10.075, 12.025) (-10.075, 13.225), closed, covered)
  P11_DCN_L4.sweep_along_vector((0mm, 0mm, 0.07mm))
  P12_DCN_L4 = polyline(z=-1.44mm, xy in mm: (10.475, 13.225) (10.475, 16.575) (10.075, 16.575) (10.075, 12.025) (10.475, 12.025) (10.475, 13.225), closed, covered)
  P12_DCN_L4.sweep_along_vector((0mm, 0mm, 0.07mm))
  P13_DCN_L4 = polyline(z=-1.44mm, xy in mm: (37.425, 13.225) (37.425, 16.575) (37.025, 16.575) (37.025, 12.025) (37.425, 12.025) (37.425, 13.225), closed, covered)
  P13_DCN_L4.sweep_along_vector((0mm, 0mm, 0.07mm))
  P14_DCN_L4 = polyline(z=-1.44mm, xy in mm: (-28.4908, -1.1811) (-28.45, 0.851) (-28.5184, 0.9452) (-37.951, 0.95) (-38.0452, 0.8816) (-38.05, -1.101) (-37.9816, -1.1952) (-28.549, -1.2) (-28.4908, -1.1811), closed, covered)
  P14_DCN_L4.sweep_along_vector((0mm, 0mm, 0.07mm))
  P15_DCN_L4 = polyline(z=-1.44mm, xy in mm: (-9.4908, -1.1811) (-9.45, 0.851) (-9.5184, 0.9452) (-18.951, 0.95) (-19.0452, 0.8816) (-19.05, -1.101) (-18.9816, -1.1952) (-9.549, -1.2) (-9.4908, -1.1811), closed, covered)
  P15_DCN_L4.sweep_along_vector((0mm, 0mm, 0.07mm))
  P16_DCN_L4 = polyline(z=-1.44mm, xy in mm: (19.0092, -1.1811) (19.05, 0.851) (18.9816, 0.9452) (9.549, 0.95) (9.4548, 0.8816) (9.45, -1.101) (9.5184, -1.1952) (18.951, -1.2) (19.0092, -1.1811), closed, covered)
  P16_DCN_L4.sweep_along_vector((0mm, 0mm, 0.07mm))
  P17_DCN_L4 = polyline(z=-1.44mm, xy in mm: (38.0092, -1.1811) (38.05, 0.851) (37.9816, 0.9452) (28.549, 0.95) (28.4548, 0.8816) (28.45, -1.101) (28.5184, -1.1952) (37.951, -1.2) (38.0092, -1.1811), closed, covered)
  P17_DCN_L4.sweep_along_vector((0mm, 0mm, 0.07mm))
  P18_DCP_L1 [copper] = polyline(z=0.17mm, xy in mm: (-28.7908, 1.5189) (-28.75, 4.501) (-28.8184, 4.5952) (-30.1057, 4.5811) (-30.1495, 3.1377) (-30.2785, 2.9494) (-30.4106, 2.8995) (-31.3854, 2.8995) (-31.5996, 3.0315) (-31.6495, 4.501) (-31.7179, 4.5952) (-32.2005, 4.6) (-32.2947, 4.5316) (-32.2995, 3.1388) (-32.3736, 2.9736) (-32.5389, 2.8995) (-33.1886, 2.9149) (-33.3351, 3.0614) (-33.3505, 4.501) (-33.4189, 4.5952) (-33.9005, 4.6) (-33.9947, 4.5316) (-33.9995, 3.1388) (-34.0736, 2.9736) (-34.2389, 2.8995) (-34.8886, 2.9149) (-35.0351, 3.0614) (-35.0505, 4.501) (-35.1189, 4.5952) (-37.651, 4.6) (-37.7452, 4.5316) (-37.75, 1.599) (-37.6816, 1.5048) (-28.849, 1.5) (-28.7908, 1.5189), closed, covered)
  P18_DCP_L1.sweep_along_vector((0mm, 0mm, 0.07mm))
  P19_DCP_L1 = polyline(z=0.17mm, xy in mm: (-9.7908, 1.5189) (-9.75, 4.501) (-9.8184, 4.5952) (-12.4087, 4.5811) (-12.4495, 3.1388) (-12.5236, 2.9736) (-12.6889, 2.8995) (-13.3386, 2.9149) (-13.4851, 3.0614) (-13.5005, 4.501) (-13.5995, 4.6) (-14.0505, 4.6) (-14.1447, 4.5316) (-14.1495, 3.1388) (-14.3114, 2.9149) (-14.9612, 2.8995) (-15.1851, 3.0614) (-15.2005, 4.501) (-15.2995, 4.6) (-15.7515, 4.6) (-15.8457, 4.5316) (-15.9029, 4.3191) (-15.8535, 3.1377) (-16.0887, 2.9025) (-17.1153, 2.9025) (-17.3036, 3.0315) (-17.3724, 3.2787) (-17.4525, 3.3195) (-18.0769, 3.3195) (-18.35, 3.2392) (-18.651, 3.3195) (-18.7452, 3.2511) (-18.75, 1.599) (-18.6816, 1.5048) (-9.849, 1.5) (-9.7908, 1.5189), closed, covered)
  P19_DCP_L1.sweep_along_vector((0mm, 0mm, 0.07mm))
  P20_DCP_L1 = polyline(z=0.17mm, xy in mm: (18.7092, 1.5189) (18.75, 4.501) (18.6816, 4.5952) (17.3943, 4.5811) (17.3505, 3.1377) (17.2215, 2.9494) (17.0894, 2.8995) (16.1146, 2.8995) (15.9004, 3.0315) (15.8505, 4.501) (15.7821, 4.5952) (15.2995, 4.6) (15.2053, 4.5316) (15.2005, 3.1388) (15.1264, 2.9736) (14.9611, 2.8995) (14.3114, 2.9149) (14.1649, 3.0614) (14.1495, 4.501) (14.0811, 4.5952) (13.5995, 4.6) (13.5053, 4.5316) (13.5005, 3.1388) (13.4264, 2.9736) (13.2611, 2.8995) (12.6114, 2.9149) (12.4649, 3.0614) (12.4495, 4.501) (12.3811, 4.5952) (9.849, 4.6) (9.7548, 4.5316) (9.75, 1.599) (9.8184, 1.5048) (18.651, 1.5) (18.7092, 1.5189), closed, covered)
  P20_DCP_L1.sweep_along_vector((0mm, 0mm, 0.07mm))
  P21_DCP_L1 = polyline(z=0.17mm, xy in mm: (37.7092, 1.5189) (37.75, 4.501) (37.6816, 4.5952) (35.0913, 4.5811) (35.0505, 3.1388) (34.9764, 2.9736) (34.8111, 2.8995) (34.1614, 2.9149) (34.0149, 3.0614) (33.9995, 4.501) (33.9005, 4.6) (33.4495, 4.6) (33.3553, 4.5316) (33.3505, 3.1388) (33.1886, 2.9149) (32.5388, 2.8995) (32.3149, 3.0614) (32.2995, 4.501) (32.2005, 4.6) (31.7485, 4.6) (31.6543, 4.5316) (31.5971, 4.3191) (31.6465, 3.1377) (31.4113, 2.9025) (30.3847, 2.9025) (30.1964, 3.0315) (30.1276, 3.2787) (30.0475, 3.3195) (29.4231, 3.3195) (29.15, 3.2392) (28.849, 3.3195) (28.7548, 3.2511) (28.75, 1.599) (28.8184, 1.5048) (37.651, 1.5) (37.7092, 1.5189), closed, covered)
  P21_DCP_L1.sweep_along_vector((0mm, 0mm, 0.07mm))
  P22_DCP_L3 = polyline(z=-1.27mm, xy in mm: (39.75, -0.8373) (39.6204, -0.7431) (39.3601, -0.96) (39.078, -1.0005) (38.8189, -0.8821) (38.5812, -0.4988) (38.8189, -0.1179) (39.078, 0.0005) (39.3601, -0.04) (39.6286, -0.2592) (39.75, -0.1627) (39.75, 4.501) (39.651, 4.6) (30.3251, 4.6) (30.1012, 4.3715) (29.848, 4.2892) (29.5948, 4.3715) (29.3709, 4.6) (24.1975, 4.6) (23.822, 4.3995) (23.5399, 4.44) (23.3025, 4.6) (0.8065, 4.6) (0.0629, 4.3995) (-0.2511, 4.4143) (-0.8065, 4.6) (-17.1749, 4.6) (-17.3988, 4.3715) (-17.652, 4.2892) (-17.9052, 4.3715) (-18.1291, 4.6) (-23.3025, 4.6) (-23.678, 4.3995) (-23.9601, 4.44) (-24.1975, 4.6) (-39.651, 4.6) (-39.75, 4.501) (-39.75, -0.1627) (-39.6204, -0.2569) (-39.3601, -0.04) (-39.078, 0.0005) (-38.8189, -0.1179) (-38.5812, -0.5012) (-38.8189, -0.8821) (-39.078, -1.0005) (-39.3601, -0.96) (-39.6286, -0.7408) (-39.7358, -0.7862) (-39.75, -4.6) (39.75, -4.6) (39.75, -0.8373), closed, covered)
  P22_DCP_L3_h0 = polyline(z=-1.27mm, xy in mm: (-18.4831, 3.2603) (-18.6985, 3.4168) (-18.7597, 3.8031) (-18.6032, 4.0185) (-18.2169, 4.0797) (-18.0015, 3.9232) (-17.9192, 3.67) (-18.0015, 3.4168) (-18.35, 3.2392) (-18.4831, 3.2603), closed, covered)
  P22_DCP_L3_h1 = polyline(z=-1.27mm, xy in mm: (29.0169, 3.2603) (28.8015, 3.4168) (28.7403, 3.8031) (28.8968, 4.0185) (29.2831, 4.0797) (29.4985, 3.9232) (29.5808, 3.67) (29.4985, 3.4168) (29.15, 3.2392) (29.0169, 3.2603), closed, covered)
  P22_DCP_L3_h2 = polyline(z=-1.27mm, xy in mm: (-38.1754, -0.96) (-38.3908, -0.7734) (-38.5342, -0.4988) (-38.3908, -0.2266) (-38.1754, -0.04) (-37.7553, -0.04) (-37.54, -0.2266) (-37.3966, -0.5012) (-37.6343, -0.8821) (-38.0373, -1.0005) (-38.1754, -0.96), closed, covered)
  P22_DCP_L3_h3 = polyline(z=-1.27mm, xy in mm: (-36.9908, -0.96) (-37.2061, -0.7734) (-37.3496, -0.4988) (-37.2061, -0.2266) (-36.9908, -0.04) (-36.5707, -0.04) (-36.3554, -0.2266) (-36.212, -0.5012) (-36.4496, -0.8821) (-36.8527, -1.0005) (-36.9908, -0.96), closed, covered)
  P22_DCP_L3_h4 = polyline(z=-1.27mm, xy in mm: (-35.8062, -0.96) (-36.0215, -0.7734) (-36.165, -0.4988) (-36.0215, -0.2266) (-35.8062, -0.04) (-35.3861, -0.04) (-35.1708, -0.2266) (-35.0273, -0.5012) (-35.265, -0.8821) (-35.6681, -1.0005) (-35.8062, -0.96), closed, covered)
  P22_DCP_L3_h5 = polyline(z=-1.27mm, xy in mm: (-34.6216, -0.96) (-34.8369, -0.7734) (-34.9804, -0.4988) (-34.8369, -0.2266) (-34.6216, -0.04) (-34.2015, -0.04) (-33.9862, -0.2266) (-33.8427, -0.5012) (-34.0804, -0.8821) (-34.4835, -1.0005) (-34.6216, -0.96), closed, covered)
  P22_DCP_L3_h6 = polyline(z=-1.27mm, xy in mm: (-33.437, -0.96) (-33.6523, -0.7734) (-33.7957, -0.4988) (-33.6523, -0.2266) (-33.437, -0.04) (-33.0169, -0.04) (-32.8015, -0.2266) (-32.6581, -0.5012) (-32.8958, -0.8821) (-33.2989, -1.0005) (-33.437, -0.96), closed, covered)
  P22_DCP_L3_h7 = polyline(z=-1.27mm, xy in mm: (-32.2524, -0.96) (-32.4677, -0.7734) (-32.6111, -0.4988) (-32.4677, -0.2266) (-32.2524, -0.04) (-31.8323, -0.04) (-31.6169, -0.2266) (-31.4735, -0.5012) (-31.7112, -0.8821) (-32.1143, -1.0005) (-32.2524, -0.96), closed, covered)
  P22_DCP_L3_h8 = polyline(z=-1.27mm, xy in mm: (-31.0677, -0.96) (-31.2831, -0.7734) (-31.4265, -0.4988) (-31.2831, -0.2266) (-31.0677, -0.04) (-30.6476, -0.04) (-30.4323, -0.2266) (-30.2889, -0.5012) (-30.5266, -0.8821) (-30.9297, -1.0005) (-31.0677, -0.96), closed, covered)
  P22_DCP_L3_h9 = polyline(z=-1.27mm, xy in mm: (-29.8831, -0.96) (-30.0985, -0.7734) (-30.2419, -0.4988) (-30.0985, -0.2266) (-29.8831, -0.04) (-29.463, -0.04) (-29.2477, -0.2266) (-29.1043, -0.5012) (-29.3419, -0.8821) (-29.745, -1.0005) (-29.8831, -0.96), closed, covered)
  P22_DCP_L3_h10 = polyline(z=-1.27mm, xy in mm: (-28.6985, -0.96) (-28.9138, -0.7734) (-29.0573, -0.4988) (-28.9138, -0.2266) (-28.6985, -0.04) (-28.2784, -0.04) (-28.0631, -0.2266) (-27.9196, -0.5012) (-28.1573, -0.8821) (-28.5604, -1.0005) (-28.6985, -0.96), closed, covered)
  P22_DCP_L3_h11 = polyline(z=-1.27mm, xy in mm: (-27.5139, -0.96) (-27.7292, -0.7734) (-27.8727, -0.4988) (-27.7292, -0.2266) (-27.5139, -0.04) (-27.0938, -0.04) (-26.8785, -0.2266) (-26.735, -0.5012) (-26.9727, -0.8821) (-27.3758, -1.0005) (-27.5139, -0.96), closed, covered)
  P22_DCP_L3_h12 = polyline(z=-1.27mm, xy in mm: (-26.3293, -0.96) (-26.5446, -0.7734) (-26.688, -0.4988) (-26.5446, -0.2266) (-26.3293, -0.04) (-25.9092, -0.04) (-25.6939, -0.2266) (-25.5504, -0.5012) (-25.7881, -0.8821) (-26.1912, -1.0005) (-26.3293, -0.96), closed, covered)
  P22_DCP_L3_h13 = polyline(z=-1.27mm, xy in mm: (-25.1447, -0.96) (-25.36, -0.7734) (-25.5034, -0.4988) (-25.36, -0.2266) (-25.1447, -0.04) (-24.7246, -0.04) (-24.5092, -0.2266) (-24.3658, -0.5012) (-24.6035, -0.8821) (-25.0066, -1.0005) (-25.1447, -0.96), closed, covered)
  P22_DCP_L3_h14 = polyline(z=-1.27mm, xy in mm: (-23.9601, -0.96) (-24.1754, -0.7734) (-24.3188, -0.4988) (-24.1754, -0.2266) (-23.9601, -0.04) (-23.5399, -0.04) (-23.3246, -0.2266) (-23.1812, -0.5012) (-23.4189, -0.8821) (-23.822, -1.0005) (-23.9601, -0.96), closed, covered)
  P22_DCP_L3_h15 = polyline(z=-1.27mm, xy in mm: (-22.7754, -0.96) (-22.9908, -0.7734) (-23.1342, -0.4988) (-22.9908, -0.2266) (-22.7754, -0.04) (-22.3553, -0.04) (-22.14, -0.2266) (-21.9966, -0.5012) (-22.2343, -0.8821) (-22.6373, -1.0005) (-22.7754, -0.96), closed, covered)
  P22_DCP_L3_h16 = polyline(z=-1.27mm, xy in mm: (-21.5908, -0.96) (-21.8061, -0.7734) (-21.9496, -0.4988) (-21.8061, -0.2266) (-21.5908, -0.04) (-21.1707, -0.04) (-20.9554, -0.2266) (-20.812, -0.5012) (-21.0496, -0.8821) (-21.4527, -1.0005) (-21.5908, -0.96), closed, covered)
  P22_DCP_L3_h17 = polyline(z=-1.27mm, xy in mm: (-20.4062, -0.96) (-20.6215, -0.7734) (-20.765, -0.4988) (-20.6215, -0.2266) (-20.4062, -0.04) (-19.9861, -0.04) (-19.7708, -0.2266) (-19.6273, -0.5012) (-19.865, -0.8821) (-20.2681, -1.0005) (-20.4062, -0.96), closed, covered)
  P22_DCP_L3_h18 = polyline(z=-1.27mm, xy in mm: (-19.2216, -0.96) (-19.4369, -0.7734) (-19.5804, -0.4988) (-19.4369, -0.2266) (-19.2216, -0.04) (-18.8015, -0.04) (-18.5862, -0.2266) (-18.4427, -0.5012) (-18.6804, -0.8821) (-19.0835, -1.0005) (-19.2216, -0.96), closed, covered)
  P22_DCP_L3_h19 = polyline(z=-1.27mm, xy in mm: (-18.037, -0.96) (-18.2523, -0.7734) (-18.3957, -0.4988) (-18.2523, -0.2266) (-18.037, -0.04) (-17.6169, -0.04) (-17.4015, -0.2266) (-17.2581, -0.5012) (-17.4958, -0.8821) (-17.8989, -1.0005) (-18.037, -0.96), closed, covered)
  P22_DCP_L3_h20 = polyline(z=-1.27mm, xy in mm: (-16.8524, -0.96) (-17.0677, -0.7734) (-17.2111, -0.4988) (-17.0677, -0.2266) (-16.8524, -0.04) (-16.4323, -0.04) (-16.2169, -0.2266) (-16.0735, -0.5012) (-16.3112, -0.8821) (-16.7143, -1.0005) (-16.8524, -0.96), closed, covered)
  P22_DCP_L3_h21 = polyline(z=-1.27mm, xy in mm: (-15.6677, -0.96) (-15.8831, -0.7734) (-16.0265, -0.4988) (-15.8831, -0.2266) (-15.6677, -0.04) (-15.2476, -0.04) (-15.0323, -0.2266) (-14.8889, -0.5012) (-15.1266, -0.8821) (-15.5297, -1.0005) (-15.6677, -0.96), closed, covered)
  P22_DCP_L3_h22 = polyline(z=-1.27mm, xy in mm: (-14.4831, -0.96) (-14.6985, -0.7734) (-14.8419, -0.4988) (-14.6985, -0.2266) (-14.4831, -0.04) (-14.063, -0.04) (-13.8477, -0.2266) (-13.7043, -0.5012) (-13.9419, -0.8821) (-14.345, -1.0005) (-14.4831, -0.96), closed, covered)
  P22_DCP_L3_h23 = polyline(z=-1.27mm, xy in mm: (-13.2985, -0.96) (-13.5138, -0.7734) (-13.6573, -0.4988) (-13.5138, -0.2266) (-13.2985, -0.04) (-12.8784, -0.04) (-12.6631, -0.2266) (-12.5196, -0.5012) (-12.7573, -0.8821) (-13.1604, -1.0005) (-13.2985, -0.96), closed, covered)
  P22_DCP_L3_h24 = polyline(z=-1.27mm, xy in mm: (-12.1139, -0.96) (-12.3292, -0.7734) (-12.4727, -0.4988) (-12.3292, -0.2266) (-12.1139, -0.04) (-11.6938, -0.04) (-11.4785, -0.2266) (-11.335, -0.5012) (-11.5727, -0.8821) (-11.9758, -1.0005) (-12.1139, -0.96), closed, covered)
  P22_DCP_L3_h25 = polyline(z=-1.27mm, xy in mm: (-10.9293, -0.96) (-11.1446, -0.7734) (-11.288, -0.4988) (-11.1446, -0.2266) (-10.9293, -0.04) (-10.5092, -0.04) (-10.2939, -0.2266) (-10.1504, -0.5012) (-10.3881, -0.8821) (-10.7912, -1.0005) (-10.9293, -0.96), closed, covered)
  P22_DCP_L3_h26 = polyline(z=-1.27mm, xy in mm: (-9.7447, -0.96) (-9.96, -0.7734) (-10.1034, -0.4988) (-9.96, -0.2266) (-9.7447, -0.04) (-9.3246, -0.04) (-9.1092, -0.2266) (-8.9658, -0.5012) (-9.2035, -0.8821) (-9.6066, -1.0005) (-9.7447, -0.96), closed, covered)
  P22_DCP_L3_h27 = polyline(z=-1.27mm, xy in mm: (-8.56, -0.96) (-8.7754, -0.7734) (-8.9188, -0.4988) (-8.7754, -0.2266) (-8.5601, -0.04) (-8.1399, -0.04) (-7.8648, -0.3575) (-7.8648, -0.6425) (-8.1399, -0.96) (-8.422, -1.0005) (-8.56, -0.96), closed, covered)
  P22_DCP_L3_h28 = polyline(z=-1.27mm, xy in mm: (-7.3601, -0.96) (-7.6352, -0.6425) (-7.6352, -0.3575) (-7.3601, -0.04) (-6.9399, -0.04) (-6.6648, -0.3575) (-6.6648, -0.6425) (-6.9399, -0.96) (-7.222, -1.0005) (-7.3601, -0.96), closed, covered)
  P22_DCP_L3_h29 = polyline(z=-1.27mm, xy in mm: (-6.1601, -0.96) (-6.4352, -0.6425) (-6.4352, -0.3575) (-6.1601, -0.04) (-5.7399, -0.04) (-5.4648, -0.3575) (-5.4648, -0.6425) (-5.7399, -0.96) (-6.022, -1.0005) (-6.1601, -0.96), closed, covered)
  P22_DCP_L3_h30 = polyline(z=-1.27mm, xy in mm: (-4.9601, -0.96) (-5.2352, -0.6425) (-5.2352, -0.3575) (-4.9601, -0.04) (-4.5399, -0.04) (-4.2648, -0.3575) (-4.2648, -0.6425) (-4.5399, -0.96) (-4.822, -1.0005) (-4.9601, -0.96), closed, covered)
  P22_DCP_L3_h31 = polyline(z=-1.27mm, xy in mm: (-3.7601, -0.96) (-4.0352, -0.6425) (-4.0352, -0.3575) (-3.7601, -0.04) (-3.3399, -0.04) (-3.0648, -0.3575) (-3.0648, -0.6425) (-3.3399, -0.96) (-3.622, -1.0005) (-3.7601, -0.96), closed, covered)
  P22_DCP_L3_h32 = polyline(z=-1.27mm, xy in mm: (-2.56, -0.96) (-2.8352, -0.6425) (-2.8352, -0.3575) (-2.5601, -0.04) (-2.1399, -0.04) (-1.8648, -0.3575) (-1.8648, -0.6425) (-2.1399, -0.96) (-2.422, -1.0005) (-2.56, -0.96), closed, covered)
  P22_DCP_L3_h33 = polyline(z=-1.27mm, xy in mm: (-1.3601, -0.96) (-1.6352, -0.6425) (-1.6352, -0.3575) (-1.3601, -0.04) (-0.9399, -0.04) (-0.6648, -0.3575) (-0.6648, -0.6425) (-0.9399, -0.96) (-1.222, -1.0005) (-1.3601, -0.96), closed, covered)
  P22_DCP_L3_h34 = polyline(z=-1.27mm, xy in mm: (-0.1601, -0.96) (-0.4352, -0.6425) (-0.4352, -0.3575) (-0.1601, -0.04) (0.2601, -0.04) (0.5352, -0.3575) (0.5352, -0.6425) (0.2601, -0.96) (-0.022, -1.0005) (-0.1601, -0.96), closed, covered)
  P22_DCP_L3_h35 = polyline(z=-1.27mm, xy in mm: (1.0399, -0.96) (0.7648, -0.6425) (0.7648, -0.3575) (1.0399, -0.04) (1.4601, -0.04) (1.7352, -0.3575) (1.7352, -0.6425) (1.4601, -0.96) (1.178, -1.0005) (1.0399, -0.96), closed, covered)
  P22_DCP_L3_h36 = polyline(z=-1.27mm, xy in mm: (2.2399, -0.96) (1.9648, -0.6425) (1.9648, -0.3575) (2.2399, -0.04) (2.6601, -0.04) (2.9352, -0.3575) (2.9352, -0.6425) (2.6601, -0.96) (2.378, -1.0005) (2.2399, -0.96), closed, covered)
  P22_DCP_L3_h37 = polyline(z=-1.27mm, xy in mm: (3.4399, -0.96) (3.1648, -0.6425) (3.1648, -0.3575) (3.4399, -0.04) (3.8601, -0.04) (4.1352, -0.3575) (4.1352, -0.6425) (3.8601, -0.96) (3.578, -1.0005) (3.4399, -0.96), closed, covered)
  P22_DCP_L3_h38 = polyline(z=-1.27mm, xy in mm: (4.6399, -0.96) (4.3648, -0.6425) (4.3648, -0.3575) (4.6399, -0.04) (5.0601, -0.04) (5.3352, -0.3575) (5.3352, -0.6425) (5.0601, -0.96) (4.778, -1.0005) (4.6399, -0.96), closed, covered)
  P22_DCP_L3_h39 = polyline(z=-1.27mm, xy in mm: (5.8399, -0.96) (5.5648, -0.6425) (5.5648, -0.3575) (5.8399, -0.04) (6.2601, -0.04) (6.5352, -0.3575) (6.5352, -0.6425) (6.2601, -0.96) (5.978, -1.0005) (5.8399, -0.96), closed, covered)
  P22_DCP_L3_h40 = polyline(z=-1.27mm, xy in mm: (8.1399, -0.96) (7.8648, -0.6425) (7.8648, -0.3575) (8.1399, -0.04) (8.5601, -0.04) (8.7754, -0.2266) (8.9188, -0.5012) (8.6811, -0.8821) (8.278, -1.0005) (8.1399, -0.96), closed, covered)
  P22_DCP_L3_h41 = polyline(z=-1.27mm, xy in mm: (9.3246, -0.96) (9.1092, -0.7734) (8.9658, -0.4988) (9.1092, -0.2266) (9.3246, -0.04) (9.7447, -0.04) (9.96, -0.2266) (10.1034, -0.5012) (9.8657, -0.8821) (9.4626, -1.0005) (9.3246, -0.96), closed, covered)
  P22_DCP_L3_h42 = polyline(z=-1.27mm, xy in mm: (10.5092, -0.96) (10.2939, -0.7734) (10.1504, -0.4988) (10.2939, -0.2266) (10.5092, -0.04) (10.9293, -0.04) (11.1446, -0.2266) (11.288, -0.5012) (11.0504, -0.8821) (10.6473, -1.0005) (10.5092, -0.96), closed, covered)
  P22_DCP_L3_h43 = polyline(z=-1.27mm, xy in mm: (11.6938, -0.96) (11.4785, -0.7734) (11.335, -0.4988) (11.4785, -0.2266) (11.6938, -0.04) (12.1139, -0.04) (12.3292, -0.2266) (12.4727, -0.5012) (12.235, -0.8821) (11.8319, -1.0005) (11.6938, -0.96), closed, covered)
  P22_DCP_L3_h44 = polyline(z=-1.27mm, xy in mm: (12.8784, -0.96) (12.6631, -0.7734) (12.5196, -0.4988) (12.6631, -0.2266) (12.8784, -0.04) (13.2985, -0.04) (13.5138, -0.2266) (13.6573, -0.5012) (13.4196, -0.8821) (13.0165, -1.0005) (12.8784, -0.96), closed, covered)
  P22_DCP_L3_h45 = polyline(z=-1.27mm, xy in mm: (14.063, -0.96) (13.8477, -0.7734) (13.7043, -0.4988) (13.8477, -0.2266) (14.063, -0.04) (14.4831, -0.04) (14.6985, -0.2266) (14.8419, -0.5012) (14.6042, -0.8821) (14.2011, -1.0005) (14.063, -0.96), closed, covered)
  P22_DCP_L3_h46 = polyline(z=-1.27mm, xy in mm: (15.2476, -0.96) (15.0323, -0.7734) (14.8889, -0.4988) (15.0323, -0.2266) (15.2476, -0.04) (15.6677, -0.04) (15.8831, -0.2266) (16.0265, -0.5012) (15.7888, -0.8821) (15.3857, -1.0005) (15.2476, -0.96), closed, covered)
  P22_DCP_L3_h47 = polyline(z=-1.27mm, xy in mm: (16.4323, -0.96) (16.2169, -0.7734) (16.0735, -0.4988) (16.2169, -0.2266) (16.4323, -0.04) (16.8524, -0.04) (17.0677, -0.2266) (17.2111, -0.5012) (16.9734, -0.8821) (16.5703, -1.0005) (16.4323, -0.96), closed, covered)
  P22_DCP_L3_h48 = polyline(z=-1.27mm, xy in mm: (17.6169, -0.96) (17.4015, -0.7734) (17.2581, -0.4988) (17.4015, -0.2266) (17.6169, -0.04) (18.037, -0.04) (18.2523, -0.2266) (18.3957, -0.5012) (18.1581, -0.8821) (17.755, -1.0005) (17.6169, -0.96), closed, covered)
  P22_DCP_L3_h49 = polyline(z=-1.27mm, xy in mm: (18.8015, -0.96) (18.5862, -0.7734) (18.4427, -0.4988) (18.5862, -0.2266) (18.8015, -0.04) (19.2216, -0.04) (19.4369, -0.2266) (19.5804, -0.5012) (19.3427, -0.8821) (18.9396, -1.0005) (18.8015, -0.96), closed, covered)
  P22_DCP_L3_h50 = polyline(z=-1.27mm, xy in mm: (19.9861, -0.96) (19.7708, -0.7734) (19.6273, -0.4988) (19.7708, -0.2266) (19.9861, -0.04) (20.4062, -0.04) (20.6215, -0.2266) (20.765, -0.5012) (20.5273, -0.8821) (20.1242, -1.0005) (19.9861, -0.96), closed, covered)
  P22_DCP_L3_h51 = polyline(z=-1.27mm, xy in mm: (21.1707, -0.96) (20.9554, -0.7734) (20.812, -0.4988) (20.9554, -0.2266) (21.1707, -0.04) (21.5908, -0.04) (21.8061, -0.2266) (21.9496, -0.5012) (21.7119, -0.8821) (21.3088, -1.0005) (21.1707, -0.96), closed, covered)
  P22_DCP_L3_h52 = polyline(z=-1.27mm, xy in mm: (22.3553, -0.96) (22.14, -0.7734) (21.9966, -0.4988) (22.14, -0.2266) (22.3553, -0.04) (22.7754, -0.04) (22.9908, -0.2266) (23.1342, -0.5012) (22.8965, -0.8821) (22.4934, -1.0005) (22.3553, -0.96), closed, covered)
  P22_DCP_L3_h53 = polyline(z=-1.27mm, xy in mm: (23.5399, -0.96) (23.3246, -0.7734) (23.1812, -0.4988) (23.3246, -0.2266) (23.5399, -0.04) (23.9601, -0.04) (24.1754, -0.2266) (24.3188, -0.5012) (24.0811, -0.8821) (23.678, -1.0005) (23.5399, -0.96), closed, covered)
  P22_DCP_L3_h54 = polyline(z=-1.27mm, xy in mm: (24.7246, -0.96) (24.5092, -0.7734) (24.3658, -0.4988) (24.5092, -0.2266) (24.7246, -0.04) (25.1447, -0.04) (25.36, -0.2266) (25.5034, -0.5012) (25.2657, -0.8821) (24.8627, -1.0005) (24.7246, -0.96), closed, covered)
  P22_DCP_L3_h55 = polyline(z=-1.27mm, xy in mm: (25.9092, -0.96) (25.6939, -0.7734) (25.5504, -0.4988) (25.6939, -0.2266) (25.9092, -0.04) (26.3293, -0.04) (26.5446, -0.2266) (26.688, -0.5012) (26.4504, -0.8821) (26.0473, -1.0005) (25.9092, -0.96), closed, covered)
  P22_DCP_L3_h56 = polyline(z=-1.27mm, xy in mm: (27.0938, -0.96) (26.8785, -0.7734) (26.735, -0.4988) (26.8785, -0.2266) (27.0938, -0.04) (27.5139, -0.04) (27.7292, -0.2266) (27.8727, -0.5012) (27.635, -0.8821) (27.2319, -1.0005) (27.0938, -0.96), closed, covered)
  P22_DCP_L3_h57 = polyline(z=-1.27mm, xy in mm: (28.2784, -0.96) (28.0631, -0.7734) (27.9196, -0.4988) (28.0631, -0.2266) (28.2784, -0.04) (28.6985, -0.04) (28.9138, -0.2266) (29.0573, -0.5012) (28.8196, -0.8821) (28.4165, -1.0005) (28.2784, -0.96), closed, covered)
  P22_DCP_L3_h58 = polyline(z=-1.27mm, xy in mm: (29.463, -0.96) (29.2477, -0.7734) (29.1043, -0.4988) (29.2477, -0.2266) (29.463, -0.04) (29.8831, -0.04) (30.0985, -0.2266) (30.2419, -0.5012) (30.0042, -0.8821) (29.6011, -1.0005) (29.463, -0.96), closed, covered)
  P22_DCP_L3_h59 = polyline(z=-1.27mm, xy in mm: (30.6476, -0.96) (30.4323, -0.7734) (30.2889, -0.4988) (30.4323, -0.2266) (30.6476, -0.04) (31.0677, -0.04) (31.2831, -0.2266) (31.4265, -0.5012) (31.1888, -0.8821) (30.7857, -1.0005) (30.6476, -0.96), closed, covered)
  P22_DCP_L3_h60 = polyline(z=-1.27mm, xy in mm: (31.8323, -0.96) (31.6169, -0.7734) (31.4735, -0.4988) (31.6169, -0.2266) (31.8323, -0.04) (32.2524, -0.04) (32.4677, -0.2266) (32.6111, -0.5012) (32.3734, -0.8821) (31.9703, -1.0005) (31.8323, -0.96), closed, covered)
  P22_DCP_L3_h61 = polyline(z=-1.27mm, xy in mm: (33.0169, -0.96) (32.8015, -0.7734) (32.6581, -0.4988) (32.8015, -0.2266) (33.0169, -0.04) (33.437, -0.04) (33.6523, -0.2266) (33.7957, -0.5012) (33.5581, -0.8821) (33.155, -1.0005) (33.0169, -0.96), closed, covered)
  P22_DCP_L3_h62 = polyline(z=-1.27mm, xy in mm: (34.2015, -0.96) (33.9862, -0.7734) (33.8427, -0.4988) (33.9862, -0.2266) (34.2015, -0.04) (34.6216, -0.04) (34.8369, -0.2266) (34.9804, -0.5012) (34.7427, -0.8821) (34.3396, -1.0005) (34.2015, -0.96), closed, covered)
  P22_DCP_L3_h63 = polyline(z=-1.27mm, xy in mm: (35.3861, -0.96) (35.1708, -0.7734) (35.0273, -0.4988) (35.1708, -0.2266) (35.3861, -0.04) (35.8062, -0.04) (36.0215, -0.2266) (36.165, -0.5012) (35.9273, -0.8821) (35.5242, -1.0005) (35.3861, -0.96), closed, covered)
  P22_DCP_L3_h64 = polyline(z=-1.27mm, xy in mm: (36.5707, -0.96) (36.3554, -0.7734) (36.212, -0.4988) (36.3554, -0.2266) (36.5707, -0.04) (36.9908, -0.04) (37.2061, -0.2266) (37.3496, -0.5012) (37.1119, -0.8821) (36.7088, -1.0005) (36.5707, -0.96), closed, covered)
  P22_DCP_L3_h65 = polyline(z=-1.27mm, xy in mm: (37.7553, -0.96) (37.54, -0.7734) (37.3966, -0.4988) (37.54, -0.2266) (37.7553, -0.04) (38.1754, -0.04) (38.3908, -0.2266) (38.5342, -0.5012) (38.2965, -0.8821) (37.8934, -1.0005) (37.7553, -0.96), closed, covered)
  P22_DCP_L3.subtract(P22_DCP_L3_h0..P22_DCP_L3_h65)
  P22_DCP_L3.sweep_along_vector((0mm, 0mm, 0.07mm))
  P23_DCP_L4 = polyline(z=-1.44mm, xy in mm: (-28.4908, 1.4689) (-28.45, 3.201) (-28.5184, 3.2952) (-37.951, 3.3) (-38.0452, 3.2316) (-38.05, 1.549) (-37.9816, 1.4548) (-28.549, 1.45) (-28.4908, 1.4689), closed, covered)
  P23_DCP_L4.sweep_along_vector((0mm, 0mm, 0.07mm))
  P24_DCP_L4 = polyline(z=-1.44mm, xy in mm: (-11.8361, 1.4689) (-11.8843, 2.6203) (-12.3943, 2.7352) (-12.7843, 3.1043) (-12.8973, 3.0768) (-13.0898, 2.8395) (-13.3978, 2.7009) (-14.0522, 2.7009) (-14.5345, 2.9871) (-15.0478, 2.7009) (-15.6316, 2.6945) (-16.0102, 2.8395) (-16.3508, 3.3) (-18.1152, 3.3) (-18.35, 3.2392) (-18.951, 3.3) (-19.0452, 3.2316) (-19.05, 1.549) (-18.9816, 1.4548) (-11.8943, 1.45) (-11.8361, 1.4689), closed, covered)
  P24_DCP_L4.sweep_along_vector((0mm, 0mm, 0.07mm))
  P25_DCP_L4 = polyline(z=-1.44mm, xy in mm: (19.0092, 1.4689) (19.05, 3.201) (18.9816, 3.2952) (9.549, 3.3) (9.4548, 3.2316) (9.45, 1.549) (9.5184, 1.4548) (18.951, 1.45) (19.0092, 1.4689), closed, covered)
  P25_DCP_L4.sweep_along_vector((0mm, 0mm, 0.07mm))
  P26_DCP_L4 = polyline(z=-1.44mm, xy in mm: (35.6639, 1.4689) (35.6157, 2.6203) (35.1057, 2.7352) (34.7157, 3.1043) (34.6027, 3.0768) (34.4102, 2.8395) (34.1022, 2.7009) (33.4478, 2.7009) (32.9655, 2.9871) (32.4522, 2.7009) (31.8684, 2.6945) (31.4898, 2.8395) (31.1492, 3.3) (29.3848, 3.3) (29.15, 3.2392) (28.549, 3.3) (28.4548, 3.2316) (28.45, 1.549) (28.5184, 1.4548) (35.6057, 1.45) (35.6639, 1.4689), closed, covered)
  P26_DCP_L4.sweep_along_vector((0mm, 0mm, 0.07mm))
  P27_AC1_L1 [copper] = polyline(z=0.17mm, xy in mm: (-36.3943, 5.2189) (-36.3505, 6.6623) (-36.1153, 6.8975) (-35.1146, 6.9005) (-34.9004, 6.7685) (-34.8505, 5.299) (-34.7515, 5.2) (-34.2995, 5.2) (-34.2053, 5.2684) (-34.2005, 6.6612) (-34.0386, 6.8851) (-33.3889, 6.9005) (-33.1649, 6.7386) (-33.1495, 5.299) (-33.0505, 5.2) (-32.5995, 5.2) (-32.5053, 5.2684) (-32.5005, 6.6612) (-32.3386, 6.8851) (-30.4106, 6.9005) (-30.1964, 6.7685) (-30.0781, 6.4853) (-29.4231, 6.4805) (-29.15, 6.5608) (-28.7908, 6.4994) (-28.7689, 8.8592) (-30.1057, 8.8811) (-30.1964, 7.3315) (-30.4106, 7.1995) (-31.3854, 7.1995) (-31.5175, 7.2494) (-31.6465, 7.4377) (-31.6684, 8.8592) (-32.2587, 8.8811) (-32.3149, 7.3614) (-32.4614, 7.2149) (-33.1112, 7.1995) (-33.2764, 7.2736) (-33.3505, 7.4389) (-33.3694, 8.8592) (-33.9005, 8.9) (-33.9995, 8.801) (-34.0149, 7.3614) (-34.1614, 7.2149) (-34.8112, 7.1995) (-34.9764, 7.2736) (-35.0505, 7.4389) (-35.0505, 8.801) (-35.1189, 8.8952) (-37.7092, 8.8811) (-37.7311, 5.2408) (-36.4525, 5.2) (-36.3943, 5.2189), closed, covered)
  P27_AC1_L1.sweep_along_vector((0mm, 0mm, 0.07mm))
  P28_AC2_L1 [copper] = polyline(z=0.17mm, xy in mm: (-17.3943, 5.2189) (-17.3505, 6.6623) (-17.2215, 6.8506) (-17.0894, 6.9005) (-15.2389, 6.9005) (-15.0736, 6.8264) (-14.9995, 6.6611) (-14.9995, 5.299) (-14.9005, 5.2) (-14.4495, 5.2) (-14.3553, 5.2684) (-14.3505, 6.6612) (-14.1886, 6.8851) (-13.5389, 6.9005) (-13.3736, 6.8264) (-13.2995, 6.6611) (-13.2806, 5.2408) (-12.7485, 5.2) (-12.6495, 5.299) (-12.5996, 6.7685) (-12.3854, 6.9005) (-11.3847, 6.8975) (-11.1495, 6.6623) (-11.1276, 5.2408) (-9.7908, 5.2189) (-9.7689, 8.8592) (-12.4087, 8.8811) (-12.4495, 7.4388) (-12.5236, 7.2736) (-12.6889, 7.1995) (-13.3386, 7.2149) (-13.4851, 7.3614) (-13.5005, 8.801) (-13.5995, 8.9) (-14.0505, 8.9) (-14.1447, 8.8316) (-14.1495, 7.4388) (-14.3114, 7.2149) (-14.9612, 7.1995) (-15.1851, 7.3614) (-15.2005, 8.801) (-15.2995, 8.9) (-15.7515, 8.9) (-15.8457, 8.8316) (-15.9029, 8.6191) (-15.8535, 7.4377) (-16.0887, 7.2025) (-17.1153, 7.2025) (-17.3036, 7.3315) (-17.3724, 7.5787) (-17.4525, 7.6195) (-18.0769, 7.6195) (-18.35, 7.5392) (-18.7092, 7.6006) (-18.7311, 5.2408) (-17.4525, 5.2) (-17.3943, 5.2189), closed, covered)
  P28_AC2_L1.sweep_along_vector((0mm, 0mm, 0.07mm))
  P29_AC3_L1 [copper] = polyline(z=0.17mm, xy in mm: (11.1057, 5.2189) (11.1495, 6.6623) (11.3847, 6.8975) (12.3854, 6.9005) (12.5996, 6.7685) (12.6495, 5.299) (12.7485, 5.2) (13.2005, 5.2) (13.2947, 5.2684) (13.2995, 6.6612) (13.4614, 6.8851) (14.1111, 6.9005) (14.3351, 6.7386) (14.3505, 5.299) (14.4495, 5.2) (14.9005, 5.2) (14.9947, 5.2684) (14.9995, 6.6612) (15.1614, 6.8851) (17.0894, 6.9005) (17.3036, 6.7685) (17.4219, 6.4853) (18.0769, 6.4805) (18.35, 6.5608) (18.7092, 6.4994) (18.7311, 8.8592) (17.3943, 8.8811) (17.3036, 7.3315) (17.0894, 7.1995) (16.1146, 7.1995) (15.9825, 7.2494) (15.8535, 7.4377) (15.8316, 8.8592) (15.2413, 8.8811) (15.1851, 7.3614) (15.0386, 7.2149) (14.3888, 7.1995) (14.2236, 7.2736) (14.1495, 7.4389) (14.1306, 8.8592) (13.5995, 8.9) (13.5005, 8.801) (13.4851, 7.3614) (13.3386, 7.2149) (12.6888, 7.1995) (12.5236, 7.2736) (12.4495, 7.4389) (12.4495, 8.801) (12.3811, 8.8952) (9.7908, 8.8811) (9.7689, 5.2408) (11.0475, 5.2) (11.1057, 5.2189), closed, covered)
  P29_AC3_L1.sweep_along_vector((0mm, 0mm, 0.07mm))
  P30_AC4_L1 [copper] = polyline(z=0.17mm, xy in mm: (30.1057, 5.2189) (30.1495, 6.6623) (30.2785, 6.8506) (30.4106, 6.9005) (32.2611, 6.9005) (32.4264, 6.8264) (32.5005, 6.6611) (32.5005, 5.299) (32.5995, 5.2) (33.0505, 5.2) (33.1447, 5.2684) (33.1495, 6.6612) (33.3114, 6.8851) (33.9611, 6.9005) (34.1264, 6.8264) (34.2005, 6.6611) (34.2194, 5.2408) (34.7515, 5.2) (34.8505, 5.299) (34.9004, 6.7685) (35.1146, 6.9005) (36.1153, 6.8975) (36.3505, 6.6623) (36.3724, 5.2408) (37.7092, 5.2189) (37.7311, 8.8592) (35.0913, 8.8811) (35.0505, 7.4388) (34.9764, 7.2736) (34.8111, 7.1995) (34.1614, 7.2149) (34.0149, 7.3614) (33.9995, 8.801) (33.9005, 8.9) (33.4495, 8.9) (33.3553, 8.8316) (33.3505, 7.4388) (33.1886, 7.2149) (32.5388, 7.1995) (32.3149, 7.3614) (32.2995, 8.801) (32.2005, 8.9) (31.7485, 8.9) (31.6543, 8.8316) (31.5971, 8.6191) (31.6465, 7.4377) (31.4113, 7.2025) (30.3847, 7.2025) (30.1964, 7.3315) (30.1276, 7.5787) (30.0475, 7.6195) (29.4231, 7.6195) (29.15, 7.5392) (28.7908, 7.6006) (28.7689, 5.2408) (30.0475, 5.2) (30.1057, 5.2189), closed, covered)
  P30_AC4_L1.sweep_along_vector((0mm, 0mm, 0.07mm))
  P31_AC1_L3 = polyline(z=-1.27mm, xy in mm: (-30.2669, 5.2189) (-30.1012, 5.4285) (-29.848, 5.5108) (-29.5948, 5.4285) (-29.4159, 5.2108) (-29.1908, 5.2189) (-29.15, 5.299) (-29.1689, 5.6728) (-29.4985, 5.8768) (-29.5808, 6.13) (-29.4985, 6.3832) (-29.15, 6.6454) (-29.15, 9.9146) (-29.4985, 10.1768) (-29.5808, 10.43) (-29.4985, 10.6832) (-29.15, 10.9454) (-29.1689, 15.8592) (-34.7, 15.9) (-34.7, 18.5129) (-34.7684, 18.6071) (-35.078, 18.4995) (-35.3601, 18.54) (-35.5754, 18.7266) (-35.6556, 19) (-35.5197, 19.3665) (-35.6556, 19.75) (-35.5754, 20.0234) (-35.222, 20.2505) (-34.7363, 20.1604) (-34.7, 20.4505) (-34.7684, 20.5447) (-43.65, 20.6) (-43.6311, 20.1444) (-43.5204, 20.1084) (-43.222, 20.2505) (-42.9399, 20.21) (-42.7246, 20.0234) (-42.6444, 19.75) (-42.7803, 19.3835) (-42.6444, 19) (-42.7246, 18.7266) (-43.078, 18.4995) (-43.5425, 18.646) (-43.65, 18.5474) (-43.6311, 5.2408) (-30.3251, 5.2) (-30.2669, 5.2189), closed, covered)
  P31_AC1_L3_h0 = polyline(z=-1.27mm, xy in mm: (-41.3601, 18.54) (-41.6352, 18.8575) (-41.6352, 19.1425) (-41.5197, 19.3665) (-41.6352, 19.6075) (-41.6352, 19.8925) (-41.3601, 20.21) (-41.078, 20.2505) (-40.8189, 20.1321) (-40.6648, 19.8925) (-40.6648, 19.6075) (-40.7803, 19.3835) (-40.6444, 19) (-40.8189, 18.6179) (-41.222, 18.4995) (-41.3601, 18.54), closed, covered)
  P31_AC1_L3_h1 = polyline(z=-1.27mm, xy in mm: (-39.3601, 18.54) (-39.6352, 18.8575) (-39.6352, 19.1425) (-39.5197, 19.3665) (-39.6352, 19.6075) (-39.6352, 19.8925) (-39.3601, 20.21) (-39.078, 20.2505) (-38.8189, 20.1321) (-38.6648, 19.8925) (-38.6648, 19.6075) (-38.7803, 19.3835) (-38.6444, 19) (-38.8189, 18.6179) (-39.222, 18.4995) (-39.3601, 18.54), closed, covered)
  P31_AC1_L3_h2 = polyline(z=-1.27mm, xy in mm: (-37.3601, 18.54) (-37.6352, 18.8575) (-37.6352, 19.1425) (-37.5197, 19.3665) (-37.6352, 19.6075) (-37.6352, 19.8925) (-37.3601, 20.21) (-37.078, 20.2505) (-36.8189, 20.1321) (-36.6648, 19.8925) (-36.6648, 19.6075) (-36.7803, 19.3835) (-36.6444, 19) (-36.8189, 18.6179) (-37.222, 18.4995) (-37.3601, 18.54), closed, covered)
  P31_AC1_L3_h3 = polyline(z=-1.27mm, xy in mm: (-37.4351, 11.765) (-37.7102, 12.0825) (-37.7102, 12.3675) (-37.4351, 12.685) (-37.0149, 12.685) (-36.7398, 12.3675) (-36.7398, 12.0825) (-37.0149, 11.765) (-37.297, 11.7245) (-37.4351, 11.765), closed, covered)
  P31_AC1_L3_h4 = polyline(z=-1.27mm, xy in mm: (-29.9811, 8.9703) (-30.1965, 9.1268) (-30.2577, 9.5131) (-30.1012, 9.7285) (-29.7149, 9.7897) (-29.4995, 9.6332) (-29.4172, 9.38) (-29.4995, 9.1268) (-29.848, 8.9492) (-29.9811, 8.9703), closed, covered)
  P31_AC1_L3.subtract(P31_AC1_L3_h0..P31_AC1_L3_h4)
  P31_AC1_L3.sweep_along_vector((0mm, 0mm, 0.07mm))
  P32_AC2_L3 = polyline(z=-1.27mm, xy in mm: (-3.8908, 5.2189) (-3.85, 18.5474) (-3.9796, 18.6416) (-4.422, 18.4995) (-4.7754, 18.7266) (-4.8556, 19) (-4.7197, 19.3665) (-4.8556, 19.75) (-4.7754, 20.0234) (-4.5601, 20.21) (-4.278, 20.2505) (-3.8979, 20.1178) (-3.85, 20.6) (-8.4402, 20.5495) (-11.5277, 20.6) (-11.85, 20.5444) (-12.8, 20.6) (-12.7811, 20.1789) (-12.6704, 20.1429) (-12.422, 20.2505) (-12.1399, 20.21) (-11.9246, 20.0234) (-11.8444, 19.75) (-11.9803, 19.3835) (-11.8444, 19) (-11.9246, 18.7266) (-12.278, 18.4995) (-12.7067, 18.6118) (-12.7967, 18.5381) (-12.8, 15.9) (-18.3092, 15.8811) (-18.35, 8.4854) (-18.0015, 8.2232) (-17.9192, 7.97) (-18.0015, 7.7168) (-18.3488, 7.4701) (-18.3311, 5.2408) (-3.949, 5.2) (-3.8908, 5.2189), closed, covered)
  P32_AC2_L3_h0 = polyline(z=-1.27mm, xy in mm: (-10.5601, 18.54) (-10.8352, 18.8575) (-10.8352, 19.1425) (-10.7197, 19.3665) (-10.8352, 19.6075) (-10.8352, 19.8925) (-10.5601, 20.21) (-10.278, 20.2505) (-10.0189, 20.1321) (-9.8648, 19.8925) (-9.8648, 19.6075) (-9.9803, 19.3835) (-9.8444, 19) (-10.0189, 18.6179) (-10.422, 18.4995) (-10.5601, 18.54), closed, covered)
  P32_AC2_L3_h1 = polyline(z=-1.27mm, xy in mm: (-8.5601, 18.54) (-8.8352, 18.8575) (-8.8352, 19.1425) (-8.7197, 19.3665) (-8.8352, 19.6075) (-8.8352, 19.8925) (-8.5601, 20.21) (-8.278, 20.2505) (-8.0189, 20.1321) (-7.8648, 19.8925) (-7.8648, 19.6075) (-7.9803, 19.3835) (-7.8444, 19) (-8.0189, 18.6179) (-8.422, 18.4995) (-8.5601, 18.54), closed, covered)
  P32_AC2_L3_h2 = polyline(z=-1.27mm, xy in mm: (-6.5601, 18.54) (-6.8352, 18.8575) (-6.8352, 19.1425) (-6.7197, 19.3665) (-6.8352, 19.6075) (-6.8352, 19.8925) (-6.5601, 20.21) (-6.278, 20.2505) (-6.0189, 20.1321) (-5.8648, 19.8925) (-5.8648, 19.6075) (-5.9803, 19.3835) (-5.8444, 19) (-6.0189, 18.6179) (-6.422, 18.4995) (-6.5601, 18.54), closed, covered)
  P32_AC2_L3_h3 = polyline(z=-1.27mm, xy in mm: (-10.4851, 11.765) (-10.7602, 12.0825) (-10.7602, 12.3675) (-10.4851, 12.685) (-10.0649, 12.685) (-9.7898, 12.3675) (-9.7898, 12.0825) (-10.0649, 11.765) (-10.347, 11.7245) (-10.4851, 11.765), closed, covered)
  P32_AC2_L3_h4 = polyline(z=-1.27mm, xy in mm: (-17.7851, 8.6103) (-18.0005, 8.7668) (-18.0617, 9.1531) (-17.9052, 9.3685) (-17.5189, 9.4297) (-17.3035, 9.2732) (-17.2212, 9.02) (-17.3035, 8.7668) (-17.652, 8.5892) (-17.7851, 8.6103), closed, covered)
  P32_AC2_L3.subtract(P32_AC2_L3_h0..P32_AC2_L3_h4)
  P32_AC2_L3.sweep_along_vector((0mm, 0mm, 0.07mm))
  P33_AC3_L3 = polyline(z=-1.27mm, xy in mm: (17.2331, 5.2189) (17.3988, 5.4285) (17.652, 5.5108) (17.9052, 5.4285) (18.0841, 5.2108) (18.3092, 5.2189) (18.35, 5.299) (18.3311, 5.6728) (18.0015, 5.8768) (17.9192, 6.13) (18.0015, 6.3832) (18.35, 6.6454) (18.35, 9.9146) (18.0015, 10.1768) (17.9192, 10.43) (18.0015, 10.6832) (18.35, 10.9454) (18.3311, 15.8592) (12.8, 15.9) (12.8, 18.5129) (12.7316, 18.6071) (12.422, 18.4995) (12.1399, 18.54) (11.9246, 18.7266) (11.8444, 19) (11.9803, 19.3665) (11.8444, 19.75) (11.9246, 20.0234) (12.278, 20.2505) (12.7637, 20.1604) (12.8, 20.4505) (12.7316, 20.5447) (3.85, 20.6) (3.8689, 20.1444) (3.9796, 20.1084) (4.278, 20.2505) (4.5601, 20.21) (4.7754, 20.0234) (4.8556, 19.75) (4.7197, 19.3835) (4.8556, 19) (4.7754, 18.7266) (4.422, 18.4995) (3.9575, 18.646) (3.85, 18.5474) (3.8689, 5.2408) (17.1749, 5.2) (17.2331, 5.2189), closed, covered)
  P33_AC3_L3_h0 = polyline(z=-1.27mm, xy in mm: (6.1399, 18.54) (5.8648, 18.8575) (5.8648, 19.1425) (5.9803, 19.3665) (5.8648, 19.6075) (5.8648, 19.8925) (6.1399, 20.21) (6.422, 20.2505) (6.6811, 20.1321) (6.8352, 19.8925) (6.8352, 19.6075) (6.7197, 19.3835) (6.8556, 19) (6.6811, 18.6179) (6.278, 18.4995) (6.1399, 18.54), closed, covered)
  P33_AC3_L3_h1 = polyline(z=-1.27mm, xy in mm: (8.1399, 18.54) (7.8648, 18.8575) (7.8648, 19.1425) (7.9803, 19.3665) (7.8648, 19.6075) (7.8648, 19.8925) (8.1399, 20.21) (8.422, 20.2505) (8.6811, 20.1321) (8.8352, 19.8925) (8.8352, 19.6075) (8.7197, 19.3835) (8.8556, 19) (8.6811, 18.6179) (8.278, 18.4995) (8.1399, 18.54), closed, covered)
  P33_AC3_L3_h2 = polyline(z=-1.27mm, xy in mm: (10.1399, 18.54) (9.8648, 18.8575) (9.8648, 19.1425) (9.9803, 19.3665) (9.8648, 19.6075) (9.8648, 19.8925) (10.1399, 20.21) (10.422, 20.2505) (10.6811, 20.1321) (10.8352, 19.8925) (10.8352, 19.6075) (10.7197, 19.3835) (10.8556, 19) (10.6811, 18.6179) (10.278, 18.4995) (10.1399, 18.54), closed, covered)
  P33_AC3_L3_h3 = polyline(z=-1.27mm, xy in mm: (10.0649, 11.765) (9.7898, 12.0825) (9.7898, 12.3675) (10.0649, 12.685) (10.4851, 12.685) (10.7602, 12.3675) (10.7602, 12.0825) (10.4851, 11.765) (10.203, 11.7245) (10.0649, 11.765), closed, covered)
  P33_AC3_L3_h4 = polyline(z=-1.27mm, xy in mm: (17.5189, 8.9703) (17.3035, 9.1268) (17.2423, 9.5131) (17.3988, 9.7285) (17.7851, 9.7897) (18.0005, 9.6332) (18.0828, 9.38) (18.0005, 9.1268) (17.652, 8.9492) (17.5189, 8.9703), closed, covered)
  P33_AC3_L3.subtract(P33_AC3_L3_h0..P33_AC3_L3_h4)
  P33_AC3_L3.sweep_along_vector((0mm, 0mm, 0.07mm))
  P34_AC4_L3 = polyline(z=-1.27mm, xy in mm: (43.6092, 5.2189) (43.65, 18.5474) (43.5204, 18.6416) (43.078, 18.4995) (42.7246, 18.7266) (42.6444, 19) (42.7803, 19.3665) (42.6444, 19.75) (42.7246, 20.0234) (42.9399, 20.21) (43.222, 20.2505) (43.6021, 20.1178) (43.65, 20.6) (39.0598, 20.5495) (35.9723, 20.6) (35.65, 20.5444) (34.7, 20.6) (34.7189, 20.1789) (34.8296, 20.1429) (35.078, 20.2505) (35.3601, 20.21) (35.5754, 20.0234) (35.6556, 19.75) (35.5197, 19.3835) (35.6556, 19) (35.5754, 18.7266) (35.222, 18.4995) (34.7933, 18.6118) (34.7033, 18.5381) (34.7, 15.9) (29.1908, 15.8811) (29.15, 8.4854) (29.4985, 8.2232) (29.5808, 7.97) (29.4985, 7.7168) (29.1512, 7.4701) (29.1689, 5.2408) (43.551, 5.2) (43.6092, 5.2189), closed, covered)
  P34_AC4_L3_h0 = polyline(z=-1.27mm, xy in mm: (36.9399, 18.54) (36.6648, 18.8575) (36.6648, 19.1425) (36.7803, 19.3665) (36.6648, 19.6075) (36.6648, 19.8925) (36.9399, 20.21) (37.222, 20.2505) (37.4811, 20.1321) (37.6352, 19.8925) (37.6352, 19.6075) (37.5197, 19.3835) (37.6556, 19) (37.4811, 18.6179) (37.078, 18.4995) (36.9399, 18.54), closed, covered)
  P34_AC4_L3_h1 = polyline(z=-1.27mm, xy in mm: (38.9399, 18.54) (38.6648, 18.8575) (38.6648, 19.1425) (38.7803, 19.3665) (38.6648, 19.6075) (38.6648, 19.8925) (38.9399, 20.21) (39.222, 20.2505) (39.4811, 20.1321) (39.6352, 19.8925) (39.6352, 19.6075) (39.5197, 19.3835) (39.6556, 19) (39.4811, 18.6179) (39.078, 18.4995) (38.9399, 18.54), closed, covered)
  P34_AC4_L3_h2 = polyline(z=-1.27mm, xy in mm: (40.9399, 18.54) (40.6648, 18.8575) (40.6648, 19.1425) (40.7803, 19.3665) (40.6648, 19.6075) (40.6648, 19.8925) (40.9399, 20.21) (41.222, 20.2505) (41.4811, 20.1321) (41.6352, 19.8925) (41.6352, 19.6075) (41.5197, 19.3835) (41.6556, 19) (41.4811, 18.6179) (41.078, 18.4995) (40.9399, 18.54), closed, covered)
  P34_AC4_L3_h3 = polyline(z=-1.27mm, xy in mm: (37.0149, 11.765) (36.7398, 12.0825) (36.7398, 12.3675) (37.0149, 12.685) (37.4351, 12.685) (37.7102, 12.3675) (37.7102, 12.0825) (37.4351, 11.765) (37.153, 11.7245) (37.0149, 11.765), closed, covered)
  P34_AC4_L3_h4 = polyline(z=-1.27mm, xy in mm: (29.7149, 8.6103) (29.4995, 8.7668) (29.4383, 9.1531) (29.5948, 9.3685) (29.9811, 9.4297) (30.1965, 9.2732) (30.2788, 9.02) (30.1965, 8.7668) (29.848, 8.5892) (29.7149, 8.6103), closed, covered)
  P34_AC4_L3.subtract(P34_AC4_L3_h0..P34_AC4_L3_h4)
  P34_AC4_L3.sweep_along_vector((0mm, 0mm, 0.07mm))
  P35_AC1_L4 = polyline(z=-1.44mm, xy in mm: (-38.5663, 4.6189) (-38.5226, 5.0147) (-38.3971, 5.2522) (-38.1597, 5.3776) (-37.7245, 5.3805) (-37.6255, 5.4795) (-37.6444, 6.8387) (-38.2879, 6.9272) (-38.5226, 7.2453) (-38.5226, 7.9647) (-38.3972, 8.2021) (-38.1597, 8.3276) (-36.1621, 8.2828) (-35.9245, 7.9343) (-35.9274, 7.2453) (-36.0862, 6.8982) (-35.9923, 6.8305) (-35.2121, 6.7828) (-34.9603, 6.4731) (-34.3987, 6.4744) (-34.1003, 6.7906) (-33.5435, 6.8055) (-33.3367, 6.7331) (-33.1745, 6.4365) (-33.1745, 5.8235) (-33.3169, 5.52) (-33.2191, 5.4055) (-32.6809, 5.4055) (-32.5867, 5.4739) (-32.7255, 5.8235) (-32.7106, 6.5303) (-32.5633, 6.7331) (-32.3565, 6.8055) (-31.7997, 6.7906) (-31.4431, 6.4555) (-29.4671, 6.4555) (-29.15, 6.5608) (-28.8015, 6.3832) (-28.7403, 5.9969) (-29.0169, 5.7203) (-29.4671, 5.8045) (-31.4431, 5.8045) (-31.6669, 5.52) (-31.5691, 5.4055) (-30.1651, 5.4055) (-29.848, 5.5108) (-29.5749, 5.4305) (-28.4995, 5.4305) (-28.4053, 5.4989) (-28.3754, 5.8927) (-28.2191, 6.0625) (-27.149, 6.1005) (-27.0548, 6.1689) (-27.0689, 7.9587) (-28.0793, 7.9959) (-28.2683, 8.0696) (-28.3945, 8.2628) (-28.4005, 8.9305) (-28.4689, 9.0247) (-29.5749, 9.0295) (-29.848, 8.9492) (-30.1651, 9.0545) (-38.7255, 9.0545) (-38.8197, 8.9861) (-38.835, 8.5272) (-38.9823, 8.2113) (-39.2557, 7.9952) (-39.525, 7.9295) (-41.4278, 7.94) (-41.7437, 8.0873) (-42.015, 8.5272) (-42.015, 9.3828) (-41.8677, 9.6987) (-41.5943, 9.9148) (-40.9245, 9.9805) (-40.8255, 10.0795) (-40.8444, 10.8387) (-41.5943, 10.9452) (-41.8677, 11.1613) (-42.015, 11.4772) (-42.0255, 12.23) (-41.9598, 12.4993) (-41.7437, 12.7727) (-41.325, 12.9305) (-39.525, 12.9305) (-39.1063, 12.7727) (-38.835, 12.3328) (-38.8157, 11.4797) (-38.1563, 11.2727) (-37.7986, 10.756) (-34.7656, 10.7555) (-34.4102, 11.2605) (-34.0316, 11.4055) (-33.4478, 11.3991) (-32.9655, 11.1129) (-32.4522, 11.3991) (-31.7978, 11.3991) (-31.4898, 11.2605) (-31.1461, 10.7562) (-29.4671, 10.7555) (-29.0169, 10.8397) (-28.8015, 10.6832) (-28.7192, 10.43) (-28.8015, 10.1768) (-29.0169, 10.0203) (-29.4671, 10.1045) (-31.1344, 10.1045) (-31.2286, 10.0361) (-31.2775, 9.7398) (-30.1651, 9.7055) (-29.848, 9.8108) (-29.5749, 9.7305) (-27.9346, 9.7161) (-27.7055, 9.4672) (-27.6806, 8.7413) (-27.0908, 8.7194) (-27.0689, 9.9592) (-28.35, 10) (-28.35, 14.901) (-28.449, 15) (-29.15, 15) (-29.15, 17.801) (-29.249, 17.9) (-34.7, 17.9) (-34.7189, 18.5711) (-34.8296, 18.6071) (-35.078, 18.4995) (-35.3601, 18.54) (-35.5754, 18.7266) (-35.6556, 19) (-35.5197, 19.3665) (-35.6556, 19.75) (-35.5754, 20.0234) (-35.222, 20.2505) (-34.7363, 20.1604) (-34.7, 20.4505) (-34.7684, 20.5447) (-39.8245, 20.6) (-39.8245, 19.933) (-39.7561, 19.8388) (-39.3601, 20.21) (-39.078, 20.2505) (-38.7246, 20.0234) (-38.6444, 19.75) (-38.7803, 19.3835) (-38.6648, 19.1425) (-38.6648, 18.8575) (-38.8189, 18.6179) (-39.222, 18.4995) (-39.4811, 18.6179) (-39.6768, 18.9032) (-39.8225, 18.8367) (-39.8245, 17.7245) (-39.7561, 17.6303) (-34.1926, 17.6255) (-33.9394, 17.413) (-33.9638, 14.7347) (-34.1926, 14.5745) (-34.6466, 14.5556) (-34.9563, 14.0573) (-35.2722, 13.91) (-35.5883, 13.8806) (-35.635, 12.9972) (-35.7823, 12.6813) (-36.0557, 12.4652) (-36.6884, 12.3806) (-36.7398, 12.0825) (-36.8939, 11.8429) (-37.297, 11.7245) (-37.6504, 11.9516) (-37.7761, 12.3893) (-38.2278, 12.41) (-38.5437, 12.5573) (-38.7598, 12.8307) (-38.8255, 13.1) (-38.815, 13.8528) (-38.6677, 14.1687) (-38.3943, 14.3848) (-37.7245, 14.4505) (-37.6303, 14.5189) (-37.6444, 15.3087) (-38.2278, 15.36) (-38.6677, 15.6313) (-38.815, 15.9472) (-38.8365, 16.9553) (-40.2074, 16.9745) (-40.4032, 17.0875) (-40.4755, 17.2426) (-40.4944, 18.8752) (-40.6051, 18.9112) (-40.8189, 18.6179) (-41.078, 18.4995) (-41.3601, 18.54) (-41.6352, 18.8575) (-41.6352, 19.1425) (-41.5197, 19.3665) (-41.6556, 19.75) (-41.5754, 20.0234) (-41.3601, 20.21) (-41.078, 20.2505) (-40.8189, 20.1321) (-40.6232, 19.8468) (-40.5076, 19.86) (-40.4755, 20.6) (-43.65, 20.6) (-43.6311, 20.1444) (-43.5204, 20.1084) (-43.222, 20.2505) (-42.9399, 20.21) (-42.7246, 20.0234) (-42.6444, 19.75) (-42.7803, 19.3835) (-42.6444, 19) (-42.7246, 18.7266) (-43.078, 18.4995) (-43.5425, 18.646) (-43.65, 18.5474) (-43.65, 4.699) (-43.551, 4.6) (-38.6245, 4.6) (-38.5663, 4.6189), closed, covered)
  P35_AC1_L4_h0 = polyline(z=-1.44mm, xy in mm: (-37.3601, 18.54) (-37.6352, 18.8575) (-37.6352, 19.1425) (-37.5197, 19.3665) (-37.6352, 19.6075) (-37.6352, 19.8925) (-37.3601, 20.21) (-37.078, 20.2505) (-36.8189, 20.1321) (-36.6648, 19.8925) (-36.6648, 19.6075) (-36.7803, 19.3835) (-36.6444, 19) (-36.8189, 18.6179) (-37.222, 18.4995) (-37.3601, 18.54), closed, covered)
  P35_AC1_L4.subtract(P35_AC1_L4_h0)
  P35_AC1_L4.sweep_along_vector((0mm, 0mm, 0.07mm))
  P36_AC2_L4 = polyline(z=-1.44mm, xy in mm: (-3.8908, 4.6189) (-3.85, 18.5474) (-3.9796, 18.6416) (-4.422, 18.4995) (-4.7754, 18.7266) (-4.8556, 19) (-4.7197, 19.3665) (-4.8556, 19.75) (-4.7754, 20.0234) (-4.5601, 20.21) (-4.278, 20.2505) (-3.8979, 20.1178) (-3.85, 20.6) (-7.0245, 20.6) (-7.0245, 19.933) (-6.9561, 19.8388) (-6.8454, 19.8748) (-6.6811, 20.1321) (-6.422, 20.2505) (-6.1399, 20.21) (-5.9246, 20.0234) (-5.8444, 19.75) (-5.9803, 19.3835) (-5.8648, 19.1425) (-5.8648, 18.8575) (-6.1399, 18.54) (-6.422, 18.4995) (-6.6811, 18.6179) (-6.8768, 18.9032) (-6.9924, 18.89) (-7.0245, 17.2426) (-7.0968, 17.0875) (-7.2926, 16.9745) (-8.663, 16.9556) (-8.685, 15.9472) (-8.8323, 15.6313) (-9.1057, 15.4152) (-9.7755, 15.3495) (-9.8697, 15.2811) (-9.8556, 14.4913) (-9.1057, 14.3848) (-8.7402, 14.0193) (-8.6745, 13.1) (-8.7402, 12.8307) (-8.9563, 12.5573) (-9.2722, 12.41) (-9.7384, 12.3806) (-9.8496, 11.9516) (-10.203, 11.7245) (-10.6061, 11.8429) (-10.7602, 12.0825) (-10.8261, 12.3893) (-11.2778, 12.41) (-11.7177, 12.6813) (-11.865, 12.9972) (-11.8843, 13.8503) (-12.5437, 14.0573) (-12.8455, 14.5492) (-13.363, 14.5894) (-13.5362, 14.7347) (-13.5755, 17.3574) (-13.5032, 17.5125) (-13.3074, 17.6255) (-7.7163, 17.6444) (-7.6944, 18.8752) (-7.8051, 18.9112) (-8.0189, 18.6179) (-8.278, 18.4995) (-8.5601, 18.54) (-8.8352, 18.8575) (-8.8352, 19.1425) (-8.7197, 19.3665) (-8.8556, 19.75) (-8.6976, 20.142) (-8.7577, 20.2417) (-9.962, 20.2306) (-9.9979, 20.1199) (-9.8444, 19.75) (-9.9803, 19.3835) (-9.8648, 19.1425) (-9.8648, 18.8575) (-10.0189, 18.6179) (-10.278, 18.4995) (-10.5601, 18.54) (-10.8352, 18.8575) (-10.8352, 19.1425) (-10.7197, 19.3665) (-10.8352, 19.6075) (-10.8352, 19.8925) (-10.4731, 20.3068) (-10.6382, 20.6) (-10.9401, 20.6) (-11.3863, 20.3261) (-11.9941, 20.1883) (-11.8444, 19.75) (-11.9803, 19.3835) (-11.8648, 19.1425) (-11.8648, 18.8575) (-12.1399, 18.54) (-12.422, 18.4995) (-12.7637, 18.5896) (-12.8, 17.9) (-18.3092, 17.8811) (-18.35, 15) (-19.051, 15) (-19.15, 14.901) (-19.15, 10) (-20.4092, 9.9811) (-20.4311, 8.7413) (-19.8413, 8.7194) (-19.7754, 9.1627) (-19.5085, 9.3705) (-17.9251, 9.3705) (-17.652, 9.4508) (-17.3349, 9.3455) (-8.7745, 9.3455) (-8.6803, 9.4139) (-8.6098, 10.0393) (-8.2443, 10.4048) (-7.975, 10.4705) (-6.0722, 10.46) (-5.7563, 10.3127) (-5.5402, 10.0393) (-5.4745, 9.77) (-5.485, 9.0172) (-5.6323, 8.7013) (-5.9057, 8.4852) (-6.6337, 8.4006) (-6.6745, 7.6195) (-6.6061, 7.5253) (-5.9057, 7.4548) (-5.6323, 7.2387) (-5.485, 6.9228) (-5.485, 6.0672) (-5.6323, 5.7513) (-6.0722, 5.48) (-7.975, 5.4695) (-8.2443, 5.5352) (-8.5177, 5.7513) (-8.665, 6.0672) (-8.6843, 6.9203) (-9.3437, 7.1273) (-9.7014, 7.644) (-12.7344, 7.6445) (-13.0898, 7.1395) (-13.4684, 6.9945) (-14.0522, 7.0009) (-14.5345, 7.2871) (-15.0478, 7.0009) (-15.7022, 7.0009) (-16.0102, 7.1395) (-16.3539, 7.6438) (-18.0329, 7.6445) (-18.4831, 7.5603) (-18.6985, 7.7168) (-18.7808, 7.97) (-18.6032, 8.3185) (-18.35, 8.4008) (-18.0329, 8.2955) (-16.3656, 8.2955) (-16.2714, 8.3639) (-16.1987, 8.6039) (-16.2973, 8.6945) (-17.3349, 8.6945) (-17.652, 8.5892) (-17.9251, 8.6695) (-19.0005, 8.6695) (-19.0947, 8.6011) (-19.1246, 8.2073) (-19.2809, 8.0375) (-20.4092, 7.9806) (-20.4311, 6.1413) (-19.4207, 6.1041) (-19.2317, 6.0304) (-19.1055, 5.8372) (-19.0995, 5.1695) (-19.0005, 5.0705) (-17.9251, 5.0705) (-17.652, 5.1508) (-17.3349, 5.0455) (-11.6745, 5.0455) (-11.5803, 5.1139) (-11.5278, 5.6329) (-11.3379, 5.8228) (-9.3707, 5.8705) (-9.0222, 5.6329) (-8.9975, 4.6705) (-8.9049, 4.6) (-3.949, 4.6) (-3.8908, 4.6189), closed, covered)
  P36_AC2_L4.sweep_along_vector((0mm, 0mm, 0.07mm))
  P37_AC3_L4 = polyline(z=-1.44mm, xy in mm: (8.9337, 4.6189) (8.9774, 5.0147) (9.1028, 5.2522) (9.3403, 5.3776) (9.7755, 5.3805) (9.8745, 5.4795) (9.8556, 6.8387) (9.2121, 6.9272) (8.9774, 7.2453) (8.9774, 7.9647) (9.1028, 8.2022) (9.3403, 8.3276) (11.3379, 8.2828) (11.5755, 7.9343) (11.5726, 7.2453) (11.4138, 6.8982) (11.5077, 6.8305) (12.2879, 6.7828) (12.5397, 6.4731) (13.1013, 6.4744) (13.3997, 6.7906) (13.9565, 6.8055) (14.1633, 6.7331) (14.3255, 6.4365) (14.3255, 5.8235) (14.1831, 5.52) (14.2809, 5.4055) (14.8191, 5.4055) (14.9133, 5.4739) (14.7745, 5.8235) (14.7894, 6.5303) (14.9367, 6.7331) (15.1435, 6.8055) (15.7003, 6.7906) (16.0569, 6.4555) (18.0329, 6.4555) (18.35, 6.5608) (18.6985, 6.3832) (18.7597, 5.9969) (18.4831, 5.7203) (18.0329, 5.8045) (16.0569, 5.8045) (15.8331, 5.52) (15.9309, 5.4055) (17.3349, 5.4055) (17.652, 5.5108) (17.9251, 5.4305) (19.0005, 5.4305) (19.0947, 5.4989) (19.1246, 5.8927) (19.2809, 6.0625) (20.351, 6.1005) (20.4452, 6.1689) (20.4311, 7.9587) (19.4207, 7.9959) (19.2317, 8.0696) (19.1055, 8.2628) (19.0995, 8.9305) (19.0311, 9.0247) (17.9251, 9.0295) (17.652, 8.9492) (17.3349, 9.0545) (8.7745, 9.0545) (8.6803, 8.9861) (8.665, 8.5272) (8.5177, 8.2113) (8.2443, 7.9952) (7.975, 7.9295) (6.0722, 7.94) (5.7563, 8.0873) (5.485, 8.5272) (5.485, 9.3828) (5.6323, 9.6987) (5.9057, 9.9148) (6.5755, 9.9805) (6.6745, 10.0795) (6.6556, 10.8387) (5.9057, 10.9452) (5.6323, 11.1613) (5.485, 11.4772) (5.4745, 12.23) (5.5402, 12.4993) (5.7563, 12.7727) (6.175, 12.9305) (7.975, 12.9305) (8.3937, 12.7727) (8.665, 12.3328) (8.6843, 11.4797) (9.3437, 11.2727) (9.7014, 10.756) (12.7344, 10.7555) (13.0898, 11.2605) (13.4684, 11.4055) (14.0522, 11.3991) (14.5345, 11.1129) (15.0478, 11.3991) (15.7022, 11.3991) (16.0102, 11.2605) (16.3539, 10.7562) (18.0329, 10.7555) (18.4831, 10.8397) (18.6985, 10.6832) (18.7808, 10.43) (18.6985, 10.1768) (18.4831, 10.0203) (18.0329, 10.1045) (16.3656, 10.1045) (16.2714, 10.0361) (16.2225, 9.7398) (17.3349, 9.7055) (17.652, 9.8108) (17.9251, 9.7305) (19.5654, 9.7161) (19.7945, 9.4672) (19.8194, 8.7413) (20.4092, 8.7194) (20.4311, 9.9592) (19.15, 10) (19.15, 14.901) (19.051, 15) (18.35, 15) (18.35, 17.7955) (18.251, 17.8945) (12.8, 17.9) (12.7811, 18.5711) (12.6704, 18.6071) (12.422, 18.4995) (12.1399, 18.54) (11.9246, 18.7266) (11.8444, 19) (11.9803, 19.3665) (11.8444, 19.75) (11.9246, 20.0234) (12.278, 20.2505) (12.7637, 20.1604) (12.8, 20.4505) (12.7316, 20.5447) (7.6755, 20.6) (7.6755, 19.933) (7.7439, 19.8388) (8.1399, 20.21) (8.422, 20.2505) (8.7754, 20.0234) (8.8556, 19.75) (8.7197, 19.3835) (8.8352, 19.1425) (8.8352, 18.8575) (8.6811, 18.6179) (8.278, 18.4995) (8.0189, 18.6179) (7.8232, 18.9032) (7.6775, 18.8367) (7.6755, 17.7245) (7.7439, 17.6303) (13.3074, 17.6255) (13.5606, 17.413) (13.5362, 14.7347) (13.3074, 14.5745) (12.8534, 14.5556) (12.5437, 14.0573) (12.2278, 13.91) (11.9117, 13.8806) (11.865, 12.9972) (11.7177, 12.6813) (11.4443, 12.4652) (10.8116, 12.3806) (10.7602, 12.0825) (10.6061, 11.8429) (10.203, 11.7245) (9.8496, 11.9516) (9.7239, 12.3893) (9.2722, 12.41) (8.9563, 12.5573) (8.7402, 12.8307) (8.6745, 13.1) (8.685, 13.8528) (8.8323, 14.1687) (9.1057, 14.3848) (9.7755, 14.4505) (9.8697, 14.5189) (9.8556, 15.3087) (9.2722, 15.36) (8.8323, 15.6313) (8.685, 15.9472) (8.6635, 16.9553) (7.2926, 16.9745) (7.0968, 17.0875) (7.0245, 17.2426) (7.0056, 18.8752) (6.8949, 18.9112) (6.6811, 18.6179) (6.422, 18.4995) (6.1399, 18.54) (5.8648, 18.8575) (5.8648, 19.1425) (5.9803, 19.3665) (5.8444, 19.75) (5.9246, 20.0234) (6.1399, 20.21) (6.422, 20.2505) (6.6811, 20.1321) (6.8768, 19.8468) (6.9924, 19.86) (7.0245, 20.6) (3.85, 20.6) (3.8689, 20.1444) (3.9796, 20.1084) (4.278, 20.2505) (4.5601, 20.21) (4.7754, 20.0234) (4.8556, 19.75) (4.7197, 19.3835) (4.8556, 19) (4.7754, 18.7266) (4.422, 18.4995) (3.9575, 18.646) (3.85, 18.5474) (3.85, 4.699) (3.949, 4.6) (8.8755, 4.6) (8.9337, 4.6189), closed, covered)
  P37_AC3_L4_h0 = polyline(z=-1.44mm, xy in mm: (10.1399, 18.54) (9.8648, 18.8575) (9.8648, 19.1425) (9.9803, 19.3665) (9.8648, 19.6075) (9.8648, 19.8925) (10.1399, 20.21) (10.422, 20.2505) (10.6811, 20.1321) (10.8352, 19.8925) (10.8352, 19.6075) (10.7197, 19.3835) (10.8556, 19) (10.6811, 18.6179) (10.278, 18.4995) (10.1399, 18.54), closed, covered)
  P37_AC3_L4.subtract(P37_AC3_L4_h0)
  P37_AC3_L4.sweep_along_vector((0mm, 0mm, 0.07mm))
  P38_AC4_L4 = polyline(z=-1.44mm, xy in mm: (43.6092, 4.6189) (43.65, 18.5474) (43.5204, 18.6416) (43.078, 18.4995) (42.7246, 18.7266) (42.6444, 19) (42.7803, 19.3665) (42.6444, 19.75) (42.7246, 20.0234) (42.9399, 20.21) (43.222, 20.2505) (43.6021, 20.1178) (43.65, 20.6) (40.4755, 20.6) (40.4755, 19.933) (40.5439, 19.8388) (40.6546, 19.8748) (40.8189, 20.1321) (41.078, 20.2505) (41.3601, 20.21) (41.5754, 20.0234) (41.6556, 19.75) (41.5197, 19.3835) (41.6352, 19.1425) (41.6352, 18.8575) (41.3601, 18.54) (41.078, 18.4995) (40.8189, 18.6179) (40.6232, 18.9032) (40.5076, 18.89) (40.4755, 17.2426) (40.4032, 17.0875) (40.2074, 16.9745) (38.837, 16.9556) (38.815, 15.9472) (38.6677, 15.6313) (38.3943, 15.4152) (37.7245, 15.3495) (37.6303, 15.2811) (37.6444, 14.4913) (38.3943, 14.3848) (38.7598, 14.0193) (38.8255, 13.1) (38.7598, 12.8307) (38.5437, 12.5573) (38.2278, 12.41) (37.7616, 12.3806) (37.6504, 11.9516) (37.297, 11.7245) (36.8939, 11.8429) (36.7398, 12.0825) (36.6739, 12.3893) (36.2222, 12.41) (35.7823, 12.6813) (35.635, 12.9972) (35.6157, 13.8503) (34.9563, 14.0573) (34.6545, 14.5492) (34.137, 14.5894) (33.9638, 14.7347) (33.9245, 17.3574) (33.9968, 17.5125) (34.1926, 17.6255) (39.7837, 17.6444) (39.8056, 18.8752) (39.6949, 18.9112) (39.4811, 18.6179) (39.222, 18.4995) (38.9399, 18.54) (38.6648, 18.8575) (38.6648, 19.1425) (38.7803, 19.3665) (38.6444, 19.75) (38.8024, 20.142) (38.7423, 20.2417) (37.538, 20.2306) (37.5021, 20.1199) (37.6556, 19.75) (37.5197, 19.3835) (37.6352, 19.1425) (37.6352, 18.8575) (37.4811, 18.6179) (37.222, 18.4995) (36.9399, 18.54) (36.6648, 18.8575) (36.6648, 19.1425) (36.7803, 19.3665) (36.6648, 19.6075) (36.6648, 19.8925) (37.0269, 20.3068) (36.8618, 20.6) (36.5599, 20.6) (36.1137, 20.3261) (35.5059, 20.1883) (35.6556, 19.75) (35.5197, 19.3835) (35.6352, 19.1425) (35.6352, 18.8575) (35.3601, 18.54) (35.078, 18.4995) (34.7363, 18.5896) (34.7, 17.9) (29.1908, 17.8756) (29.15, 15) (28.449, 15) (28.35, 14.901) (28.35, 10) (27.0908, 9.9811) (27.0689, 8.7413) (27.6587, 8.7194) (27.7246, 9.1627) (27.9915, 9.3705) (29.5749, 9.3705) (29.848, 9.4508) (30.1651, 9.3455) (38.7255, 9.3455) (38.8197, 9.4139) (38.8902, 10.0393) (39.2557, 10.4048) (39.525, 10.4705) (41.4278, 10.46) (41.7437, 10.3127) (41.9598, 10.0393) (42.0255, 9.77) (42.015, 9.0172) (41.8677, 8.7013) (41.5943, 8.4852) (40.8663, 8.4006) (40.8255, 7.6195) (40.8939, 7.5253) (41.5943, 7.4548) (41.8677, 7.2387) (42.015, 6.9228) (42.015, 6.0672) (41.8677, 5.7513) (41.4278, 5.48) (39.525, 5.4695) (39.2557, 5.5352) (38.9823, 5.7513) (38.835, 6.0672) (38.8157, 6.9203) (38.1563, 7.1273) (37.7986, 7.644) (34.7656, 7.6445) (34.4102, 7.1395) (34.0316, 6.9945) (33.4478, 7.0009) (32.9655, 7.2871) (32.4522, 7.0009) (31.7978, 7.0009) (31.4898, 7.1395) (31.1461, 7.6438) (29.4671, 7.6445) (29.0169, 7.5603) (28.8015, 7.7168) (28.7192, 7.97) (28.8968, 8.3185) (29.15, 8.4008) (29.4671, 8.2955) (31.1344, 8.2955) (31.2286, 8.3639) (31.3013, 8.6039) (31.2027, 8.6945) (30.1651, 8.6945) (29.848, 8.5892) (29.5749, 8.6695) (28.4995, 8.6695) (28.4053, 8.6011) (28.3754, 8.2073) (28.2191, 8.0375) (27.0908, 7.9806) (27.0689, 6.1413) (28.0793, 6.1041) (28.2683, 6.0304) (28.3945, 5.8372) (28.4005, 5.1695) (28.4995, 5.0705) (29.5749, 5.0705) (29.848, 5.1508) (30.1651, 5.0455) (35.8255, 5.0455) (35.9197, 5.1139) (35.9722, 5.6329) (36.1621, 5.8228) (38.1293, 5.8705) (38.4778, 5.6329) (38.5025, 4.6705) (38.5951, 4.6) (43.551, 4.6) (43.6092, 4.6189), closed, covered)
  P38_AC4_L4.sweep_along_vector((0mm, 0mm, 0.07mm))
  V0_DCP = cylinder(axis=Z, base_centre=(-16.5mm, 2.5mm, -1.44mm), radius=0.15mm, height=1.68mm)
  V1_DCP = cylinder(axis=Z, base_centre=(-35.5mm, 2.5mm, -1.44mm), radius=0.15mm, height=1.68mm)
  V2_DCP = cylinder(axis=Z, base_centre=(29.2mm, 2.5mm, -1.44mm), radius=0.15mm, height=1.68mm)
  V3_DCP = cylinder(axis=Z, base_centre=(35.5mm, 2.5mm, -1.44mm), radius=0.15mm, height=1.68mm)
  V4_DCP = cylinder(axis=Z, base_centre=(-33.7mm, 2.5mm, -1.44mm), radius=0.15mm, height=1.68mm)
  V5_DCP = cylinder(axis=Z, base_centre=(-18.3mm, 2.5mm, -1.44mm), radius=0.15mm, height=1.68mm)
  V6_DCP = cylinder(axis=Z, base_centre=(12mm, 2.5mm, -1.44mm), radius=0.15mm, height=1.68mm)
  V7_DCP = cylinder(axis=Z, base_centre=(-12mm, 2.5mm, -1.44mm), radius=0.15mm, height=1.68mm)
  V8_DCP = cylinder(axis=Z, base_centre=(33.7mm, 2.5mm, -1.44mm), radius=0.15mm, height=1.68mm)
  V9_DCP = cylinder(axis=Z, base_centre=(-13.8mm, 2.5mm, -1.44mm), radius=0.15mm, height=1.68mm)
  V10_DCP = cylinder(axis=Z, base_centre=(12.9mm, 2.5mm, -1.44mm), radius=0.15mm, height=1.68mm)
  V11_DCP = cylinder(axis=Z, base_centre=(-31mm, 2.5mm, -1.44mm), radius=0.15mm, height=1.68mm)
  V12_DCP = cylinder(axis=Z, base_centre=(16.5mm, 2.5mm, -1.44mm), radius=0.15mm, height=1.68mm)
  V13_DCP = cylinder(axis=Z, base_centre=(-12.9mm, 2.5mm, -1.44mm), radius=0.15mm, height=1.68mm)
  V14_DCP = cylinder(axis=Z, base_centre=(-15.6mm, 2.5mm, -1.44mm), radius=0.15mm, height=1.68mm)
  V15_DCP = cylinder(axis=Z, base_centre=(-14.7mm, 2.5mm, -1.44mm), radius=0.15mm, height=1.68mm)
  V16_DCP = cylinder(axis=Z, base_centre=(34.6mm, 2.5mm, -1.44mm), radius=0.15mm, height=1.68mm)
  V17_DCP = cylinder(axis=Z, base_centre=(14.7mm, 2.5mm, -1.44mm), radius=0.15mm, height=1.68mm)
  V18_DCP = cylinder(axis=Z, base_centre=(-29.2mm, 2.5mm, -1.44mm), radius=0.15mm, height=1.68mm)
  V19_DCP = cylinder(axis=Z, base_centre=(-31.9mm, 2.5mm, -1.44mm), radius=0.15mm, height=1.68mm)
  V20_DCP = cylinder(axis=Z, base_centre=(15.6mm, 2.5mm, -1.44mm), radius=0.15mm, height=1.68mm)
  V21_DCP = cylinder(axis=Z, base_centre=(32.8mm, 2.5mm, -1.44mm), radius=0.15mm, height=1.68mm)
  V22_DCP = cylinder(axis=Z, base_centre=(30.1mm, 2.5mm, -1.44mm), radius=0.15mm, height=1.68mm)
  V23_DCP = cylinder(axis=Z, base_centre=(-32.8mm, 2.5mm, -1.44mm), radius=0.15mm, height=1.68mm)
  V24_DCP = cylinder(axis=Z, base_centre=(31mm, 2.5mm, -1.44mm), radius=0.15mm, height=1.68mm)
  V25_DCP = cylinder(axis=Z, base_centre=(31.9mm, 2.5mm, -1.44mm), radius=0.15mm, height=1.68mm)
  V26_DCP = cylinder(axis=Z, base_centre=(-30.1mm, 2.5mm, -1.44mm), radius=0.15mm, height=1.68mm)
  V27_DCP = cylinder(axis=Z, base_centre=(17.4mm, 2.5mm, -1.44mm), radius=0.15mm, height=1.68mm)
  V28_DCP = cylinder(axis=Z, base_centre=(18.3mm, 2.5mm, -1.44mm), radius=0.15mm, height=1.68mm)
  V29_DCP = cylinder(axis=Z, base_centre=(-34.6mm, 2.5mm, -1.44mm), radius=0.15mm, height=1.68mm)
  V30_DCP = cylinder(axis=Z, base_centre=(13.8mm, 2.5mm, -1.44mm), radius=0.15mm, height=1.68mm)
  V31_DCP = cylinder(axis=Z, base_centre=(-17.4mm, 2.5mm, -1.44mm), radius=0.15mm, height=1.68mm)
  V32_DCN = cylinder(axis=Z, base_centre=(16.6423mm, -0.5mm, -1.44mm), radius=0.15mm, height=1.68mm)
  V33_DCN = cylinder(axis=Z, base_centre=(11.9038mm, -0.5mm, -1.44mm), radius=0.15mm, height=1.68mm)
  V34_DCN = cylinder(axis=Z, base_centre=(-37.15mm, 19.75mm, -1.44mm), radius=0.15mm, height=1.68mm)
  V35_DCN = cylinder(axis=Z, base_centre=(14.675mm, 10.28mm, 0mm), radius=0.15mm, height=0.24mm)
  V36_DCN = cylinder(axis=Z, base_centre=(19.0115mm, -0.5mm, -1.44mm), radius=0.15mm, height=1.68mm)
  V37_DCN = cylinder(axis=Z, base_centre=(-6.35mm, 19.75mm, -1.44mm), radius=0.15mm, height=1.68mm)
  V38_DCN = cylinder(axis=Z, base_centre=(8.35mm, -0.5mm, -1.44mm), radius=0.15mm, height=1.68mm)
  V39_DCN = cylinder(axis=Z, base_centre=(34.525mm, 10.28mm, 0mm), radius=0.15mm, height=0.24mm)
  V40_DCN = cylinder(axis=Z, base_centre=(43.15mm, 19.75mm, -1.44mm), radius=0.15mm, height=1.68mm)
  V41_DCN = cylinder(axis=Z, base_centre=(-37.225mm, 12.225mm, -1.44mm), radius=0.15mm, height=1.68mm)
  V42_DCN = cylinder(axis=Z, base_centre=(12.975mm, 9.2mm, 0mm), radius=0.15mm, height=0.24mm)
  V43_DCN = cylinder(axis=Z, base_centre=(37.15mm, 19.75mm, -1.44mm), radius=0.15mm, height=1.68mm)
  V44_DCN = cylinder(axis=Z, base_centre=(14.675mm, 9.2mm, 0mm), radius=0.15mm, height=0.24mm)
  V45_DCN = cylinder(axis=Z, base_centre=(-1.15mm, -0.5mm, -1.44mm), radius=0.15mm, height=1.68mm)
  V46_DCN = cylinder(axis=Z, base_centre=(12.975mm, 8.12mm, 0mm), radius=0.15mm, height=0.24mm)
  V47_DCN = cylinder(axis=Z, base_centre=(29.6731mm, -0.5mm, -1.44mm), radius=0.15mm, height=1.68mm)
  V48_DCN = cylinder(axis=Z, base_centre=(-32.825mm, 8.12mm, 0mm), radius=0.15mm, height=0.24mm)
  V49_DCN = cylinder(axis=Z, base_centre=(6.05mm, -0.5mm, -1.44mm), radius=0.15mm, height=1.68mm)
  V50_DCN = cylinder(axis=Z, base_centre=(35.15mm, 19.75mm, -1.44mm), radius=0.15mm, height=1.68mm)
  V51_DCN = cylinder(axis=Z, base_centre=(37.225mm, 12.225mm, -1.44mm), radius=0.15mm, height=1.68mm)
  V52_DCN = cylinder(axis=Z, base_centre=(15.4577mm, -0.5mm, -1.44mm), radius=0.15mm, height=1.68mm)
  V53_DCN = cylinder(axis=Z, base_centre=(-37.9654mm, -0.5mm, -1.44mm), radius=0.15mm, height=1.68mm)
  V54_DCN = cylinder(axis=Z, base_centre=(36.7808mm, -0.5mm, -1.44mm), radius=0.15mm, height=1.68mm)
  V55_DCN = cylinder(axis=Z, base_centre=(4.35mm, 19mm, -1.44mm), radius=0.15mm, height=1.68mm)
  V56_DCN = cylinder(axis=Z, base_centre=(-12.975mm, 8.12mm, 0mm), radius=0.15mm, height=0.24mm)
  V57_DCN = cylinder(axis=Z, base_centre=(28.4885mm, -0.5mm, -1.44mm), radius=0.15mm, height=1.68mm)
  V58_DCN = cylinder(axis=Z, base_centre=(-16.6423mm, -0.5mm, -1.44mm), radius=0.15mm, height=1.68mm)
  V59_DCN = cylinder(axis=Z, base_centre=(9.5346mm, -0.5mm, -1.44mm), radius=0.15mm, height=1.68mm)
  V60_DCN = cylinder(axis=Z, base_centre=(-12.975mm, 9.2mm, 0mm), radius=0.15mm, height=0.24mm)
  V61_DCN = cylinder(axis=Z, base_centre=(12.975mm, 10.28mm, 0mm), radius=0.15mm, height=0.24mm)
  V62_DCN = cylinder(axis=Z, base_centre=(34.525mm, 8.12mm, 0mm), radius=0.15mm, height=0.24mm)
  V63_DCN = cylinder(axis=Z, base_centre=(21.3808mm, -0.5mm, -1.44mm), radius=0.15mm, height=1.68mm)
  V64_DCN = cylinder(axis=Z, base_centre=(39.15mm, 19mm, -1.44mm), radius=0.15mm, height=1.68mm)
  V65_DCN = cylinder(axis=Z, base_centre=(-39.15mm, -0.5mm, -1.44mm), radius=0.15mm, height=1.68mm)
  V66_DCN = cylinder(axis=Z, base_centre=(43.15mm, 19mm, -1.44mm), radius=0.15mm, height=1.68mm)
  V67_DCN = cylinder(axis=Z, base_centre=(39.15mm, 19.75mm, -1.44mm), radius=0.15mm, height=1.68mm)
  V68_DCN = cylinder(axis=Z, base_centre=(-10.35mm, 19mm, -1.44mm), radius=0.15mm, height=1.68mm)
  V69_DCN = cylinder(axis=Z, base_centre=(-4.75mm, -0.5mm, -1.44mm), radius=0.15mm, height=1.68mm)
  V70_DCN = cylinder(axis=Z, base_centre=(-15.4577mm, -0.5mm, -1.44mm), radius=0.15mm, height=1.68mm)
  V71_DCN = cylinder(axis=Z, base_centre=(32.825mm, 10.28mm, 0mm), radius=0.15mm, height=0.24mm)
  V72_DCN = cylinder(axis=Z, base_centre=(0.05mm, -0.5mm, -1.44mm), radius=0.15mm, height=1.68mm)
  V73_DCN = cylinder(axis=Z, base_centre=(27.3038mm, -0.5mm, -1.44mm), radius=0.15mm, height=1.68mm)
  V74_DCN = cylinder(axis=Z, base_centre=(-5.95mm, -0.5mm, -1.44mm), radius=0.15mm, height=1.68mm)
  V75_DCN = cylinder(axis=Z, base_centre=(10.275mm, 12.225mm, -1.44mm), radius=0.15mm, height=1.68mm)
  V76_DCN = cylinder(axis=Z, base_centre=(-17.8269mm, -0.5mm, -1.44mm), radius=0.15mm, height=1.68mm)
  V77_DCN = cylinder(axis=Z, base_centre=(-23.75mm, -0.5mm, -1.44mm), radius=0.15mm, height=1.68mm)
  V78_DCN = cylinder(axis=Z, base_centre=(-35.15mm, 19mm, -1.44mm), radius=0.15mm, height=1.68mm)
  V79_DCN = cylinder(axis=Z, base_centre=(-13.0885mm, -0.5mm, -1.44mm), radius=0.15mm, height=1.68mm)
  V80_DCN = cylinder(axis=Z, base_centre=(34.525mm, 9.2mm, 0mm), radius=0.15mm, height=0.24mm)
  V81_DCN = cylinder(axis=Z, base_centre=(34.4115mm, -0.5mm, -1.44mm), radius=0.15mm, height=1.68mm)
  V82_DCN = cylinder(axis=Z, base_centre=(-4.35mm, 19.75mm, -1.44mm), radius=0.15mm, height=1.68mm)
  V83_DCN = cylinder(axis=Z, base_centre=(2.45mm, -0.5mm, -1.44mm), radius=0.15mm, height=1.68mm)
  V84_DCN = cylinder(axis=Z, base_centre=(33.2269mm, -0.5mm, -1.44mm), radius=0.15mm, height=1.68mm)
  V85_DCN = cylinder(axis=Z, base_centre=(6.35mm, 19.75mm, -1.44mm), radius=0.15mm, height=1.68mm)
  V86_DCN = cylinder(axis=Z, base_centre=(22.5654mm, -0.5mm, -1.44mm), radius=0.15mm, height=1.68mm)
  V87_DCN = cylinder(axis=Z, base_centre=(30.8577mm, -0.5mm, -1.44mm), radius=0.15mm, height=1.68mm)
  V88_DCN = cylinder(axis=Z, base_centre=(3.65mm, -0.5mm, -1.44mm), radius=0.15mm, height=1.68mm)
  V89_DCN = cylinder(axis=Z, base_centre=(-34.525mm, 8.12mm, 0mm), radius=0.15mm, height=0.24mm)
  V90_DCN = cylinder(axis=Z, base_centre=(-22.5654mm, -0.5mm, -1.44mm), radius=0.15mm, height=1.68mm)
  V91_DCN = cylinder(axis=Z, base_centre=(-29.6731mm, -0.5mm, -1.44mm), radius=0.15mm, height=1.68mm)
  V92_DCN = cylinder(axis=Z, base_centre=(-19.0115mm, -0.5mm, -1.44mm), radius=0.15mm, height=1.68mm)
  V93_DCN = cylinder(axis=Z, base_centre=(-35.15mm, 19.75mm, -1.44mm), radius=0.15mm, height=1.68mm)
  V94_DCN = cylinder(axis=Z, base_centre=(-41.15mm, 19mm, -1.44mm), radius=0.15mm, height=1.68mm)
  V95_DCN = cylinder(axis=Z, base_centre=(23.75mm, -0.5mm, -1.44mm), radius=0.15mm, height=1.68mm)
  V96_DCN = cylinder(axis=Z, base_centre=(-37.15mm, 19mm, -1.44mm), radius=0.15mm, height=1.68mm)
  V97_DCN = cylinder(axis=Z, base_centre=(24.9346mm, -0.5mm, -1.44mm), radius=0.15mm, height=1.68mm)
  V98_DCN = cylinder(axis=Z, base_centre=(-39.15mm, 19.75mm, -1.44mm), radius=0.15mm, height=1.68mm)
  V99_DCN = cylinder(axis=Z, base_centre=(10.35mm, 19.75mm, -1.44mm), radius=0.15mm, height=1.68mm)
  V100_DCN = cylinder(axis=Z, base_centre=(12.35mm, 19.75mm, -1.44mm), radius=0.15mm, height=1.68mm)
  V101_DCN = cylinder(axis=Z, base_centre=(-14.675mm, 8.12mm, 0mm), radius=0.15mm, height=0.24mm)
  V102_DCN = cylinder(axis=Z, base_centre=(-8.35mm, -0.5mm, -1.44mm), radius=0.15mm, height=1.68mm)
  V103_DCN = cylinder(axis=Z, base_centre=(35.5962mm, -0.5mm, -1.44mm), radius=0.15mm, height=1.68mm)
  V104_DCN = cylinder(axis=Z, base_centre=(41.15mm, 19mm, -1.44mm), radius=0.15mm, height=1.68mm)
  V105_DCN = cylinder(axis=Z, base_centre=(-12.35mm, 19.75mm, -1.44mm), radius=0.15mm, height=1.68mm)
  V106_DCN = cylinder(axis=Z, base_centre=(-34.525mm, 9.2mm, 0mm), radius=0.15mm, height=0.24mm)
  V107_DCN = cylinder(axis=Z, base_centre=(26.1192mm, -0.5mm, -1.44mm), radius=0.15mm, height=1.68mm)
  V108_DCN = cylinder(axis=Z, base_centre=(-35.5962mm, -0.5mm, -1.44mm), radius=0.15mm, height=1.68mm)
  V109_DCN = cylinder(axis=Z, base_centre=(32.0423mm, -0.5mm, -1.44mm), radius=0.15mm, height=1.68mm)
  V110_DCN = cylinder(axis=Z, base_centre=(-7.15mm, -0.5mm, -1.44mm), radius=0.15mm, height=1.68mm)
  V111_DCN = cylinder(axis=Z, base_centre=(-3.55mm, -0.5mm, -1.44mm), radius=0.15mm, height=1.68mm)
  V112_DCN = cylinder(axis=Z, base_centre=(-12.975mm, 10.28mm, 0mm), radius=0.15mm, height=0.24mm)
  V113_DCN = cylinder(axis=Z, base_centre=(-33.2269mm, -0.5mm, -1.44mm), radius=0.15mm, height=1.68mm)
  V114_DCN = cylinder(axis=Z, base_centre=(-26.1192mm, -0.5mm, -1.44mm), radius=0.15mm, height=1.68mm)
  V115_DCN = cylinder(axis=Z, base_centre=(4.85mm, -0.5mm, -1.44mm), radius=0.15mm, height=1.68mm)
  V116_DCN = cylinder(axis=Z, base_centre=(-20.1962mm, -0.5mm, -1.44mm), radius=0.15mm, height=1.68mm)
  V117_DCN = cylinder(axis=Z, base_centre=(-2.35mm, -0.5mm, -1.44mm), radius=0.15mm, height=1.68mm)
  V118_DCN = cylinder(axis=Z, base_centre=(37.15mm, 19mm, -1.44mm), radius=0.15mm, height=1.68mm)
  V119_DCN = cylinder(axis=Z, base_centre=(-28.4885mm, -0.5mm, -1.44mm), radius=0.15mm, height=1.68mm)
  V120_DCN = cylinder(axis=Z, base_centre=(-30.8577mm, -0.5mm, -1.44mm), radius=0.15mm, height=1.68mm)
  V121_DCN = cylinder(axis=Z, base_centre=(12.35mm, 19mm, -1.44mm), radius=0.15mm, height=1.68mm)
  V122_DCN = cylinder(axis=Z, base_centre=(8.35mm, 19.75mm, -1.44mm), radius=0.15mm, height=1.68mm)
  V123_DCN = cylinder(axis=Z, base_centre=(8.35mm, 19mm, -1.44mm), radius=0.15mm, height=1.68mm)
  V124_DCN = cylinder(axis=Z, base_centre=(13.0885mm, -0.5mm, -1.44mm), radius=0.15mm, height=1.68mm)
  V125_DCN = cylinder(axis=Z, base_centre=(-32.825mm, 10.28mm, 0mm), radius=0.15mm, height=0.24mm)
  V126_DCN = cylinder(axis=Z, base_centre=(-34.4115mm, -0.5mm, -1.44mm), radius=0.15mm, height=1.68mm)
  V127_DCN = cylinder(axis=Z, base_centre=(-14.675mm, 9.2mm, 0mm), radius=0.15mm, height=0.24mm)
  V128_DCN = cylinder(axis=Z, base_centre=(-39.15mm, 19mm, -1.44mm), radius=0.15mm, height=1.68mm)
  V129_DCN = cylinder(axis=Z, base_centre=(-34.525mm, 10.28mm, 0mm), radius=0.15mm, height=0.24mm)
  V130_DCN = cylinder(axis=Z, base_centre=(-24.9346mm, -0.5mm, -1.44mm), radius=0.15mm, height=1.68mm)
  V131_DCN = cylinder(axis=Z, base_centre=(41.15mm, 19.75mm, -1.44mm), radius=0.15mm, height=1.68mm)
  V132_DCN = cylinder(axis=Z, base_centre=(35.15mm, 19mm, -1.44mm), radius=0.15mm, height=1.68mm)
  V133_DCN = cylinder(axis=Z, base_centre=(-8.35mm, 19mm, -1.44mm), radius=0.15mm, height=1.68mm)
  V134_DCN = cylinder(axis=Z, base_centre=(-10.275mm, 12.225mm, -1.44mm), radius=0.15mm, height=1.68mm)
  V135_DCN = cylinder(axis=Z, base_centre=(17.8269mm, -0.5mm, -1.44mm), radius=0.15mm, height=1.68mm)
  V136_DCN = cylinder(axis=Z, base_centre=(10.7192mm, -0.5mm, -1.44mm), radius=0.15mm, height=1.68mm)
  V137_DCN = cylinder(axis=Z, base_centre=(-41.15mm, 19.75mm, -1.44mm), radius=0.15mm, height=1.68mm)
  V138_DCN = cylinder(axis=Z, base_centre=(-8.35mm, 19.75mm, -1.44mm), radius=0.15mm, height=1.68mm)
  V139_DCN = cylinder(axis=Z, base_centre=(-12.35mm, 19mm, -1.44mm), radius=0.15mm, height=1.68mm)
  V140_DCN = cylinder(axis=Z, base_centre=(1.25mm, -0.5mm, -1.44mm), radius=0.15mm, height=1.68mm)
  V141_DCN = cylinder(axis=Z, base_centre=(10.35mm, 19mm, -1.44mm), radius=0.15mm, height=1.68mm)
  V142_DCN = cylinder(axis=Z, base_centre=(32.825mm, 8.12mm, 0mm), radius=0.15mm, height=0.24mm)
  V143_DCN = cylinder(axis=Z, base_centre=(39.15mm, -0.5mm, -1.44mm), radius=0.15mm, height=1.68mm)
  V144_DCN = cylinder(axis=Z, base_centre=(-43.15mm, 19.75mm, -1.44mm), radius=0.15mm, height=1.68mm)
  V145_DCN = cylinder(axis=Z, base_centre=(6.35mm, 19mm, -1.44mm), radius=0.15mm, height=1.68mm)
  V146_DCN = cylinder(axis=Z, base_centre=(14.675mm, 8.12mm, 0mm), radius=0.15mm, height=0.24mm)
  V147_DCN = cylinder(axis=Z, base_centre=(-6.35mm, 19mm, -1.44mm), radius=0.15mm, height=1.68mm)
  V148_DCN = cylinder(axis=Z, base_centre=(14.2731mm, -0.5mm, -1.44mm), radius=0.15mm, height=1.68mm)
  V149_DCN = cylinder(axis=Z, base_centre=(-36.7808mm, -0.5mm, -1.44mm), radius=0.15mm, height=1.68mm)
  V150_DCN = cylinder(axis=Z, base_centre=(-32.825mm, 9.2mm, 0mm), radius=0.15mm, height=0.24mm)
  V151_DCN = cylinder(axis=Z, base_centre=(-4.35mm, 19mm, -1.44mm), radius=0.15mm, height=1.68mm)
  V152_DCN = cylinder(axis=Z, base_centre=(37.9654mm, -0.5mm, -1.44mm), radius=0.15mm, height=1.68mm)
  V153_DCN = cylinder(axis=Z, base_centre=(-27.3038mm, -0.5mm, -1.44mm), radius=0.15mm, height=1.68mm)
  V154_DCN = cylinder(axis=Z, base_centre=(-9.5346mm, -0.5mm, -1.44mm), radius=0.15mm, height=1.68mm)
  V155_DCN = cylinder(axis=Z, base_centre=(-21.3808mm, -0.5mm, -1.44mm), radius=0.15mm, height=1.68mm)
  V156_DCN = cylinder(axis=Z, base_centre=(-32.0423mm, -0.5mm, -1.44mm), radius=0.15mm, height=1.68mm)
  V157_DCN = cylinder(axis=Z, base_centre=(4.35mm, 19.75mm, -1.44mm), radius=0.15mm, height=1.68mm)
  V158_DCN = cylinder(axis=Z, base_centre=(-10.35mm, 19.75mm, -1.44mm), radius=0.15mm, height=1.68mm)
  V159_DCN = cylinder(axis=Z, base_centre=(-14.675mm, 10.28mm, 0mm), radius=0.15mm, height=0.24mm)
  V160_DCN = cylinder(axis=Z, base_centre=(-11.9038mm, -0.5mm, -1.44mm), radius=0.15mm, height=1.68mm)
  V161_DCN = cylinder(axis=Z, base_centre=(-14.2731mm, -0.5mm, -1.44mm), radius=0.15mm, height=1.68mm)
  V162_DCN = cylinder(axis=Z, base_centre=(-43.15mm, 19mm, -1.44mm), radius=0.15mm, height=1.68mm)
  V163_DCN = cylinder(axis=Z, base_centre=(20.1962mm, -0.5mm, -1.44mm), radius=0.15mm, height=1.68mm)
  V164_DCN = cylinder(axis=Z, base_centre=(32.825mm, 9.2mm, 0mm), radius=0.15mm, height=0.24mm)
  V165_DCN = cylinder(axis=Z, base_centre=(-10.7192mm, -0.5mm, -1.44mm), radius=0.15mm, height=1.68mm)
  V166_AC3 = cylinder(axis=Z, base_centre=(18.3mm, 7.05mm, -1.44mm), radius=0.15mm, height=1.68mm)
  V167_AC1 = cylinder(axis=Z, base_centre=(-29.2mm, 7.05mm, -1.44mm), radius=0.15mm, height=1.68mm)
  V168_AC4 = cylinder(axis=Z, base_centre=(29.2mm, 7.05mm, -1.44mm), radius=0.15mm, height=1.68mm)
  V169_AC2 = cylinder(axis=Z, base_centre=(-18.3mm, 7.05mm, -1.44mm), radius=0.15mm, height=1.68mm)
  Q6_3 = box(corner=(31.65mm, 3.1mm, 0.17mm), size=(0.65mm, 3.6mm, 0.105mm))
  Q6_4 = box(corner=(32.5mm, 3.1mm, 0.17mm), size=(0.65mm, 3.6mm, 0.105mm))
  Q6_5 = box(corner=(33.35mm, 3.1mm, 0.17mm), size=(0.65mm, 3.6mm, 0.105mm))
  Q6_6 = box(corner=(34.2mm, 3.1mm, 0.17mm), size=(0.65mm, 3.6mm, 0.105mm))
  Q6_7 = box(corner=(35.051mm, 3.1mm, 0.17mm), size=(1.102mm, 3.6mm, 0.105mm))
  Q3_3 = box(corner=(-32.3mm, 7.4mm, 0.17mm), size=(0.65mm, 3.6mm, 0.105mm))
  Q3_4 = box(corner=(-33.15mm, 7.4mm, 0.17mm), size=(0.65mm, 3.6mm, 0.105mm))
  Q3_5 = box(corner=(-34mm, 7.4mm, 0.17mm), size=(0.65mm, 3.6mm, 0.105mm))
  Q3_6 = box(corner=(-34.85mm, 7.4mm, 0.17mm), size=(0.65mm, 3.6mm, 0.105mm))
  Q3_7 = box(corner=(-36.153mm, 7.4mm, 0.17mm), size=(1.102mm, 3.6mm, 0.105mm))
  Q5_3 = box(corner=(15.2mm, 3.1mm, 0.17mm), size=(0.65mm, 3.6mm, 0.105mm))
  Q5_4 = box(corner=(14.35mm, 3.1mm, 0.17mm), size=(0.65mm, 3.6mm, 0.105mm))
  Q5_5 = box(corner=(13.5mm, 3.1mm, 0.17mm), size=(0.65mm, 3.6mm, 0.105mm))
  Q5_6 = box(corner=(12.65mm, 3.1mm, 0.17mm), size=(0.65mm, 3.6mm, 0.105mm))
  Q5_7 = box(corner=(11.347mm, 3.1mm, 0.17mm), size=(1.102mm, 3.6mm, 0.105mm))
  Q4_3 = box(corner=(-15.85mm, 7.4mm, 0.17mm), size=(0.65mm, 3.6mm, 0.105mm))
  Q4_4 = box(corner=(-15mm, 7.4mm, 0.17mm), size=(0.65mm, 3.6mm, 0.105mm))
  Q4_5 = box(corner=(-14.15mm, 7.4mm, 0.17mm), size=(0.65mm, 3.6mm, 0.105mm))
  Q4_6 = box(corner=(-13.3mm, 7.4mm, 0.17mm), size=(0.65mm, 3.6mm, 0.105mm))
  Q4_7 = box(corner=(-12.449mm, 7.4mm, 0.17mm), size=(1.102mm, 3.6mm, 0.105mm))
  Q2_3 = box(corner=(-15.85mm, 3.1mm, 0.17mm), size=(0.65mm, 3.6mm, 0.105mm))
  Q2_4 = box(corner=(-15mm, 3.1mm, 0.17mm), size=(0.65mm, 3.6mm, 0.105mm))
  Q2_5 = box(corner=(-14.15mm, 3.1mm, 0.17mm), size=(0.65mm, 3.6mm, 0.105mm))
  Q2_6 = box(corner=(-13.3mm, 3.1mm, 0.17mm), size=(0.65mm, 3.6mm, 0.105mm))
  Q2_7 = box(corner=(-12.449mm, 3.1mm, 0.17mm), size=(1.102mm, 3.6mm, 0.105mm))
  Q7_3 = box(corner=(15.2mm, 7.4mm, 0.17mm), size=(0.65mm, 3.6mm, 0.105mm))
  Q7_4 = box(corner=(14.35mm, 7.4mm, 0.17mm), size=(0.65mm, 3.6mm, 0.105mm))
  Q7_5 = box(corner=(13.5mm, 7.4mm, 0.17mm), size=(0.65mm, 3.6mm, 0.105mm))
  Q7_6 = box(corner=(12.65mm, 7.4mm, 0.17mm), size=(0.65mm, 3.6mm, 0.105mm))
  Q7_7 = box(corner=(11.347mm, 7.4mm, 0.17mm), size=(1.102mm, 3.6mm, 0.105mm))
  Q8_3 = box(corner=(31.65mm, 7.4mm, 0.17mm), size=(0.65mm, 3.6mm, 0.105mm))
  Q8_4 = box(corner=(32.5mm, 7.4mm, 0.17mm), size=(0.65mm, 3.6mm, 0.105mm))
  Q8_5 = box(corner=(33.35mm, 7.4mm, 0.17mm), size=(0.65mm, 3.6mm, 0.105mm))
  Q8_6 = box(corner=(34.2mm, 7.4mm, 0.17mm), size=(0.65mm, 3.6mm, 0.105mm))
  Q8_7 = box(corner=(35.051mm, 7.4mm, 0.17mm), size=(1.102mm, 3.6mm, 0.105mm))
  Q1_3 = box(corner=(-32.3mm, 3.1mm, 0.17mm), size=(0.65mm, 3.6mm, 0.105mm))
  Q1_4 = box(corner=(-33.15mm, 3.1mm, 0.17mm), size=(0.65mm, 3.6mm, 0.105mm))
  Q1_5 = box(corner=(-34mm, 3.1mm, 0.17mm), size=(0.65mm, 3.6mm, 0.105mm))
  Q1_6 = box(corner=(-34.85mm, 3.1mm, 0.17mm), size=(0.65mm, 3.6mm, 0.105mm))
  Q1_7 = box(corner=(-36.153mm, 3.1mm, 0.17mm), size=(1.102mm, 3.6mm, 0.105mm))
  C12_1 = box(corner=(-10.975mm, 1.55mm, 0.17mm), size=(1.45mm, 1mm, 0.105mm))
  C12_2 = box(corner=(-10.975mm, -0.35mm, 0.17mm), size=(1.45mm, 1mm, 0.105mm))
  C4_1 = box(corner=(-33.175mm, 1.55mm, 0.17mm), size=(1.45mm, 1mm, 0.105mm))
  C4_2 = box(corner=(-33.175mm, -0.35mm, 0.17mm), size=(1.45mm, 1mm, 0.105mm))
  C3_1 = box(corner=(-34.775mm, 1.55mm, 0.17mm), size=(1.45mm, 1mm, 0.105mm))
  C3_2 = box(corner=(-34.775mm, -0.35mm, 0.17mm), size=(1.45mm, 1mm, 0.105mm))
  C34_1 = box(corner=(9.525mm, 1.55mm, 0.17mm), size=(1.45mm, 1mm, 0.105mm))
  C34_2 = box(corner=(9.525mm, -0.35mm, 0.17mm), size=(1.45mm, 1mm, 0.105mm))
  C9_1 = box(corner=(-15.775mm, 1.55mm, 0.17mm), size=(1.45mm, 1mm, 0.105mm))
  C9_2 = box(corner=(-15.775mm, -0.35mm, 0.17mm), size=(1.45mm, 1mm, 0.105mm))
  C36_1 = box(corner=(12.725mm, 1.55mm, 0.17mm), size=(1.45mm, 1mm, 0.105mm))
  C36_2 = box(corner=(12.725mm, -0.35mm, 0.17mm), size=(1.45mm, 1mm, 0.105mm))
  C10_1 = box(corner=(-14.175mm, 1.55mm, 0.17mm), size=(1.45mm, 1mm, 0.105mm))
  C10_2 = box(corner=(-14.175mm, -0.35mm, 0.17mm), size=(1.45mm, 1mm, 0.105mm))
  C41_1 = box(corner=(30.125mm, 1.55mm, 0.17mm), size=(1.45mm, 1mm, 0.105mm))
  C41_2 = box(corner=(30.125mm, -0.35mm, 0.17mm), size=(1.45mm, 1mm, 0.105mm))
  C42_1 = box(corner=(31.725mm, 1.55mm, 0.17mm), size=(1.45mm, 1mm, 0.105mm))
  C42_2 = box(corner=(31.725mm, -0.35mm, 0.17mm), size=(1.45mm, 1mm, 0.105mm))
  C44_1 = box(corner=(34.925mm, 1.55mm, 0.17mm), size=(1.45mm, 1mm, 0.105mm))
  C44_2 = box(corner=(34.925mm, -0.35mm, 0.17mm), size=(1.45mm, 1mm, 0.105mm))
  C45_1 = box(corner=(36.525mm, 1.55mm, 0.17mm), size=(1.45mm, 1mm, 0.105mm))
  C45_2 = box(corner=(36.525mm, -0.35mm, 0.17mm), size=(1.45mm, 1mm, 0.105mm))
  C8_1 = box(corner=(-17.375mm, 1.55mm, 0.17mm), size=(1.45mm, 1mm, 0.105mm))
  C8_2 = box(corner=(-17.375mm, -0.35mm, 0.17mm), size=(1.45mm, 1mm, 0.105mm))
  C37_1 = box(corner=(14.325mm, 1.55mm, 0.17mm), size=(1.45mm, 1mm, 0.105mm))
  C37_2 = box(corner=(14.325mm, -0.35mm, 0.17mm), size=(1.45mm, 1mm, 0.105mm))
  C35_1 = box(corner=(11.125mm, 1.55mm, 0.17mm), size=(1.45mm, 1mm, 0.105mm))
  C35_2 = box(corner=(11.125mm, -0.35mm, 0.17mm), size=(1.45mm, 1mm, 0.105mm))
  C5_1 = box(corner=(-31.575mm, 1.55mm, 0.17mm), size=(1.45mm, 1mm, 0.105mm))
  C5_2 = box(corner=(-31.575mm, -0.35mm, 0.17mm), size=(1.45mm, 1mm, 0.105mm))
  C40_1 = box(corner=(28.525mm, 1.55mm, 0.17mm), size=(1.45mm, 1mm, 0.105mm))
  C40_2 = box(corner=(28.525mm, -0.35mm, 0.17mm), size=(1.45mm, 1mm, 0.105mm))
  C2_1 = box(corner=(-36.375mm, 1.55mm, 0.17mm), size=(1.45mm, 1mm, 0.105mm))
  C2_2 = box(corner=(-36.375mm, -0.35mm, 0.17mm), size=(1.45mm, 1mm, 0.105mm))
  C7_1 = box(corner=(-18.975mm, 1.55mm, 0.17mm), size=(1.45mm, 1mm, 0.105mm))
  C7_2 = box(corner=(-18.975mm, -0.35mm, 0.17mm), size=(1.45mm, 1mm, 0.105mm))
  C39_1 = box(corner=(17.525mm, 1.55mm, 0.17mm), size=(1.45mm, 1mm, 0.105mm))
  C39_2 = box(corner=(17.525mm, -0.35mm, 0.17mm), size=(1.45mm, 1mm, 0.105mm))
  C11_1 = box(corner=(-12.575mm, 1.55mm, 0.17mm), size=(1.45mm, 1mm, 0.105mm))
  C11_2 = box(corner=(-12.575mm, -0.35mm, 0.17mm), size=(1.45mm, 1mm, 0.105mm))
  C38_1 = box(corner=(15.925mm, 1.55mm, 0.17mm), size=(1.45mm, 1mm, 0.105mm))
  C38_2 = box(corner=(15.925mm, -0.35mm, 0.17mm), size=(1.45mm, 1mm, 0.105mm))
  C43_1 = box(corner=(33.325mm, 1.55mm, 0.17mm), size=(1.45mm, 1mm, 0.105mm))
  C43_2 = box(corner=(33.325mm, -0.35mm, 0.17mm), size=(1.45mm, 1mm, 0.105mm))
  C1_1 = box(corner=(-37.975mm, 1.55mm, 0.17mm), size=(1.45mm, 1mm, 0.105mm))
  C1_2 = box(corner=(-37.975mm, -0.35mm, 0.17mm), size=(1.45mm, 1mm, 0.105mm))
  C6_1 = box(corner=(-29.975mm, 1.55mm, 0.17mm), size=(1.45mm, 1mm, 0.105mm))
  C6_2 = box(corner=(-29.975mm, -0.35mm, 0.17mm), size=(1.45mm, 1mm, 0.105mm))
  C65_1 = box(corner=(30.125mm, -0.25mm, -1.475mm), size=(1.45mm, 1mm, 0.105mm))
  C65_2 = box(corner=(30.125mm, 1.65mm, -1.475mm), size=(1.45mm, 1mm, 0.105mm))
  C59_1 = box(corner=(12.725mm, -0.25mm, -1.475mm), size=(1.45mm, 1mm, 0.105mm))
  C59_2 = box(corner=(12.725mm, 1.65mm, -1.475mm), size=(1.45mm, 1mm, 0.105mm))
  C62_1 = box(corner=(17.525mm, -0.25mm, -1.475mm), size=(1.45mm, 1mm, 0.105mm))
  C62_2 = box(corner=(17.525mm, 1.65mm, -1.475mm), size=(1.45mm, 1mm, 0.105mm))
  C60_1 = box(corner=(14.325mm, -0.25mm, -1.475mm), size=(1.45mm, 1mm, 0.105mm))
  C60_2 = box(corner=(14.325mm, 1.65mm, -1.475mm), size=(1.45mm, 1mm, 0.105mm))
  C63_1 = box(corner=(33.325mm, -0.25mm, -1.475mm), size=(1.45mm, 1mm, 0.105mm))
  C63_2 = box(corner=(33.325mm, 1.65mm, -1.475mm), size=(1.45mm, 1mm, 0.105mm))
  C29_1 = box(corner=(-29.975mm, -0.25mm, -1.475mm), size=(1.45mm, 1mm, 0.105mm))
  C29_2 = box(corner=(-29.975mm, 1.65mm, -1.475mm), size=(1.45mm, 1mm, 0.105mm))
  C33_1 = box(corner=(-18.975mm, -0.25mm, -1.475mm), size=(1.45mm, 1mm, 0.105mm))
  C33_2 = box(corner=(-18.975mm, 1.65mm, -1.475mm), size=(1.45mm, 1mm, 0.105mm))
  C64_1 = box(corner=(31.725mm, -0.25mm, -1.475mm), size=(1.45mm, 1mm, 0.105mm))
  C64_2 = box(corner=(31.725mm, 1.65mm, -1.475mm), size=(1.45mm, 1mm, 0.105mm))
  C27_1 = box(corner=(-33.175mm, -0.25mm, -1.475mm), size=(1.45mm, 1mm, 0.105mm))
  C27_2 = box(corner=(-33.175mm, 1.65mm, -1.475mm), size=(1.45mm, 1mm, 0.105mm))
  C30_1 = box(corner=(-14.175mm, -0.25mm, -1.475mm), size=(1.45mm, 1mm, 0.105mm))
  C30_2 = box(corner=(-14.175mm, 1.65mm, -1.475mm), size=(1.45mm, 1mm, 0.105mm))
  C28_1 = box(corner=(-31.575mm, -0.25mm, -1.475mm), size=(1.45mm, 1mm, 0.105mm))
  C28_2 = box(corner=(-31.575mm, 1.65mm, -1.475mm), size=(1.45mm, 1mm, 0.105mm))
  C61_1 = box(corner=(15.925mm, -0.25mm, -1.475mm), size=(1.45mm, 1mm, 0.105mm))
  C61_2 = box(corner=(15.925mm, 1.65mm, -1.475mm), size=(1.45mm, 1mm, 0.105mm))
  C66_1 = box(corner=(28.525mm, -0.25mm, -1.475mm), size=(1.45mm, 1mm, 0.105mm))
  C66_2 = box(corner=(28.525mm, 1.65mm, -1.475mm), size=(1.45mm, 1mm, 0.105mm))
  C26_1 = box(corner=(-34.775mm, -0.25mm, -1.475mm), size=(1.45mm, 1mm, 0.105mm))
  C26_2 = box(corner=(-34.775mm, 1.65mm, -1.475mm), size=(1.45mm, 1mm, 0.105mm))
  C31_1 = box(corner=(-15.775mm, -0.25mm, -1.475mm), size=(1.45mm, 1mm, 0.105mm))
  C31_2 = box(corner=(-15.775mm, 1.65mm, -1.475mm), size=(1.45mm, 1mm, 0.105mm))
  C32_1 = box(corner=(-17.375mm, -0.25mm, -1.475mm), size=(1.45mm, 1mm, 0.105mm))
  C32_2 = box(corner=(-17.375mm, 1.65mm, -1.475mm), size=(1.45mm, 1mm, 0.105mm))
  P27_AC1_L1.unite(P31_AC1_L3, P35_AC1_L4, V167_AC1, Q3_3, Q3_5, Q3_7, Q1_4, Q1_6)
  P27_AC1_L1.separate_bodies()
  P28_AC2_L1.unite(P32_AC2_L3, P36_AC2_L4, V169_AC2, Q4_3, Q4_5, Q4_7, Q2_4, Q2_6)
  P28_AC2_L1.separate_bodies()
  P29_AC3_L1.unite(P33_AC3_L3, P37_AC3_L4, V166_AC3, Q5_4, Q5_6, Q7_3, Q7_5, Q7_7)
  P29_AC3_L1.separate_bodies()
  P0_DCN_L1.unite(P1_DCN_L1, P2_DCN_L1, P3_DCN_L1, P4_DCN_L1, P5_DCN_L1, P6_DCN_L1, P7_DCN_L1, P8_DCN_L1, P9_DCN_L2, P10_DCN_L4, P11_DCN_L4, P12_DCN_L4, P13_DCN_L4, P14_DCN_L4, P15_DCN_L4, P16_DCN_L4, P17_DCN_L4, V32_DCN, V33_DCN, V34_DCN, V35_DCN, V36_DCN, V37_DCN, V38_DCN, V39_DCN, V40_DCN, V41_DCN, V42_DCN, V43_DCN, V44_DCN, V45_DCN, V46_DCN, V47_DCN, V48_DCN, V49_DCN, V50_DCN, V51_DCN, V52_DCN, V53_DCN, V54_DCN, V55_DCN, V56_DCN, V57_DCN, V58_DCN, V59_DCN, V60_DCN, V61_DCN, V62_DCN, V63_DCN, V64_DCN, V65_DCN, V66_DCN, V67_DCN, V68_DCN, V69_DCN, V70_DCN, V71_DCN, V72_DCN, V73_DCN, V74_DCN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)
  P0_DCN_L1.separate_bodies()
  P30_AC4_L1.unite(P34_AC4_L3, P38_AC4_L4, V168_AC4, Q6_4, Q6_6, Q8_3, Q8_5, Q8_7)
  P30_AC4_L1.separate_bodies()
  P18_DCP_L1.unite(P19_DCP_L1, P20_DCP_L1, P21_DCP_L1, P22_DCP_L3, P23_DCP_L4, P24_DCP_L4, P25_DCP_L4, P26_DCP_L4, V0_DCP, V1_DCP, V2_DCP, V3_DCP, V4_DCP, V5_DCP, V6_DCP, V7_DCP, V8_DCP, V9_DCP, V10_DCP, V11_DCP, V12_DCP, V13_DCP, V14_DCP, V15_DCP, V16_DCP, V17_DCP, V18_DCP, V19_DCP, V20_DCP, V21_DCP, V22_DCP, V23_DCP, V24_DCP, V25_DCP, V26_DCP, V27_DCP, V28_DCP, V29_DCP, V30_DCP, V31_DCP, Q6_3, Q6_5, Q6_7, Q5_3, Q5_5, Q5_7, Q2_3, Q2_5, Q2_7, Q1_3, Q1_5, Q1_7, C12_1, C4_1, C3_1, C34_1, C9_1, C36_1, C10_1, C41_1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)
  P18_DCP_L1.separate_bodies()
boundaries and excitations:
  AC1: SignalNet Objects=P27_AC1_L1
  AC2: SignalNet Objects=P28_AC2_L1
  AC3: SignalNet Objects=P29_AC3_L1
  DCN: SignalNet Objects=P0_DCN_L1
  AC4: SignalNet Objects=P30_AC4_L1
  DCP: SignalNet Objects=P18_DCP_L1
  CapN_2: Source Faces=P0_DCN_L1.face(at (-10.25, 0.15, 0.275), at (-15.05, 0.15, 0.275), at (-13.45, 0.15, 0.275), at (-16.65, 0.15, 0.275), at (-18.25, 0.15, 0.275), at (-11.85, 0.15, 0.275)) TerminalType=ConstantVoltage Net=DCN
  CapN_3: Source Faces=P0_DCN_L1.face(at (10.25, 0.15, 0.275), at (13.45, 0.15, 0.275), at (15.05, 0.15, 0.275), at (11.85, 0.15, 0.275), at (18.25, 0.15, 0.275), at (16.65, 0.15, 0.275)) TerminalType=ConstantVoltage Net=DCN
  CapN_4: Source Faces=P0_DCN_L1.face(at (30.85, 0.15, 0.275), at (32.45, 0.15, 0.275), at (35.65, 0.15, 0.275), at (37.25, 0.15, 0.275), at (29.25, 0.15, 0.275), at (34.05, 0.15, 0.275)) TerminalType=ConstantVoltage Net=DCN
  CapNb_1: Source Faces=P0_DCN_L1.face(at (-29.25, 0.25, -1.475), at (-32.45, 0.25, -1.475), at (-30.85, 0.25, -1.475), at (-34.05, 0.25, -1.475)) TerminalType=ConstantVoltage Net=DCN
  CapNb_2: Source Faces=P0_DCN_L1.face(at (-18.25, 0.25, -1.475), at (-13.45, 0.25, -1.475), at (-15.05, 0.25, -1.475), at (-16.65, 0.25, -1.475)) TerminalType=ConstantVoltage Net=DCN
  CapNb_3: Source Faces=P0_DCN_L1.face(at (13.45, 0.25, -1.475), at (18.25, 0.25, -1.475), at (15.05, 0.25, -1.475), at (16.65, 0.25, -1.475)) TerminalType=ConstantVoltage Net=DCN
  CapNb_4: Source Faces=P0_DCN_L1.face(at (30.85, 0.25, -1.475), at (34.05, 0.25, -1.475), at (32.45, 0.25, -1.475), at (29.25, 0.25, -1.475)) TerminalType=ConstantVoltage Net=DCN
  CapP_2: Source Faces=P18_DCP_L1.face(at (-10.25, 2.05, 0.275), at (-15.05, 2.05, 0.275), at (-13.45, 2.05, 0.275), at (-16.65, 2.05, 0.275), at (-18.25, 2.05, 0.275), at (-11.85, 2.05, 0.275)) TerminalType=ConstantVoltage Net=DCP
  CapP_3: Source Faces=P18_DCP_L1.face(at (10.25, 2.05, 0.275), at (13.45, 2.05, 0.275), at (15.05, 2.05, 0.275), at (11.85, 2.05, 0.275), at (18.25, 2.05, 0.275), at (16.65, 2.05, 0.275)) TerminalType=ConstantVoltage Net=DCP
  CapP_4: Source Faces=P18_DCP_L1.face(at (30.85, 2.05, 0.275), at (32.45, 2.05, 0.275), at (35.65, 2.05, 0.275), at (37.25, 2.05, 0.275), at (29.25, 2.05, 0.275), at (34.05, 2.05, 0.275)) TerminalType=ConstantVoltage Net=DCP
  CapPb_1: Source Faces=P18_DCP_L1.face(at (-29.25, 2.15, -1.475), at (-32.45, 2.15, -1.475), at (-30.85, 2.15, -1.475), at (-34.05, 2.15, -1.475)) TerminalType=ConstantVoltage Net=DCP
  CapPb_2: Source Faces=P18_DCP_L1.face(at (-18.25, 2.15, -1.475), at (-13.45, 2.15, -1.475), at (-15.05, 2.15, -1.475), at (-16.65, 2.15, -1.475)) TerminalType=ConstantVoltage Net=DCP
  CapPb_3: Source Faces=P18_DCP_L1.face(at (13.45, 2.15, -1.475), at (18.25, 2.15, -1.475), at (15.05, 2.15, -1.475), at (16.65, 2.15, -1.475)) TerminalType=ConstantVoltage Net=DCP
  CapPb_4: Source Faces=P18_DCP_L1.face(at (30.85, 2.15, -1.475), at (34.05, 2.15, -1.475), at (32.45, 2.15, -1.475), at (29.25, 2.15, -1.475)) TerminalType=ConstantVoltage Net=DCP
  QH_D_1: Source Faces=P18_DCP_L1.face(at (-31.975, 4.9, 0.275), at (-33.675, 4.9, 0.275), at (-35.602, 4.9, 0.275)) TerminalType=ConstantVoltage Net=DCP
  QH_D_2: Source Faces=P18_DCP_L1.face(at (-15.525, 4.9, 0.275), at (-13.825, 4.9, 0.275), at (-11.898, 4.9, 0.275)) TerminalType=ConstantVoltage Net=DCP
  QH_D_3: Source Faces=P18_DCP_L1.face(at (15.525, 4.9, 0.275), at (13.825, 4.9, 0.275), at (11.898, 4.9, 0.275)) TerminalType=ConstantVoltage Net=DCP
  QH_D_4: Source Faces=P18_DCP_L1.face(at (31.975, 4.9, 0.275), at (33.675, 4.9, 0.275), at (35.602, 4.9, 0.275)) TerminalType=ConstantVoltage Net=DCP
  QL_D_1: Source Faces=P27_AC1_L1.face(at (-31.975, 9.2, 0.275), at (-33.675, 9.2, 0.275), at (-35.602, 9.2, 0.275)) TerminalType=ConstantVoltage Net=AC1
  QL_D_2: Source Faces=P28_AC2_L1.face(at (-15.525, 9.2, 0.275), at (-13.825, 9.2, 0.275), at (-11.898, 9.2, 0.275)) TerminalType=ConstantVoltage Net=AC2
  QL_D_3: Source Faces=P29_AC3_L1.face(at (15.525, 9.2, 0.275), at (13.825, 9.2, 0.275), at (11.898, 9.2, 0.275)) TerminalType=ConstantVoltage Net=AC3
  QL_D_4: Source Faces=P30_AC4_L1.face(at (31.975, 9.2, 0.275), at (33.675, 9.2, 0.275), at (35.602, 9.2, 0.275)) TerminalType=ConstantVoltage Net=AC4
  QL_S_1: Source Faces=P0_DCN_L1.face(at (-32.825, 9.2, 0.275), at (-34.525, 9.2, 0.275)) TerminalType=ConstantVoltage Net=DCN
  QL_S_2: Source Faces=P0_DCN_L1.face(at (-14.675, 9.2, 0.275), at (-12.975, 9.2, 0.275)) TerminalType=ConstantVoltage Net=DCN
  QL_S_3: Source Faces=P0_DCN_L1.face(at (14.675, 9.2, 0.275), at (12.975, 9.2, 0.275)) TerminalType=ConstantVoltage Net=DCN
  QL_S_4: Source Faces=P0_DCN_L1.face(at (32.825, 9.2, 0.275), at (34.525, 9.2, 0.275)) TerminalType=ConstantVoltage Net=DCN
  CapN_1: Sink Faces=P0_DCN_L1.face(at (-32.45, 0.15, 0.275), at (-34.05, 0.15, 0.275), at (-30.85, 0.15, 0.275), at (-35.65, 0.15, 0.275), at (-37.25, 0.15, 0.275), at (-29.25, 0.15, 0.275)) TerminalType=ConstantVoltage Net=DCN
  CapP_1: Sink Faces=P18_DCP_L1.face(at (-32.45, 2.05, 0.275), at (-34.05, 2.05, 0.275), at (-30.85, 2.05, 0.275), at (-35.65, 2.05, 0.275), at (-37.25, 2.05, 0.275), at (-29.25, 2.05, 0.275)) TerminalType=ConstantVoltage Net=DCP
  QH_S_1: Sink Faces=P27_AC1_L1.face(at (-32.825, 4.9, 0.275), at (-34.525, 4.9, 0.275)) TerminalType=ConstantVoltage Net=AC1
  QH_S_2: Sink Faces=P28_AC2_L1.face(at (-14.675, 4.9, 0.275), at (-12.975, 4.9, 0.275)) TerminalType=ConstantVoltage Net=AC2
  QH_S_3: Sink Faces=P29_AC3_L1.face(at (14.675, 4.9, 0.275), at (12.975, 4.9, 0.275)) TerminalType=ConstantVoltage Net=AC3
  QH_S_4: Sink Faces=P30_AC4_L1.face(at (32.825, 4.9, 0.275), at (34.525, 4.9, 0.275)) TerminalType=ConstantVoltage Net=AC4
setups:
  Setup1: Matrix AdaptiveFreq=100MHz Cap{MaxPass=1 MinPass=1 MinConvPass=1 PerError=30 PerRefine=30 AutoIncreaseAccuracy AccuracyLevel=High Solver_Type=Iterative} DC{SolveResOnly Cond{MaxPass=3 MinPass=1 MinConvPass=1 PerError=5 PerRefine=30} Mult{MaxPass=1 MinPass=1 MinConvPass=1 PerError=1 PerRefine=30} AccuracyLevel=Normal} AC{MaxPass=8 MinPass=2 MinConvPass=1 PerError=2 PerRefine=30 ACRLSolverType=ACA} ErrorValue=0.1
source amplitudes:
  AC1:QL_D_1, AC2:QL_D_2, AC3:QL_D_3, AC4:QL_D_4, DCN:CapN_3, DCN:CapN_4, DCN:CapNb_1..DCN:CapNb_4, DCN:QL_S_1..DCN:QL_S_4, DCP:CapP_2, DCP:CapP_3, DCP:CapP_4, DCP:CapPb_1..DCP:CapPb_4, DCP:QH_D_1..DCP:QH_D_4: AC R/L Fields 0A
  DCN:CapN_2: AC R/L Fields 1A
  AC1: CG Fields 1V 0deg
  AC2, AC3, AC4, DCN, DCP: CG Fields 0V 0deg
  AC1:QL_D_1, AC2:QL_D_2, AC3:QL_D_3, AC4:QL_D_4, DCN:CapN_3, DCN:CapN_4, DCN:CapNb_1..DCN:CapNb_4, DCN:QL_S_1..DCN:QL_S_4, DCP:CapP_2, DCP:CapP_3, DCP:CapP_4, DCP:CapPb_1..DCP:CapPb_4, DCP:QH_D_1..DCP:QH_D_4: DC R/L Fields 0A
  DCN:CapN_2: DC R/L Fields 1A
