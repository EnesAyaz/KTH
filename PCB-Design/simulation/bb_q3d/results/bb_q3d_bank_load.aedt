# Ansys Electronics Desktop project, version 2024.2
materials:
  vacuum: permittivity=1
  copper: permeability=0.999991 conductivity=58000000

design BB_PL_BANK_load (Q3D Extractor, model units mm)
options: SParamCalcMethod=EqTransLine Calculate_Lossy_Dielectrics
geometry:
  P0_DCN_L1 [copper] = polyline(z=0.17mm, xy in mm: (39.7092, -4.1811) (39.75, 0.801) (39.651, 0.9) (-39.651, 0.9) (-39.75, 0.801) (-39.75, -4.101) (-39.651, -4.2) (39.651, -4.2) (39.7092, -4.1811), closed, covered)
  P0_DCN_L1.sweep_along_vector((0mm, 0mm, 0.07mm))
  P1_DCN_L1 = polyline(z=0.17mm, xy in mm: (41.3621, -12.2) (41.0621, -11.9) (42.5621, -10.4) (42.35, -10.1879) (40.85, -11.6879) (40.3, -11.1379) (40.3, -11.05) (40.15, -10.9879) (40.0879, -11.05) (39.75, -11.05) (39.75, -8.299) (39.651, -8.2) (-39.651, -8.2) (-39.75, -8.299) (-39.75, -11.301) (-39.651, -11.4) (40.0879, -11.35) (41.15, -12.4121) (41.3621, -12.2), closed, covered)
  P1_DCN_L1.sweep_along_vector((0mm, 0mm, 0.07mm))
  P2_DCN_L2 = polyline(z=0mm, xy in mm: (-9.9519, -23.3811) (-9.9159, -23.2704) (-10.4268, -22.7521) (-10.6603, -22.2672) (-10.7405, -21.735) (-10.6603, -21.2028) (-10.4268, -20.7179) (-10.0607, -20.3234) (-9.5946, -20.0543) (-9.0699, -19.9345) (-8.5332, -19.9747) (-8.0322, -20.1713) (-7.5161, -20.6264) (-7.2097, -21.2028) (-7.1295, -21.735) (-7.2097, -22.2672) (-7.4432, -22.7521) (-7.9531, -23.2676) (-7.8629, -23.4) (-4.0819, -23.3811) (-4.0459, -23.2704) (-4.5568, -22.7521) (-4.7903, -22.2672) (-4.8705, -21.735) (-4.7903, -21.2028) (-4.5568, -20.7179) (-4.1907, -20.3234) (-3.7246, -20.0543) (-3.1999, -19.9345) (-2.6632, -19.9747) (-2.1622, -20.1713) (-1.6461, -20.6264) (-1.3397, -21.2028) (-1.2595, -21.735) (-1.3397, -22.2672) (-1.5732, -22.7521) (-2.0831, -23.2676) (-1.9929, -23.4) (35.7092, -23.3811) (35.75, -13.2495) (35.6816, -13.1553) (35.265, -13.0321) (35.0273, -12.6488) (35.265, -12.2679) (35.7452, -12.0811) (35.75, -11.3) (39.651, -11.3) (39.75, -11.201) (39.75, -5.8373) (39.6204, -5.7431) (39.3601, -5.96) (39.078, -6.0005) (38.8189, -5.8821) (38.5812, -5.4988) (38.8189, -5.1179) (39.078, -4.9995) (39.3601, -5.04) (39.6286, -5.2592) (39.75, -5.1627) (39.75, 4.3) (27.05, 4.3) (27.05, 3.3) (20.45, 3.3) (20.45, 4.3) (6.3255, 4.3) (6.3255, 2.7456) (6.5056, 2.32) (6.4254, 2.0466) (6.072, 1.8195) (5.7899, 1.86) (5.5148, 2.1775) (5.5148, 2.4625) (5.6741, 2.7371) (5.6745, 4.3) (-20.45, 4.3) (-20.45, 3.3) (-27.05, 3.3) (-27.05, 4.3) (-39.75, 4.3) (-39.75, -5.1627) (-39.6204, -5.2569) (-39.3601, -5.04) (-39.078, -4.9995) (-38.8189, -5.1179) (-38.5812, -5.5012) (-38.8189, -5.8821) (-39.078, -6.0005) (-39.3601, -5.96) (-39.6286, -5.7408) (-39.75, -5.8373) (-39.75, -11.201) (-39.651, -11.3) (-35.75, -11.3) (-35.7311, -12.1087) (-35.265, -12.2679) (-35.0273, -12.6512) (-35.265, -13.0321) (-35.7092, -13.1694) (-35.75, -13.2495) (-35.7311, -23.3592) (-10.0101, -23.4) (-9.9519, -23.3811), closed, covered)
  P2_DCN_L2_h0 = polyline(z=0mm, xy in mm: (-18.4831, 3.2603) (-18.6985, 3.4168) (-18.7597, 3.8031) (-18.6032, 4.0185) (-18.2169, 4.0797) (-18.0015, 3.9232) (-17.9192, 3.67) (-18.0015, 3.4168) (-18.35, 3.2392) (-18.4831, 3.2603), closed, covered)
  P2_DCN_L2_h1 = polyline(z=0mm, xy in mm: (29.0169, 3.2603) (28.8015, 3.4168) (28.7403, 3.8031) (28.8968, 4.0185) (29.2831, 4.0797) (29.4985, 3.9232) (29.5808, 3.67) (29.4985, 3.4168) (29.15, 3.2392) (29.0169, 3.2603), closed, covered)
  P2_DCN_L2_h2 = polyline(z=0mm, xy in mm: (-35.7101, 2.04) (-35.9852, 2.3575) (-35.9852, 2.6425) (-35.8311, 2.8821) (-35.572, 3.0005) (-35.2899, 2.96) (-35.0724, 2.7997) (-34.672, 3.0005) (-34.3899, 2.96) (-34.1724, 2.7997) (-33.772, 3.0005) (-33.4899, 2.96) (-33.2724, 2.7997) (-32.872, 3.0005) (-32.5899, 2.96) (-32.3724, 2.7997) (-31.972, 3.0005) (-31.6899, 2.96) (-31.4724, 2.7997) (-31.072, 3.0005) (-30.7899, 2.96) (-30.5724, 2.7997) (-30.172, 3.0005) (-29.8899, 2.96) (-29.6724, 2.7997) (-29.4101, 2.96) (-29.128, 3.0005) (-28.7746, 2.7734) (-28.6944, 2.5) (-28.7746, 2.2266) (-29.128, 1.9995) (-29.4101, 2.04) (-29.6276, 2.2003) (-30.028, 1.9995) (-30.3101, 2.04) (-30.5276, 2.2003) (-30.928, 1.9995) (-31.2101, 2.04) (-31.4276, 2.2003) (-31.828, 1.9995) (-32.1101, 2.04) (-32.3276, 2.2003) (-32.728, 1.9995) (-33.0101, 2.04) (-33.2276, 2.2003) (-33.628, 1.9995) (-33.9101, 2.04) (-34.1276, 2.2003) (-34.528, 1.9995) (-34.8101, 2.04) (-35.0276, 2.2003) (-35.2899, 2.04) (-35.572, 1.9995) (-35.7101, 2.04), closed, covered)
  P2_DCN_L2_h3 = polyline(z=0mm, xy in mm: (-18.5101, 2.04) (-18.7852, 2.3575) (-18.7852, 2.6425) (-18.6311, 2.8821) (-18.372, 3.0005) (-18.0899, 2.96) (-17.8724, 2.7997) (-17.472, 3.0005) (-17.1899, 2.96) (-16.9724, 2.7997) (-16.572, 3.0005) (-16.2899, 2.96) (-16.0724, 2.7997) (-15.672, 3.0005) (-15.3899, 2.96) (-15.1724, 2.7997) (-14.772, 3.0005) (-14.4899, 2.96) (-14.2724, 2.7997) (-13.872, 3.0005) (-13.5899, 2.96) (-13.3724, 2.7997) (-12.972, 3.0005) (-12.6899, 2.96) (-12.4724, 2.7997) (-12.2101, 2.96) (-11.928, 3.0005) (-11.5746, 2.7734) (-11.4944, 2.5) (-11.5746, 2.2266) (-11.928, 1.9995) (-12.2101, 2.04) (-12.4276, 2.2003) (-12.828, 1.9995) (-13.1101, 2.04) (-13.3276, 2.2003) (-13.728, 1.9995) (-14.0101, 2.04) (-14.2276, 2.2003) (-14.628, 1.9995) (-14.9101, 2.04) (-15.1276, 2.2003) (-15.528, 1.9995) (-15.8101, 2.04) (-16.0276, 2.2003) (-16.428, 1.9995) (-16.7101, 2.04) (-16.9276, 2.2003) (-17.328, 1.9995) (-17.6101, 2.04) (-17.8276, 2.2003) (-18.0899, 2.04) (-18.372, 1.9995) (-18.5101, 2.04), closed, covered)
  P2_DCN_L2_h4 = polyline(z=0mm, xy in mm: (11.7899, 2.04) (11.5148, 2.3575) (11.5148, 2.6425) (11.6689, 2.8821) (11.928, 3.0005) (12.2101, 2.96) (12.4276, 2.7997) (12.828, 3.0005) (13.1101, 2.96) (13.3276, 2.7997) (13.728, 3.0005) (14.0101, 2.96) (14.2276, 2.7997) (14.628, 3.0005) (14.9101, 2.96) (15.1276, 2.7997) (15.528, 3.0005) (15.8101, 2.96) (16.0276, 2.7997) (16.428, 3.0005) (16.7101, 2.96) (16.9276, 2.7997) (17.328, 3.0005) (17.6101, 2.96) (17.8276, 2.7997) (18.0899, 2.96) (18.372, 3.0005) (18.7254, 2.7734) (18.8056, 2.5) (18.7254, 2.2266) (18.372, 1.9995) (18.0899, 2.04) (17.8724, 2.2003) (17.472, 1.9995) (17.1899, 2.04) (16.9724, 2.2003) (16.572, 1.9995) (16.2899, 2.04) (16.0724, 2.2003) (15.672, 1.9995) (15.3899, 2.04) (15.1724, 2.2003) (14.772, 1.9995) (14.4899, 2.04) (14.2724, 2.2003) (13.872, 1.9995) (13.5899, 2.04) (13.3724, 2.2003) (12.972, 1.9995) (12.6899, 2.04) (12.4724, 2.2003) (12.2101, 2.04) (11.928, 1.9995) (11.7899, 2.04), closed, covered)
  P2_DCN_L2_h5 = polyline(z=0mm, xy in mm: (28.9899, 2.04) (28.7148, 2.3575) (28.7148, 2.6425) (28.8689, 2.8821) (29.128, 3.0005) (29.4101, 2.96) (29.6276, 2.7997) (30.028, 3.0005) (30.3101, 2.96) (30.5276, 2.7997) (30.928, 3.0005) (31.2101, 2.96) (31.4276, 2.7997) (31.828, 3.0005) (32.1101, 2.96) (32.3276, 2.7997) (32.728, 3.0005) (33.0101, 2.96) (33.2276, 2.7997) (33.628, 3.0005) (33.9101, 2.96) (34.1276, 2.7997) (34.528, 3.0005) (34.8101, 2.96) (35.0276, 2.7997) (35.2899, 2.96) (35.572, 3.0005) (35.9254, 2.7734) (36.0056, 2.5) (35.9254, 2.2266) (35.572, 1.9995) (35.2899, 2.04) (35.0724, 2.2003) (34.672, 1.9995) (34.3899, 2.04) (34.1724, 2.2003) (33.772, 1.9995) (33.4899, 2.04) (33.2724, 2.2003) (32.872, 1.9995) (32.5899, 2.04) (32.3724, 2.2003) (31.972, 1.9995) (31.6899, 2.04) (31.4724, 2.2003) (31.072, 1.9995) (30.7899, 2.04) (30.5724, 2.2003) (30.172, 1.9995) (29.8899, 2.04) (29.6724, 2.2003) (29.4101, 2.04) (29.128, 1.9995) (28.9899, 2.04), closed, covered)
  P2_DCN_L2_h6 = polyline(z=0mm, xy in mm: (-38.1754, -5.96) (-38.3908, -5.7734) (-38.5342, -5.4988) (-38.3908, -5.2266) (-38.1754, -5.04) (-37.7553, -5.04) (-37.54, -5.2266) (-37.3966, -5.5012) (-37.6343, -5.8821) (-38.0373, -6.0005) (-38.1754, -5.96), closed, covered)
  P2_DCN_L2_h7 = polyline(z=0mm, xy in mm: (-36.9908, -5.96) (-37.2061, -5.7734) (-37.3496, -5.4988) (-37.2061, -5.2266) (-36.9908, -5.04) (-36.5707, -5.04) (-36.3554, -5.2266) (-36.212, -5.5012) (-36.4496, -5.8821) (-36.8527, -6.0005) (-36.9908, -5.96), closed, covered)
  P2_DCN_L2_h8 = polyline(z=0mm, xy in mm: (-35.8062, -5.96) (-36.0215, -5.7734) (-36.165, -5.4988) (-36.0215, -5.2266) (-35.8062, -5.04) (-35.3861, -5.04) (-35.1708, -5.2266) (-35.0273, -5.5012) (-35.265, -5.8821) (-35.6681, -6.0005) (-35.8062, -5.96), closed, covered)
  P2_DCN_L2_h9 = polyline(z=0mm, xy in mm: (-34.6216, -5.96) (-34.8369, -5.7734) (-34.9804, -5.4988) (-34.8369, -5.2266) (-34.6216, -5.04) (-34.2015, -5.04) (-33.9862, -5.2266) (-33.8427, -5.5012) (-34.0804, -5.8821) (-34.4835, -6.0005) (-34.6216, -5.96), closed, covered)
  P2_DCN_L2_h10 = polyline(z=0mm, xy in mm: (-33.437, -5.96) (-33.6523, -5.7734) (-33.7957, -5.4988) (-33.6523, -5.2266) (-33.437, -5.04) (-33.0169, -5.04) (-32.8015, -5.2266) (-32.6581, -5.5012) (-32.8958, -5.8821) (-33.2989, -6.0005) (-33.437, -5.96), closed, covered)
  P2_DCN_L2_h11 = polyline(z=0mm, xy in mm: (-32.2524, -5.96) (-32.4677, -5.7734) (-32.6111, -5.4988) (-32.4677, -5.2266) (-32.2524, -5.04) (-31.8323, -5.04) (-31.6169, -5.2266) (-31.4735, -5.5012) (-31.7112, -5.8821) (-32.1143, -6.0005) (-32.2524, -5.96), closed, covered)
  P2_DCN_L2_h12 = polyline(z=0mm, xy in mm: (-31.0677, -5.96) (-31.2831, -5.7734) (-31.4265, -5.4988) (-31.2831, -5.2266) (-31.0678, -5.04) (-30.6476, -5.04) (-30.4323, -5.2266) (-30.2889, -5.5012) (-30.5266, -5.8821) (-30.9297, -6.0005) (-31.0677, -5.96), closed, covered)
  P2_DCN_L2_h13 = polyline(z=0mm, xy in mm: (-29.8831, -5.96) (-30.0985, -5.7734) (-30.2419, -5.4988) (-30.0985, -5.2266) (-29.8831, -5.04) (-29.463, -5.04) (-29.2477, -5.2266) (-29.1043, -5.5012) (-29.3419, -5.8821) (-29.745, -6.0005) (-29.8831, -5.96), closed, covered)
  P2_DCN_L2_h14 = polyline(z=0mm, xy in mm: (-28.6985, -5.96) (-28.9138, -5.7734) (-29.0573, -5.4988) (-28.9138, -5.2266) (-28.6985, -5.04) (-28.2784, -5.04) (-28.0631, -5.2266) (-27.9196, -5.5012) (-28.1573, -5.8821) (-28.5604, -6.0005) (-28.6985, -5.96), closed, covered)
  P2_DCN_L2_h15 = polyline(z=0mm, xy in mm: (-27.5139, -5.96) (-27.7292, -5.7734) (-27.8727, -5.4988) (-27.7292, -5.2266) (-27.5139, -5.04) (-27.0938, -5.04) (-26.8785, -5.2266) (-26.735, -5.5012) (-26.9727, -5.8821) (-27.3758, -6.0005) (-27.5139, -5.96), closed, covered)
  P2_DCN_L2_h16 = polyline(z=0mm, xy in mm: (-26.3293, -5.96) (-26.5446, -5.7734) (-26.688, -5.4988) (-26.5446, -5.2266) (-26.3293, -5.04) (-25.9092, -5.04) (-25.6939, -5.2266) (-25.5504, -5.5012) (-25.7881, -5.8821) (-26.1912, -6.0005) (-26.3293, -5.96), closed, covered)
  P2_DCN_L2_h17 = polyline(z=0mm, xy in mm: (-25.1447, -5.96) (-25.36, -5.7734) (-25.5034, -5.4988) (-25.36, -5.2266) (-25.1447, -5.04) (-24.7246, -5.04) (-24.5092, -5.2266) (-24.3658, -5.5012) (-24.6035, -5.8821) (-25.0066, -6.0005) (-25.1447, -5.96), closed, covered)
  P2_DCN_L2_h18 = polyline(z=0mm, xy in mm: (-23.9601, -5.96) (-24.1754, -5.7734) (-24.3188, -5.4988) (-24.1754, -5.2266) (-23.9601, -5.04) (-23.5399, -5.04) (-23.3246, -5.2266) (-23.1812, -5.5012) (-23.4189, -5.8821) (-23.822, -6.0005) (-23.9601, -5.96), closed, covered)
  P2_DCN_L2_h19 = polyline(z=0mm, xy in mm: (-22.7754, -5.96) (-22.9908, -5.7734) (-23.1342, -5.4988) (-22.9908, -5.2266) (-22.7754, -5.04) (-22.3553, -5.04) (-22.14, -5.2266) (-21.9966, -5.5012) (-22.2343, -5.8821) (-22.6373, -6.0005) (-22.7754, -5.96), closed, covered)
  P2_DCN_L2_h20 = polyline(z=0mm, xy in mm: (-21.5908, -5.96) (-21.8061, -5.7734) (-21.9496, -5.4988) (-21.8061, -5.2266) (-21.5908, -5.04) (-21.1707, -5.04) (-20.9554, -5.2266) (-20.812, -5.5012) (-21.0496, -5.8821) (-21.4527, -6.0005) (-21.5908, -5.96), closed, covered)
  P2_DCN_L2_h21 = polyline(z=0mm, xy in mm: (-20.4062, -5.96) (-20.6215, -5.7734) (-20.765, -5.4988) (-20.6215, -5.2266) (-20.4062, -5.04) (-19.9861, -5.04) (-19.7708, -5.2266) (-19.6273, -5.5012) (-19.865, -5.8821) (-20.2681, -6.0005) (-20.4062, -5.96), closed, covered)
  P2_DCN_L2_h22 = polyline(z=0mm, xy in mm: (-19.2216, -5.96) (-19.4369, -5.7734) (-19.5804, -5.4988) (-19.4369, -5.2266) (-19.2216, -5.04) (-18.8015, -5.04) (-18.5862, -5.2266) (-18.4427, -5.5012) (-18.6804, -5.8821) (-19.0835, -6.0005) (-19.2216, -5.96), closed, covered)
  P2_DCN_L2_h23 = polyline(z=0mm, xy in mm: (-18.037, -5.96) (-18.2523, -5.7734) (-18.3957, -5.4988) (-18.2523, -5.2266) (-18.037, -5.04) (-17.6169, -5.04) (-17.4015, -5.2266) (-17.2581, -5.5012) (-17.4958, -5.8821) (-17.8989, -6.0005) (-18.037, -5.96), closed, covered)
  P2_DCN_L2_h24 = polyline(z=0mm, xy in mm: (-16.8524, -5.96) (-17.0677, -5.7734) (-17.2111, -5.4988) (-17.0677, -5.2266) (-16.8524, -5.04) (-16.4323, -5.04) (-16.2169, -5.2266) (-16.0735, -5.5012) (-16.3112, -5.8821) (-16.7143, -6.0005) (-16.8524, -5.96), closed, covered)
  P2_DCN_L2_h25 = polyline(z=0mm, xy in mm: (-15.6677, -5.96) (-15.8831, -5.7734) (-16.0265, -5.4988) (-15.8831, -5.2266) (-15.6678, -5.04) (-15.2476, -5.04) (-15.0323, -5.2266) (-14.8889, -5.5012) (-15.1266, -5.8821) (-15.5297, -6.0005) (-15.6677, -5.96), closed, covered)
  P2_DCN_L2_h26 = polyline(z=0mm, xy in mm: (-14.4831, -5.96) (-14.6985, -5.7734) (-14.8419, -5.4988) (-14.6985, -5.2266) (-14.4831, -5.04) (-14.063, -5.04) (-13.8477, -5.2266) (-13.7043, -5.5012) (-13.9419, -5.8821) (-14.345, -6.0005) (-14.4831, -5.96), closed, covered)
  P2_DCN_L2_h27 = polyline(z=0mm, xy in mm: (-13.2985, -5.96) (-13.5138, -5.7734) (-13.6573, -5.4988) (-13.5138, -5.2266) (-13.2985, -5.04) (-12.8784, -5.04) (-12.6631, -5.2266) (-12.5196, -5.5012) (-12.7573, -5.8821) (-13.1604, -6.0005) (-13.2985, -5.96), closed, covered)
  P2_DCN_L2_h28 = polyline(z=0mm, xy in mm: (-12.1139, -5.96) (-12.3292, -5.7734) (-12.4727, -5.4988) (-12.3292, -5.2266) (-12.1139, -5.04) (-11.6938, -5.04) (-11.4785, -5.2266) (-11.335, -5.5012) (-11.5727, -5.8821) (-11.9758, -6.0005) (-12.1139, -5.96), closed, covered)
  P2_DCN_L2_h29 = polyline(z=0mm, xy in mm: (-10.9293, -5.96) (-11.1446, -5.7734) (-11.288, -5.4988) (-11.1446, -5.2266) (-10.9293, -5.04) (-10.5092, -5.04) (-10.2939, -5.2266) (-10.1504, -5.5012) (-10.3881, -5.8821) (-10.7912, -6.0005) (-10.9293, -5.96), closed, covered)
  P2_DCN_L2_h30 = polyline(z=0mm, xy in mm: (-9.7447, -5.96) (-9.96, -5.7734) (-10.1034, -5.4988) (-9.96, -5.2266) (-9.7447, -5.04) (-9.3246, -5.04) (-9.1092, -5.2266) (-8.9658, -5.5012) (-9.2035, -5.8821) (-9.6066, -6.0005) (-9.7447, -5.96), closed, covered)
  P2_DCN_L2_h31 = polyline(z=0mm, xy in mm: (-8.56, -5.96) (-8.7754, -5.7734) (-8.9188, -5.4988) (-8.7754, -5.2266) (-8.5601, -5.04) (-8.1399, -5.04) (-7.8648, -5.3575) (-7.8648, -5.6425) (-8.1399, -5.96) (-8.422, -6.0005) (-8.56, -5.96), closed, covered)
  P2_DCN_L2_h32 = polyline(z=0mm, xy in mm: (-7.3601, -5.96) (-7.6352, -5.6425) (-7.6352, -5.3575) (-7.3601, -5.04) (-6.9399, -5.04) (-6.6648, -5.3575) (-6.6648, -5.6425) (-6.9399, -5.96) (-7.222, -6.0005) (-7.3601, -5.96), closed, covered)
  P2_DCN_L2_h33 = polyline(z=0mm, xy in mm: (-6.1601, -5.96) (-6.4352, -5.6425) (-6.4352, -5.3575) (-6.1601, -5.04) (-5.7399, -5.04) (-5.4648, -5.3575) (-5.4648, -5.6425) (-5.7399, -5.96) (-6.022, -6.0005) (-6.1601, -5.96), closed, covered)
  P2_DCN_L2_h34 = polyline(z=0mm, xy in mm: (-4.9601, -5.96) (-5.2352, -5.6425) (-5.2352, -5.3575) (-4.9601, -5.04) (-4.5399, -5.04) (-4.2648, -5.3575) (-4.2648, -5.6425) (-4.5399, -5.96) (-4.822, -6.0005) (-4.9601, -5.96), closed, covered)
  P2_DCN_L2_h35 = polyline(z=0mm, xy in mm: (-3.7601, -5.96) (-4.0352, -5.6425) (-4.0352, -5.3575) (-3.7601, -5.04) (-3.3399, -5.04) (-3.0648, -5.3575) (-3.0648, -5.6425) (-3.3399, -5.96) (-3.622, -6.0005) (-3.7601, -5.96), closed, covered)
  P2_DCN_L2_h36 = polyline(z=0mm, xy in mm: (-2.56, -5.96) (-2.8352, -5.6425) (-2.8352, -5.3575) (-2.5601, -5.04) (-2.1399, -5.04) (-1.8648, -5.3575) (-1.8648, -5.6425) (-2.1399, -5.96) (-2.422, -6.0005) (-2.56, -5.96), closed, covered)
  P2_DCN_L2_h37 = polyline(z=0mm, xy in mm: (-1.3601, -5.96) (-1.6352, -5.6425) (-1.6352, -5.3575) (-1.3601, -5.04) (-0.9399, -5.04) (-0.6648, -5.3575) (-0.6648, -5.6425) (-0.9399, -5.96) (-1.222, -6.0005) (-1.3601, -5.96), closed, covered)
  P2_DCN_L2_h38 = polyline(z=0mm, xy in mm: (-0.1601, -5.96) (-0.4352, -5.6425) (-0.4352, -5.3575) (-0.1601, -5.04) (0.2601, -5.04) (0.5352, -5.3575) (0.5352, -5.6425) (0.2601, -5.96) (-0.022, -6.0005) (-0.1601, -5.96), closed, covered)
  P2_DCN_L2_h39 = polyline(z=0mm, xy in mm: (1.0399, -5.96) (0.7648, -5.6425) (0.7648, -5.3575) (1.0399, -5.04) (1.4601, -5.04) (1.7352, -5.3575) (1.7352, -5.6425) (1.4601, -5.96) (1.178, -6.0005) (1.0399, -5.96), closed, covered)
  P2_DCN_L2_h40 = polyline(z=0mm, xy in mm: (2.2399, -5.96) (1.9648, -5.6425) (1.9648, -5.3575) (2.2399, -5.04) (2.6601, -5.04) (2.9352, -5.3575) (2.9352, -5.6425) (2.6601, -5.96) (2.378, -6.0005) (2.2399, -5.96), closed, covered)
  P2_DCN_L2_h41 = polyline(z=0mm, xy in mm: (3.4399, -5.96) (3.1648, -5.6425) (3.1648, -5.3575) (3.4399, -5.04) (3.8601, -5.04) (4.1352, -5.3575) (4.1352, -5.6425) (3.8601, -5.96) (3.578, -6.0005) (3.4399, -5.96), closed, covered)
  P2_DCN_L2_h42 = polyline(z=0mm, xy in mm: (4.6399, -5.96) (4.3648, -5.6425) (4.3648, -5.3575) (4.6399, -5.04) (5.0601, -5.04) (5.3352, -5.3575) (5.3352, -5.6425) (5.0601, -5.96) (4.778, -6.0005) (4.6399, -5.96), closed, covered)
  P2_DCN_L2_h43 = polyline(z=0mm, xy in mm: (5.8399, -5.96) (5.5648, -5.6425) (5.5648, -5.3575) (5.8399, -5.04) (6.2601, -5.04) (6.5352, -5.3575) (6.5352, -5.6425) (6.2601, -5.96) (5.978, -6.0005) (5.8399, -5.96), closed, covered)
  P2_DCN_L2_h44 = polyline(z=0mm, xy in mm: (8.1399, -5.96) (7.8648, -5.6425) (7.8648, -5.3575) (8.1399, -5.04) (8.5601, -5.04) (8.7754, -5.2266) (8.9188, -5.5012) (8.6811, -5.8821) (8.278, -6.0005) (8.1399, -5.96), closed, covered)
  P2_DCN_L2_h45 = polyline(z=0mm, xy in mm: (9.3246, -5.96) (9.1092, -5.7734) (8.9658, -5.4988) (9.1092, -5.2266) (9.3246, -5.04) (9.7447, -5.04) (9.96, -5.2266) (10.1034, -5.5012) (9.8657, -5.8821) (9.4626, -6.0005) (9.3246, -5.96), closed, covered)
  P2_DCN_L2_h46 = polyline(z=0mm, xy in mm: (10.5092, -5.96) (10.2939, -5.7734) (10.1504, -5.4988) (10.2939, -5.2266) (10.5092, -5.04) (10.9293, -5.04) (11.1446, -5.2266) (11.288, -5.5012) (11.0504, -5.8821) (10.6473, -6.0005) (10.5092, -5.96), closed, covered)
  P2_DCN_L2_h47 = polyline(z=0mm, xy in mm: (11.6938, -5.96) (11.4785, -5.7734) (11.335, -5.4988) (11.4785, -5.2266) (11.6938, -5.04) (12.1139, -5.04) (12.3292, -5.2266) (12.4727, -5.5012) (12.235, -5.8821) (11.8319, -6.0005) (11.6938, -5.96), closed, covered)
  P2_DCN_L2_h48 = polyline(z=0mm, xy in mm: (12.8784, -5.96) (12.6631, -5.7734) (12.5196, -5.4988) (12.6631, -5.2266) (12.8784, -5.04) (13.2985, -5.04) (13.5138, -5.2266) (13.6573, -5.5012) (13.4196, -5.8821) (13.0165, -6.0005) (12.8784, -5.96), closed, covered)
  P2_DCN_L2_h49 = polyline(z=0mm, xy in mm: (14.063, -5.96) (13.8477, -5.7734) (13.7043, -5.4988) (13.8477, -5.2266) (14.063, -5.04) (14.4831, -5.04) (14.6985, -5.2266) (14.8419, -5.5012) (14.6042, -5.8821) (14.2011, -6.0005) (14.063, -5.96), closed, covered)
  P2_DCN_L2_h50 = polyline(z=0mm, xy in mm: (15.2476, -5.96) (15.0323, -5.7734) (14.8889, -5.4988) (15.0323, -5.2266) (15.2476, -5.04) (15.6677, -5.04) (15.8831, -5.2266) (16.0265, -5.5012) (15.7888, -5.8821) (15.3857, -6.0005) (15.2476, -5.96), closed, covered)
  P2_DCN_L2_h51 = polyline(z=0mm, xy in mm: (16.4323, -5.96) (16.2169, -5.7734) (16.0735, -5.4988) (16.2169, -5.2266) (16.4322, -5.04) (16.8524, -5.04) (17.0677, -5.2266) (17.2111, -5.5012) (16.9734, -5.8821) (16.5703, -6.0005) (16.4323, -5.96), closed, covered)
  P2_DCN_L2_h52 = polyline(z=0mm, xy in mm: (17.6169, -5.96) (17.4015, -5.7734) (17.2581, -5.4988) (17.4015, -5.2266) (17.6169, -5.04) (18.037, -5.04) (18.2523, -5.2266) (18.3957, -5.5012) (18.1581, -5.8821) (17.755, -6.0005) (17.6169, -5.96), closed, covered)
  P2_DCN_L2_h53 = polyline(z=0mm, xy in mm: (18.8015, -5.96) (18.5862, -5.7734) (18.4427, -5.4988) (18.5862, -5.2266) (18.8015, -5.04) (19.2216, -5.04) (19.4369, -5.2266) (19.5804, -5.5012) (19.3427, -5.8821) (18.9396, -6.0005) (18.8015, -5.96), closed, covered)
  P2_DCN_L2_h54 = polyline(z=0mm, xy in mm: (19.9861, -5.96) (19.7708, -5.7734) (19.6273, -5.4988) (19.7708, -5.2266) (19.9861, -5.04) (20.4062, -5.04) (20.6215, -5.2266) (20.765, -5.5012) (20.5273, -5.8821) (20.1242, -6.0005) (19.9861, -5.96), closed, covered)
  P2_DCN_L2_h55 = polyline(z=0mm, xy in mm: (21.1707, -5.96) (20.9554, -5.7734) (20.812, -5.4988) (20.9554, -5.2266) (21.1707, -5.04) (21.5908, -5.04) (21.8061, -5.2266) (21.9496, -5.5012) (21.7119, -5.8821) (21.3088, -6.0005) (21.1707, -5.96), closed, covered)
  P2_DCN_L2_h56 = polyline(z=0mm, xy in mm: (22.3553, -5.96) (22.14, -5.7734) (21.9966, -5.4988) (22.14, -5.2266) (22.3553, -5.04) (22.7754, -5.04) (22.9908, -5.2266) (23.1342, -5.5012) (22.8965, -5.8821) (22.4934, -6.0005) (22.3553, -5.96), closed, covered)
  P2_DCN_L2_h57 = polyline(z=0mm, xy in mm: (23.5399, -5.96) (23.3246, -5.7734) (23.1812, -5.4988) (23.3246, -5.2266) (23.5399, -5.04) (23.9601, -5.04) (24.1754, -5.2266) (24.3188, -5.5012) (24.0811, -5.8821) (23.678, -6.0005) (23.5399, -5.96), closed, covered)
  P2_DCN_L2_h58 = polyline(z=0mm, xy in mm: (24.7246, -5.96) (24.5092, -5.7734) (24.3658, -5.4988) (24.5092, -5.2266) (24.7246, -5.04) (25.1447, -5.04) (25.36, -5.2266) (25.5034, -5.5012) (25.2657, -5.8821) (24.8627, -6.0005) (24.7246, -5.96), closed, covered)
  P2_DCN_L2_h59 = polyline(z=0mm, xy in mm: (25.9092, -5.96) (25.6939, -5.7734) (25.5504, -5.4988) (25.6939, -5.2266) (25.9092, -5.04) (26.3293, -5.04) (26.5446, -5.2266) (26.688, -5.5012) (26.4504, -5.8821) (26.0473, -6.0005) (25.9092, -5.96), closed, covered)
  P2_DCN_L2_h60 = polyline(z=0mm, xy in mm: (27.0938, -5.96) (26.8785, -5.7734) (26.735, -5.4988) (26.8785, -5.2266) (27.0938, -5.04) (27.5139, -5.04) (27.7292, -5.2266) (27.8727, -5.5012) (27.635, -5.8821) (27.2319, -6.0005) (27.0938, -5.96), closed, covered)
  P2_DCN_L2_h61 = polyline(z=0mm, xy in mm: (28.2784, -5.96) (28.0631, -5.7734) (27.9196, -5.4988) (28.0631, -5.2266) (28.2784, -5.04) (28.6985, -5.04) (28.9138, -5.2266) (29.0573, -5.5012) (28.8196, -5.8821) (28.4165, -6.0005) (28.2784, -5.96), closed, covered)
  P2_DCN_L2_h62 = polyline(z=0mm, xy in mm: (29.463, -5.96) (29.2477, -5.7734) (29.1043, -5.4988) (29.2477, -5.2266) (29.463, -5.04) (29.8831, -5.04) (30.0985, -5.2266) (30.2419, -5.5012) (30.0042, -5.8821) (29.6011, -6.0005) (29.463, -5.96), closed, covered)
  P2_DCN_L2_h63 = polyline(z=0mm, xy in mm: (30.6476, -5.96) (30.4323, -5.7734) (30.2889, -5.4988) (30.4323, -5.2266) (30.6476, -5.04) (31.0677, -5.04) (31.2831, -5.2266) (31.4265, -5.5012) (31.1888, -5.8821) (30.7857, -6.0005) (30.6476, -5.96), closed, covered)
  P2_DCN_L2_h64 = polyline(z=0mm, xy in mm: (31.8323, -5.96) (31.6169, -5.7734) (31.4735, -5.4988) (31.6169, -5.2266) (31.8322, -5.04) (32.2524, -5.04) (32.4677, -5.2266) (32.6111, -5.5012) (32.3734, -5.8821) (31.9703, -6.0005) (31.8323, -5.96), closed, covered)
  P2_DCN_L2_h65 = polyline(z=0mm, xy in mm: (33.0169, -5.96) (32.8015, -5.7734) (32.6581, -5.4988) (32.8015, -5.2266) (33.0169, -5.04) (33.437, -5.04) (33.6523, -5.2266) (33.7957, -5.5012) (33.5581, -5.8821) (33.155, -6.0005) (33.0169, -5.96), closed, covered)
  P2_DCN_L2_h66 = polyline(z=0mm, xy in mm: (34.2015, -5.96) (33.9862, -5.7734) (33.8427, -5.4988) (33.9862, -5.2266) (34.2015, -5.04) (34.6216, -5.04) (34.8369, -5.2266) (34.9804, -5.5012) (34.7427, -5.8821) (34.3396, -6.0005) (34.2015, -5.96), closed, covered)
  P2_DCN_L2_h67 = polyline(z=0mm, xy in mm: (35.3861, -5.96) (35.1708, -5.7734) (35.0273, -5.4988) (35.1708, -5.2266) (35.3861, -5.04) (35.8062, -5.04) (36.0215, -5.2266) (36.165, -5.5012) (35.9273, -5.8821) (35.5242, -6.0005) (35.3861, -5.96), closed, covered)
  P2_DCN_L2_h68 = polyline(z=0mm, xy in mm: (36.5707, -5.96) (36.3554, -5.7734) (36.212, -5.4988) (36.3554, -5.2266) (36.5707, -5.04) (36.9908, -5.04) (37.2061, -5.2266) (37.3496, -5.5012) (37.1119, -5.8821) (36.7088, -6.0005) (36.5707, -5.96), closed, covered)
  P2_DCN_L2_h69 = polyline(z=0mm, xy in mm: (37.7553, -5.96) (37.54, -5.7734) (37.3966, -5.4988) (37.54, -5.2266) (37.7553, -5.04) (38.1754, -5.04) (38.3908, -5.2266) (38.5342, -5.5012) (38.2965, -5.8821) (37.8934, -6.0005) (37.7553, -5.96), closed, covered)
  P2_DCN_L2_h70 = polyline(z=0mm, xy in mm: (-34.6216, -13.11) (-34.8369, -12.9234) (-34.9804, -12.6488) (-34.8369, -12.3766) (-34.6216, -12.19) (-34.2015, -12.19) (-33.9862, -12.3766) (-33.8427, -12.6512) (-34.0804, -13.0321) (-34.4835, -13.1505) (-34.6216, -13.11), closed, covered)
  P2_DCN_L2_h71 = polyline(z=0mm, xy in mm: (-33.437, -13.11) (-33.6523, -12.9234) (-33.7957, -12.6488) (-33.6523, -12.3766) (-33.437, -12.19) (-33.0169, -12.19) (-32.8015, -12.3766) (-32.6581, -12.6512) (-32.8958, -13.0321) (-33.2989, -13.1505) (-33.437, -13.11), closed, covered)
  P2_DCN_L2_h72 = polyline(z=0mm, xy in mm: (-32.2524, -13.11) (-32.4677, -12.9234) (-32.6111, -12.6488) (-32.4677, -12.3766) (-32.2524, -12.19) (-31.8323, -12.19) (-31.6169, -12.3766) (-31.4735, -12.6512) (-31.7112, -13.0321) (-32.1143, -13.1505) (-32.2524, -13.11), closed, covered)
  P2_DCN_L2_h73 = polyline(z=0mm, xy in mm: (-31.0677, -13.11) (-31.2831, -12.9234) (-31.4265, -12.6488) (-31.2831, -12.3766) (-31.0678, -12.19) (-30.6476, -12.19) (-30.4323, -12.3766) (-30.2889, -12.6512) (-30.5266, -13.0321) (-30.9297, -13.1505) (-31.0677, -13.11), closed, covered)
  P2_DCN_L2_h74 = polyline(z=0mm, xy in mm: (-29.8831, -13.11) (-30.0985, -12.9234) (-30.2419, -12.6488) (-30.0985, -12.3766) (-29.8831, -12.19) (-29.463, -12.19) (-29.2477, -12.3766) (-29.1043, -12.6512) (-29.3419, -13.0321) (-29.745, -13.1505) (-29.8831, -13.11), closed, covered)
  P2_DCN_L2_h75 = polyline(z=0mm, xy in mm: (-28.6985, -13.11) (-28.9138, -12.9234) (-29.0573, -12.6488) (-28.9138, -12.3766) (-28.6985, -12.19) (-28.2784, -12.19) (-28.0631, -12.3766) (-27.9196, -12.6512) (-28.1573, -13.0321) (-28.5604, -13.1505) (-28.6985, -13.11), closed, covered)
  P2_DCN_L2_h76 = polyline(z=0mm, xy in mm: (-27.5139, -13.11) (-27.7292, -12.9234) (-27.8727, -12.6488) (-27.7292, -12.3766) (-27.5139, -12.19) (-27.0938, -12.19) (-26.8785, -12.3766) (-26.735, -12.6512) (-26.9727, -13.0321) (-27.3758, -13.1505) (-27.5139, -13.11), closed, covered)
  P2_DCN_L2_h77 = polyline(z=0mm, xy in mm: (-26.3293, -13.11) (-26.5446, -12.9234) (-26.688, -12.6488) (-26.5446, -12.3766) (-26.3293, -12.19) (-25.9092, -12.19) (-25.6939, -12.3766) (-25.5504, -12.6512) (-25.7881, -13.0321) (-26.1912, -13.1505) (-26.3293, -13.11), closed, covered)
  P2_DCN_L2_h78 = polyline(z=0mm, xy in mm: (-25.1447, -13.11) (-25.36, -12.9234) (-25.5034, -12.6488) (-25.36, -12.3766) (-25.1447, -12.19) (-24.7246, -12.19) (-24.5092, -12.3766) (-24.3658, -12.6512) (-24.6035, -13.0321) (-25.0066, -13.1505) (-25.1447, -13.11), closed, covered)
  P2_DCN_L2_h79 = polyline(z=0mm, xy in mm: (-23.9601, -13.11) (-24.1754, -12.9234) (-24.3188, -12.6488) (-24.1754, -12.3766) (-23.9601, -12.19) (-23.5399, -12.19) (-23.3246, -12.3766) (-23.1812, -12.6512) (-23.4189, -13.0321) (-23.822, -13.1505) (-23.9601, -13.11), closed, covered)
  P2_DCN_L2_h80 = polyline(z=0mm, xy in mm: (-22.7754, -13.11) (-22.9908, -12.9234) (-23.1342, -12.6488) (-22.9908, -12.3766) (-22.7754, -12.19) (-22.3553, -12.19) (-22.14, -12.3766) (-21.9966, -12.6512) (-22.2343, -13.0321) (-22.6373, -13.1505) (-22.7754, -13.11), closed, covered)
  P2_DCN_L2_h81 = polyline(z=0mm, xy in mm: (-21.5908, -13.11) (-21.8061, -12.9234) (-21.9496, -12.6488) (-21.8061, -12.3766) (-21.5908, -12.19) (-21.1707, -12.19) (-20.9554, -12.3766) (-20.812, -12.6512) (-21.0496, -13.0321) (-21.4527, -13.1505) (-21.5908, -13.11), closed, covered)
  P2_DCN_L2_h82 = polyline(z=0mm, xy in mm: (-20.4062, -13.11) (-20.6215, -12.9234) (-20.765, -12.6488) (-20.6215, -12.3766) (-20.4062, -12.19) (-19.9861, -12.19) (-19.7708, -12.3766) (-19.6273, -12.6512) (-19.865, -13.0321) (-20.2681, -13.1505) (-20.4062, -13.11), closed, covered)
  P2_DCN_L2_h83 = polyline(z=0mm, xy in mm: (-19.2216, -13.11) (-19.4369, -12.9234) (-19.5804, -12.6488) (-19.4369, -12.3766) (-19.2216, -12.19) (-18.8015, -12.19) (-18.5862, -12.3766) (-18.4427, -12.6512) (-18.6804, -13.0321) (-19.0835, -13.1505) (-19.2216, -13.11), closed, covered)
  P2_DCN_L2_h84 = polyline(z=0mm, xy in mm: (-18.037, -13.11) (-18.2523, -12.9234) (-18.3957, -12.6488) (-18.2523, -12.3766) (-18.037, -12.19) (-17.6169, -12.19) (-17.4015, -12.3766) (-17.2581, -12.6512) (-17.4958, -13.0321) (-17.8989, -13.1505) (-18.037, -13.11), closed, covered)
  P2_DCN_L2_h85 = polyline(z=0mm, xy in mm: (-16.8524, -13.11) (-17.0677, -12.9234) (-17.2111, -12.6488) (-17.0677, -12.3766) (-16.8524, -12.19) (-16.4323, -12.19) (-16.2169, -12.3766) (-16.0735, -12.6512) (-16.3112, -13.0321) (-16.7143, -13.1505) (-16.8524, -13.11), closed, covered)
  P2_DCN_L2_h86 = polyline(z=0mm, xy in mm: (-15.6677, -13.11) (-15.8831, -12.9234) (-16.0265, -12.6488) (-15.8831, -12.3766) (-15.6678, -12.19) (-15.2476, -12.19) (-15.0323, -12.3766) (-14.8889, -12.6512) (-15.1266, -13.0321) (-15.5297, -13.1505) (-15.6677, -13.11), closed, covered)
  P2_DCN_L2_h87 = polyline(z=0mm, xy in mm: (-14.4831, -13.11) (-14.6985, -12.9234) (-14.8419, -12.6488) (-14.6985, -12.3766) (-14.4831, -12.19) (-14.063, -12.19) (-13.8477, -12.3766) (-13.7043, -12.6512) (-13.9419, -13.0321) (-14.345, -13.1505) (-14.4831, -13.11), closed, covered)
  P2_DCN_L2_h88 = polyline(z=0mm, xy in mm: (-13.2985, -13.11) (-13.5138, -12.9234) (-13.6573, -12.6488) (-13.5138, -12.3766) (-13.2985, -12.19) (-12.8784, -12.19) (-12.6631, -12.3766) (-12.5196, -12.6512) (-12.7573, -13.0321) (-13.1604, -13.1505) (-13.2985, -13.11), closed, covered)
  P2_DCN_L2_h89 = polyline(z=0mm, xy in mm: (-12.1139, -13.11) (-12.3292, -12.9234) (-12.4727, -12.6488) (-12.3292, -12.3766) (-12.1139, -12.19) (-11.6938, -12.19) (-11.4785, -12.3766) (-11.335, -12.6512) (-11.5727, -13.0321) (-11.9758, -13.1505) (-12.1139, -13.11), closed, covered)
  P2_DCN_L2_h90 = polyline(z=0mm, xy in mm: (-10.9293, -13.11) (-11.1446, -12.9234) (-11.288, -12.6488) (-11.1446, -12.3766) (-10.9293, -12.19) (-10.5092, -12.19) (-10.2939, -12.3766) (-10.1504, -12.6512) (-10.3881, -13.0321) (-10.7912, -13.1505) (-10.9293, -13.11), closed, covered)
  P2_DCN_L2_h91 = polyline(z=0mm, xy in mm: (-9.7447, -13.11) (-9.96, -12.9234) (-10.1034, -12.6488) (-9.96, -12.3766) (-9.7447, -12.19) (-9.3246, -12.19) (-9.1092, -12.3766) (-8.9658, -12.6512) (-9.2035, -13.0321) (-9.6066, -13.1505) (-9.7447, -13.11), closed, covered)
  P2_DCN_L2_h92 = polyline(z=0mm, xy in mm: (-8.56, -13.11) (-8.7754, -12.9234) (-8.9188, -12.6488) (-8.7754, -12.3766) (-8.5601, -12.19) (-8.1399, -12.19) (-7.8648, -12.5075) (-7.8648, -12.7925) (-8.1399, -13.11) (-8.422, -13.1505) (-8.56, -13.11), closed, covered)
  P2_DCN_L2_h93 = polyline(z=0mm, xy in mm: (-7.3601, -13.11) (-7.6352, -12.7925) (-7.6352, -12.5075) (-7.3601, -12.19) (-6.9399, -12.19) (-6.6648, -12.5075) (-6.6648, -12.7925) (-6.9399, -13.11) (-7.222, -13.1505) (-7.3601, -13.11), closed, covered)
  P2_DCN_L2_h94 = polyline(z=0mm, xy in mm: (-6.1601, -13.11) (-6.4352, -12.7925) (-6.4352, -12.5075) (-6.1601, -12.19) (-5.7399, -12.19) (-5.4648, -12.5075) (-5.4648, -12.7925) (-5.7399, -13.11) (-6.022, -13.1505) (-6.1601, -13.11), closed, covered)
  P2_DCN_L2_h95 = polyline(z=0mm, xy in mm: (-4.9601, -13.11) (-5.2352, -12.7925) (-5.2352, -12.5075) (-4.9601, -12.19) (-4.5399, -12.19) (-4.2648, -12.5075) (-4.2648, -12.7925) (-4.5399, -13.11) (-4.822, -13.1505) (-4.9601, -13.11), closed, covered)
  P2_DCN_L2_h96 = polyline(z=0mm, xy in mm: (-3.7601, -13.11) (-4.0352, -12.7925) (-4.0352, -12.5075) (-3.7601, -12.19) (-3.3399, -12.19) (-3.0648, -12.5075) (-3.0648, -12.7925) (-3.3399, -13.11) (-3.622, -13.1505) (-3.7601, -13.11), closed, covered)
  P2_DCN_L2_h97 = polyline(z=0mm, xy in mm: (-2.56, -13.11) (-2.8352, -12.7925) (-2.8352, -12.5075) (-2.5601, -12.19) (-2.1399, -12.19) (-1.8648, -12.5075) (-1.8648, -12.7925) (-2.1399, -13.11) (-2.422, -13.1505) (-2.56, -13.11), closed, covered)
  P2_DCN_L2_h98 = polyline(z=0mm, xy in mm: (-1.3601, -13.11) (-1.6352, -12.7925) (-1.6352, -12.5075) (-1.3601, -12.19) (-0.9399, -12.19) (-0.6648, -12.5075) (-0.6648, -12.7925) (-0.9399, -13.11) (-1.222, -13.1505) (-1.3601, -13.11), closed, covered)
  P2_DCN_L2_h99 = polyline(z=0mm, xy in mm: (-0.1601, -13.11) (-0.4352, -12.7925) (-0.4352, -12.5075) (-0.1601, -12.19) (0.2601, -12.19) (0.5352, -12.5075) (0.5352, -12.7925) (0.2601, -13.11) (-0.022, -13.1505) (-0.1601, -13.11), closed, covered)
  P2_DCN_L2_h100 = polyline(z=0mm, xy in mm: (1.0399, -13.11) (0.7648, -12.7925) (0.7648, -12.5075) (1.0399, -12.19) (1.4601, -12.19) (1.7352, -12.5075) (1.7352, -12.7925) (1.4601, -13.11) (1.178, -13.1505) (1.0399, -13.11), closed, covered)
  P2_DCN_L2_h101 = polyline(z=0mm, xy in mm: (2.2399, -13.11) (1.9648, -12.7925) (1.9648, -12.5075) (2.2399, -12.19) (2.6601, -12.19) (2.9352, -12.5075) (2.9352, -12.7925) (2.6601, -13.11) (2.378, -13.1505) (2.2399, -13.11), closed, covered)
  P2_DCN_L2_h102 = polyline(z=0mm, xy in mm: (3.4399, -13.11) (3.1648, -12.7925) (3.1648, -12.5075) (3.4399, -12.19) (3.8601, -12.19) (4.1352, -12.5075) (4.1352, -12.7925) (3.8601, -13.11) (3.578, -13.1505) (3.4399, -13.11), closed, covered)
  P2_DCN_L2_h103 = polyline(z=0mm, xy in mm: (4.6399, -13.11) (4.3648, -12.7925) (4.3648, -12.5075) (4.6399, -12.19) (5.0601, -12.19) (5.3352, -12.5075) (5.3352, -12.7925) (5.0601, -13.11) (4.778, -13.1505) (4.6399, -13.11), closed, covered)
  P2_DCN_L2_h104 = polyline(z=0mm, xy in mm: (5.8399, -13.11) (5.5648, -12.7925) (5.5648, -12.5075) (5.8399, -12.19) (6.2601, -12.19) (6.5352, -12.5075) (6.5352, -12.7925) (6.2601, -13.11) (5.978, -13.1505) (5.8399, -13.11), closed, covered)
  P2_DCN_L2_h105 = polyline(z=0mm, xy in mm: (8.1399, -13.11) (7.8648, -12.7925) (7.8648, -12.5075) (8.1399, -12.19) (8.5601, -12.19) (8.7754, -12.3766) (8.9188, -12.6512) (8.6811, -13.0321) (8.278, -13.1505) (8.1399, -13.11), closed, covered)
  P2_DCN_L2_h106 = polyline(z=0mm, xy in mm: (9.3246, -13.11) (9.1092, -12.9234) (8.9658, -12.6488) (9.1092, -12.3766) (9.3246, -12.19) (9.7447, -12.19) (9.96, -12.3766) (10.1034, -12.6512) (9.8657, -13.0321) (9.4626, -13.1505) (9.3246, -13.11), closed, covered)
  P2_DCN_L2_h107 = polyline(z=0mm, xy in mm: (10.5092, -13.11) (10.2939, -12.9234) (10.1504, -12.6488) (10.2939, -12.3766) (10.5092, -12.19) (10.9293, -12.19) (11.1446, -12.3766) (11.288, -12.6512) (11.0504, -13.0321) (10.6473, -13.1505) (10.5092, -13.11), closed, covered)
  P2_DCN_L2_h108 = polyline(z=0mm, xy in mm: (11.6938, -13.11) (11.4785, -12.9234) (11.335, -12.6488) (11.4785, -12.3766) (11.6938, -12.19) (12.1139, -12.19) (12.3292, -12.3766) (12.4727, -12.6512) (12.235, -13.0321) (11.8319, -13.1505) (11.6938, -13.11), closed, covered)
  P2_DCN_L2_h109 = polyline(z=0mm, xy in mm: (12.8784, -13.11) (12.6631, -12.9234) (12.5196, -12.6488) (12.6631, -12.3766) (12.8784, -12.19) (13.2985, -12.19) (13.5138, -12.3766) (13.6573, -12.6512) (13.4196, -13.0321) (13.0165, -13.1505) (12.8784, -13.11), closed, covered)
  P2_DCN_L2_h110 = polyline(z=0mm, xy in mm: (14.063, -13.11) (13.8477, -12.9234) (13.7043, -12.6488) (13.8477, -12.3766) (14.063, -12.19) (14.4831, -12.19) (14.6985, -12.3766) (14.8419, -12.6512) (14.6042, -13.0321) (14.2011, -13.1505) (14.063, -13.11), closed, covered)
  P2_DCN_L2_h111 = polyline(z=0mm, xy in mm: (15.2476, -13.11) (15.0323, -12.9234) (14.8889, -12.6488) (15.0323, -12.3766) (15.2476, -12.19) (15.6677, -12.19) (15.8831, -12.3766) (16.0265, -12.6512) (15.7888, -13.0321) (15.3857, -13.1505) (15.2476, -13.11), closed, covered)
  P2_DCN_L2_h112 = polyline(z=0mm, xy in mm: (16.4323, -13.11) (16.2169, -12.9234) (16.0735, -12.6488) (16.2169, -12.3766) (16.4322, -12.19) (16.8524, -12.19) (17.0677, -12.3766) (17.2111, -12.6512) (16.9734, -13.0321) (16.5703, -13.1505) (16.4323, -13.11), closed, covered)
  P2_DCN_L2_h113 = polyline(z=0mm, xy in mm: (17.6169, -13.11) (17.4015, -12.9234) (17.2581, -12.6488) (17.4015, -12.3766) (17.6169, -12.19) (18.037, -12.19) (18.2523, -12.3766) (18.3957, -12.6512) (18.1581, -13.0321) (17.755, -13.1505) (17.6169, -13.11), closed, covered)
  P2_DCN_L2_h114 = polyline(z=0mm, xy in mm: (18.8015, -13.11) (18.5862, -12.9234) (18.4427, -12.6488) (18.5862, -12.3766) (18.8015, -12.19) (19.2216, -12.19) (19.4369, -12.3766) (19.5804, -12.6512) (19.3427, -13.0321) (18.9396, -13.1505) (18.8015, -13.11), closed, covered)
  P2_DCN_L2_h115 = polyline(z=0mm, xy in mm: (19.9861, -13.11) (19.7708, -12.9234) (19.6273, -12.6488) (19.7708, -12.3766) (19.9861, -12.19) (20.4062, -12.19) (20.6215, -12.3766) (20.765, -12.6512) (20.5273, -13.0321) (20.1242, -13.1505) (19.9861, -13.11), closed, covered)
  P2_DCN_L2_h116 = polyline(z=0mm, xy in mm: (21.1707, -13.11) (20.9554, -12.9234) (20.812, -12.6488) (20.9554, -12.3766) (21.1707, -12.19) (21.5908, -12.19) (21.8061, -12.3766) (21.9496, -12.6512) (21.7119, -13.0321) (21.3088, -13.1505) (21.1707, -13.11), closed, covered)
  P2_DCN_L2_h117 = polyline(z=0mm, xy in mm: (22.3553, -13.11) (22.14, -12.9234) (21.9966, -12.6488) (22.14, -12.3766) (22.3553, -12.19) (22.7754, -12.19) (22.9908, -12.3766) (23.1342, -12.6512) (22.8965, -13.0321) (22.4934, -13.1505) (22.3553, -13.11), closed, covered)
  P2_DCN_L2_h118 = polyline(z=0mm, xy in mm: (23.5399, -13.11) (23.3246, -12.9234) (23.1812, -12.6488) (23.3246, -12.3766) (23.5399, -12.19) (23.9601, -12.19) (24.1754, -12.3766) (24.3188, -12.6512) (24.0811, -13.0321) (23.678, -13.1505) (23.5399, -13.11), closed, covered)
  P2_DCN_L2_h119 = polyline(z=0mm, xy in mm: (24.7246, -13.11) (24.5092, -12.9234) (24.3658, -12.6488) (24.5092, -12.3766) (24.7246, -12.19) (25.1447, -12.19) (25.36, -12.3766) (25.5034, -12.6512) (25.2657, -13.0321) (24.8627, -13.1505) (24.7246, -13.11), closed, covered)
  P2_DCN_L2_h120 = polyline(z=0mm, xy in mm: (25.9092, -13.11) (25.6939, -12.9234) (25.5504, -12.6488) (25.6939, -12.3766) (25.9092, -12.19) (26.3293, -12.19) (26.5446, -12.3766) (26.688, -12.6512) (26.4504, -13.0321) (26.0473, -13.1505) (25.9092, -13.11), closed, covered)
  P2_DCN_L2_h121 = polyline(z=0mm, xy in mm: (27.0938, -13.11) (26.8785, -12.9234) (26.735, -12.6488) (26.8785, -12.3766) (27.0938, -12.19) (27.5139, -12.19) (27.7292, -12.3766) (27.8727, -12.6512) (27.635, -13.0321) (27.2319, -13.1505) (27.0938, -13.11), closed, covered)
  P2_DCN_L2_h122 = polyline(z=0mm, xy in mm: (28.2784, -13.11) (28.0631, -12.9234) (27.9196, -12.6488) (28.0631, -12.3766) (28.2784, -12.19) (28.6985, -12.19) (28.9138, -12.3766) (29.0573, -12.6512) (28.8196, -13.0321) (28.4165, -13.1505) (28.2784, -13.11), closed, covered)
  P2_DCN_L2_h123 = polyline(z=0mm, xy in mm: (29.463, -13.11) (29.2477, -12.9234) (29.1043, -12.6488) (29.2477, -12.3766) (29.463, -12.19) (29.8831, -12.19) (30.0985, -12.3766) (30.2419, -12.6512) (30.0042, -13.0321) (29.6011, -13.1505) (29.463, -13.11), closed, covered)
  P2_DCN_L2_h124 = polyline(z=0mm, xy in mm: (30.6476, -13.11) (30.4323, -12.9234) (30.2889, -12.6488) (30.4323, -12.3766) (30.6476, -12.19) (31.0677, -12.19) (31.2831, -12.3766) (31.4265, -12.6512) (31.1888, -13.0321) (30.7857, -13.1505) (30.6476, -13.11), closed, covered)
  P2_DCN_L2_h125 = polyline(z=0mm, xy in mm: (31.8323, -13.11) (31.6169, -12.9234) (31.4735, -12.6488) (31.6169, -12.3766) (31.8322, -12.19) (32.2524, -12.19) (32.4677, -12.3766) (32.6111, -12.6512) (32.3734, -13.0321) (31.9703, -13.1505) (31.8323, -13.11), closed, covered)
  P2_DCN_L2_h126 = polyline(z=0mm, xy in mm: (33.0169, -13.11) (32.8015, -12.9234) (32.6581, -12.6488) (32.8015, -12.3766) (33.0169, -12.19) (33.437, -12.19) (33.6523, -12.3766) (33.7957, -12.6512) (33.5581, -13.0321) (33.155, -13.1505) (33.0169, -13.11), closed, covered)
  P2_DCN_L2_h127 = polyline(z=0mm, xy in mm: (34.2015, -13.11) (33.9862, -12.9234) (33.8427, -12.6488) (33.9862, -12.3766) (34.2015, -12.19) (34.6216, -12.19) (34.8369, -12.3766) (34.9804, -12.6512) (34.7427, -13.0321) (34.3396, -13.1505) (34.2015, -13.11), closed, covered)
  P2_DCN_L2_h128 = polyline(z=0mm, xy in mm: (-9.3368, -17.6253) (-9.8378, -17.4287) (-10.4268, -16.8821) (-10.7204, -16.1341) (-10.7204, -15.5959) (-10.4268, -14.8479) (-9.8378, -14.3013) (-9.3368, -14.1047) (-8.5332, -14.1047) (-8.0322, -14.3013) (-7.4432, -14.8479) (-7.1496, -15.5959) (-7.1496, -16.1341) (-7.4432, -16.8821) (-7.8093, -17.2766) (-8.5332, -17.6253) (-9.0699, -17.6655) (-9.3368, -17.6253), closed, covered)
  P2_DCN_L2_h129 = polyline(z=0mm, xy in mm: (-3.4668, -17.6253) (-3.9678, -17.4287) (-4.5568, -16.8821) (-4.8504, -16.1341) (-4.8504, -15.5959) (-4.5568, -14.8479) (-3.9678, -14.3013) (-3.4668, -14.1047) (-2.6632, -14.1047) (-2.1622, -14.3013) (-1.5732, -14.8479) (-1.2796, -15.5959) (-1.2796, -16.1341) (-1.5732, -16.8821) (-1.9393, -17.2766) (-2.6632, -17.6253) (-3.1999, -17.6655) (-3.4668, -17.6253), closed, covered)
  P2_DCN_L2.subtract(P2_DCN_L2_h0..P2_DCN_L2_h129)
  P2_DCN_L2.sweep_along_vector((0mm, 0mm, 0.07mm))
  P3_DCN_L4 = polyline(z=-1.44mm, xy in mm: (-28.4908, -1.1811) (-28.45, 0.851) (-28.5184, 0.9452) (-37.951, 0.95) (-38.0452, 0.8816) (-38.05, -1.101) (-37.9816, -1.1952) (-28.549, -1.2) (-28.4908, -1.1811), closed, covered)
  P3_DCN_L4.sweep_along_vector((0mm, 0mm, 0.07mm))
  P4_DCN_L4 = polyline(z=-1.44mm, xy in mm: (-9.4908, -1.1811) (-9.45, 0.851) (-9.5184, 0.9452) (-18.951, 0.95) (-19.0452, 0.8816) (-19.05, -1.101) (-18.9816, -1.1952) (-9.549, -1.2) (-9.4908, -1.1811), closed, covered)
  P4_DCN_L4.sweep_along_vector((0mm, 0mm, 0.07mm))
  P5_DCN_L4 = polyline(z=-1.44mm, xy in mm: (19.0092, -1.1811) (19.05, 0.851) (18.9816, 0.9452) (9.549, 0.95) (9.4548, 0.8816) (9.45, -1.101) (9.5184, -1.1952) (18.951, -1.2) (19.0092, -1.1811), closed, covered)
  P5_DCN_L4.sweep_along_vector((0mm, 0mm, 0.07mm))
  P6_DCN_L4 = polyline(z=-1.44mm, xy in mm: (38.0092, -1.1811) (38.05, 0.851) (37.9816, 0.9452) (28.549, 0.95) (28.4548, 0.8816) (28.45, -1.101) (28.5184, -1.1952) (37.951, -1.2) (38.0092, -1.1811), closed, covered)
  P6_DCN_L4.sweep_along_vector((0mm, 0mm, 0.07mm))
  P7_DCN_L4 = polyline(z=-1.44mm, xy in mm: (-9.9519, -23.3811) (-9.9159, -23.2704) (-10.2586, -22.9631) (-10.5617, -22.5184) (-10.7405, -21.735) (-10.6603, -21.2028) (-10.4268, -20.7179) (-9.8378, -20.1713) (-9.3368, -19.9747) (-8.5332, -19.9747) (-8.0322, -20.1713) (-7.4432, -20.7179) (-7.1496, -21.4659) (-7.1496, -22.0041) (-7.3083, -22.5184) (-7.6114, -22.9631) (-7.9531, -23.2676) (-7.9205, -23.3793) (-4.1401, -23.4) (-4.0459, -23.2704) (-4.5568, -22.7521) (-4.7903, -22.2672) (-4.8705, -21.735) (-4.7903, -21.2028) (-4.3886, -20.5069) (-3.9678, -20.1713) (-3.4668, -19.9747) (-2.9301, -19.9345) (-2.4054, -20.0543) (-1.9393, -20.3234) (-1.5732, -20.7179) (-1.3397, -21.2028) (-1.2595, -21.735) (-1.3397, -22.2672) (-1.5732, -22.7521) (-2.0831, -23.2676) (-1.9929, -23.4) (35.651, -23.4) (35.75, -23.301) (35.75, -16.699) (35.651, -16.6) (-1.3532, -16.6) (-1.7414, -17.0931) (-2.1622, -17.4287) (-2.6632, -17.6253) (-3.1999, -17.6655) (-3.7246, -17.5457) (-4.1907, -17.2766) (-4.7366, -16.6086) (-7.2232, -16.6) (-7.6114, -17.0931) (-8.0322, -17.4287) (-8.5332, -17.6253) (-9.0699, -17.6655) (-9.8378, -17.4287) (-10.2586, -17.0931) (-10.6468, -16.6) (-35.651, -16.6) (-35.75, -16.699) (-35.75, -23.301) (-35.6816, -23.3952) (-10.0101, -23.4) (-9.9519, -23.3811), closed, covered)
  P7_DCN_L4.sweep_along_vector((0mm, 0mm, 0.07mm))
  P8_DCP_L1 [copper] = polyline(z=0.17mm, xy in mm: (-28.7908, 1.5189) (-28.75, 4.3) (-30.1465, 4.3) (-30.1495, 3.1377) (-30.2785, 2.9494) (-30.4106, 2.8995) (-31.3854, 2.8995) (-31.5996, 3.0315) (-31.6495, 4.3) (-32.2995, 4.3) (-32.2995, 3.1388) (-32.3736, 2.9736) (-32.5389, 2.8995) (-33.1886, 2.9149) (-33.3351, 3.0614) (-33.3505, 4.3) (-33.9995, 4.3) (-33.9995, 3.1388) (-34.0736, 2.9736) (-34.2389, 2.8995) (-34.8886, 2.9149) (-35.0351, 3.0614) (-35.0505, 4.3) (-37.75, 4.3) (-37.75, 1.599) (-37.6816, 1.5048) (-28.849, 1.5) (-28.7908, 1.5189), closed, covered)
  P8_DCP_L1.sweep_along_vector((0mm, 0mm, 0.07mm))
  P9_DCP_L1 = polyline(z=0.17mm, xy in mm: (-9.7908, 1.5189) (-9.75, 4.3) (-12.4495, 4.3) (-12.4495, 3.1388) (-12.5236, 2.9736) (-12.6889, 2.8995) (-13.3386, 2.9149) (-13.4851, 3.0614) (-13.5005, 4.3) (-14.1495, 4.3) (-14.1495, 3.1388) (-14.3114, 2.9149) (-14.9612, 2.8995) (-15.1851, 3.0614) (-15.2005, 4.3) (-15.8966, 4.3) (-15.8535, 3.1377) (-16.0887, 2.9025) (-17.1153, 2.9025) (-17.3036, 3.0315) (-17.3724, 3.2787) (-17.4525, 3.3195) (-18.0769, 3.3195) (-18.35, 3.2392) (-18.651, 3.3195) (-18.7452, 3.2511) (-18.75, 1.599) (-18.6816, 1.5048) (-9.849, 1.5) (-9.7908, 1.5189), closed, covered)
  P9_DCP_L1.sweep_along_vector((0mm, 0mm, 0.07mm))
  P10_DCP_L1 = polyline(z=0.17mm, xy in mm: (18.7092, 1.5189) (18.75, 4.3) (17.3535, 4.3) (17.3505, 3.1377) (17.2215, 2.9494) (17.0894, 2.8995) (16.1146, 2.8995) (15.9004, 3.0315) (15.8505, 4.3) (15.2005, 4.3) (15.2005, 3.1388) (15.1264, 2.9736) (14.9611, 2.8995) (14.3114, 2.9149) (14.1649, 3.0614) (14.1495, 4.3) (13.5005, 4.3) (13.5005, 3.1388) (13.4264, 2.9736) (13.2611, 2.8995) (12.6114, 2.9149) (12.4649, 3.0614) (12.4495, 4.3) (9.75, 4.3) (9.75, 1.599) (9.8184, 1.5048) (18.651, 1.5) (18.7092, 1.5189), closed, covered)
  P10_DCP_L1.sweep_along_vector((0mm, 0mm, 0.07mm))
  P11_DCP_L1 = polyline(z=0.17mm, xy in mm: (37.7092, 1.5189) (37.75, 4.3) (35.0505, 4.3) (35.0505, 3.1388) (34.9764, 2.9736) (34.8111, 2.8995) (34.1614, 2.9149) (34.0149, 3.0614) (33.9995, 4.3) (33.3505, 4.3) (33.3505, 3.1388) (33.1886, 2.9149) (32.5388, 2.8995) (32.3149, 3.0614) (32.2995, 4.3) (31.6034, 4.3) (31.6465, 3.1377) (31.4113, 2.9025) (30.3847, 2.9025) (30.1964, 3.0315) (30.1276, 3.2787) (30.0475, 3.3195) (29.4231, 3.3195) (29.15, 3.2392) (28.849, 3.3195) (28.7548, 3.2511) (28.75, 1.599) (28.8184, 1.5048) (37.651, 1.5) (37.7092, 1.5189), closed, covered)
  P11_DCP_L1.sweep_along_vector((0mm, 0mm, 0.07mm))
  P12_DCP_L1 = polyline(z=0.17mm, xy in mm: (39.7092, -7.9756) (39.75, -7.25) (42.3, -7.25) (42.3, -6.95) (39.75, -6.95) (39.75, -4.899) (39.651, -4.8) (-39.651, -4.8) (-39.75, -4.899) (-39.75, -7.8955) (-39.651, -7.9945) (39.651, -7.9945) (39.7092, -7.9756), closed, covered)
  P12_DCP_L1.sweep_along_vector((0mm, 0mm, 0.07mm))
  P13_DCP_L1 = polyline(z=0.17mm, xy in mm: (2.0481, -23.3811) (2.0841, -23.2704) (1.7414, -22.9631) (1.4383, -22.5184) (1.2595, -21.735) (1.3397, -21.2028) (1.5732, -20.7179) (2.1622, -20.1713) (2.6632, -19.9747) (3.4668, -19.9747) (3.9678, -20.1713) (4.5568, -20.7179) (4.8504, -21.4659) (4.8504, -22.0041) (4.6917, -22.5184) (4.3886, -22.9631) (4.0469, -23.2676) (4.0795, -23.3793) (7.8599, -23.4) (7.9541, -23.2704) (7.4432, -22.7521) (7.2097, -22.2672) (7.1295, -21.735) (7.2097, -21.2028) (7.6114, -20.5069) (8.0322, -20.1713) (8.5332, -19.9747) (9.0699, -19.9345) (9.5946, -20.0543) (10.0607, -20.3234) (10.4268, -20.7179) (10.6603, -21.2028) (10.7405, -21.735) (10.6603, -22.2672) (10.4268, -22.7521) (9.9169, -23.2676) (10.0071, -23.4) (35.651, -23.4) (35.75, -23.301) (35.75, -16) (39.7092, -15.9811) (39.75, -12.099) (39.6816, -12.0048) (-39.651, -12) (-39.7452, -12.0684) (-39.7311, -15.9592) (-35.75, -16) (-35.75, -23.301) (-35.6816, -23.3952) (1.9899, -23.4) (2.0481, -23.3811), closed, covered)
  P13_DCP_L1_h0 = polyline(z=0.17mm, xy in mm: (2.6632, -17.6253) (2.1622, -17.4287) (1.5732, -16.8821) (1.2796, -16.1341) (1.2796, -15.5959) (1.5732, -14.8479) (2.1622, -14.3013) (2.6632, -14.1047) (3.4668, -14.1047) (3.9678, -14.3013) (4.5568, -14.8479) (4.8504, -15.5959) (4.8504, -16.1341) (4.5568, -16.8821) (4.1907, -17.2766) (3.4668, -17.6253) (2.9301, -17.6655) (2.6632, -17.6253), closed, covered)
  P13_DCP_L1_h1 = polyline(z=0.17mm, xy in mm: (8.5332, -17.6253) (8.0322, -17.4287) (7.4432, -16.8821) (7.1496, -16.1341) (7.1496, -15.5959) (7.4432, -14.8479) (8.0322, -14.3013) (8.5332, -14.1047) (9.3368, -14.1047) (9.8378, -14.3013) (10.4268, -14.8479) (10.7204, -15.5959) (10.7204, -16.1341) (10.4268, -16.8821) (10.0607, -17.2766) (9.3368, -17.6253) (8.8001, -17.6655) (8.5332, -17.6253), closed, covered)
  P13_DCP_L1.subtract(P13_DCP_L1_h0, P13_DCP_L1_h1)
  P13_DCP_L1.sweep_along_vector((0mm, 0mm, 0.07mm))
  P14_DCP_L3 = polyline(z=-1.27mm, xy in mm: (2.0481, -23.3811) (2.0841, -23.2704) (1.5732, -22.7521) (1.3397, -22.2672) (1.2595, -21.735) (1.3397, -21.2028) (1.5732, -20.7179) (1.9393, -20.3234) (2.4054, -20.0543) (2.9301, -19.9345) (3.4668, -19.9747) (3.9678, -20.1713) (4.4839, -20.6264) (4.7903, -21.2028) (4.8705, -21.735) (4.7903, -22.2672) (4.5568, -22.7521) (4.0469, -23.2676) (4.1371, -23.4) (7.9181, -23.3811) (7.9541, -23.2704) (7.4432, -22.7521) (7.2097, -22.2672) (7.1295, -21.735) (7.2097, -21.2028) (7.4432, -20.7179) (7.8093, -20.3234) (8.2754, -20.0543) (8.8001, -19.9345) (9.3368, -19.9747) (9.8378, -20.1713) (10.3539, -20.6264) (10.6603, -21.2028) (10.7405, -21.735) (10.6603, -22.2672) (10.4268, -22.7521) (9.9169, -23.2676) (10.0071, -23.4) (35.7092, -23.3811) (35.75, -13.4) (39.651, -13.4) (39.75, -13.301) (39.7311, -11.0291) (39.6204, -10.9931) (39.3601, -11.21) (39.078, -11.2505) (38.8189, -11.1321) (38.5812, -10.7488) (38.8189, -10.3679) (39.078, -10.2495) (39.3601, -10.29) (39.6286, -10.5092) (39.75, -10.4127) (39.75, -0.8373) (39.6204, -0.7431) (39.3601, -0.96) (39.078, -1.0005) (38.8189, -0.8821) (38.5812, -0.4988) (38.8189, -0.1179) (39.078, 0.0005) (39.3601, -0.04) (39.6286, -0.2592) (39.75, -0.1627) (39.75, 4.3) (7.4023, 4.3) (7.4852, 4.1425) (7.4852, 3.8575) (7.3311, 3.6179) (7.072, 3.4995) (6.7899, 3.54) (6.5746, 3.7266) (6.4944, 4) (6.5977, 4.3) (-39.75, 4.3) (-39.75, -0.1627) (-39.6204, -0.2569) (-39.3601, -0.04) (-39.078, 0.0005) (-38.8189, -0.1179) (-38.5812, -0.5012) (-38.8189, -0.8821) (-39.078, -1.0005) (-39.3601, -0.96) (-39.6286, -0.7408) (-39.75, -0.8373) (-39.75, -10.4127) (-39.6204, -10.5069) (-39.3601, -10.29) (-39.078, -10.2495) (-38.8189, -10.3679) (-38.5812, -10.7512) (-38.8189, -11.1321) (-39.078, -11.2505) (-39.3601, -11.21) (-39.6286, -10.9908) (-39.7358, -11.0362) (-39.75, -13.301) (-39.651, -13.4) (-35.75, -13.4) (-35.75, -23.301) (-35.6816, -23.3952) (1.9899, -23.4) (2.0481, -23.3811), closed, covered)
  P14_DCP_L3_h0 = polyline(z=-1.27mm, xy in mm: (-18.4831, 3.2603) (-18.6985, 3.4168) (-18.7597, 3.8031) (-18.6032, 4.0185) (-18.2169, 4.0797) (-18.0015, 3.9232) (-17.9192, 3.67) (-18.0015, 3.4168) (-18.35, 3.2392) (-18.4831, 3.2603), closed, covered)
  P14_DCP_L3_h1 = polyline(z=-1.27mm, xy in mm: (29.0169, 3.2603) (28.8015, 3.4168) (28.7403, 3.8031) (28.8968, 4.0185) (29.2831, 4.0797) (29.4985, 3.9232) (29.5808, 3.67) (29.4985, 3.4168) (29.15, 3.2392) (29.0169, 3.2603), closed, covered)
  P14_DCP_L3_h2 = polyline(z=-1.27mm, xy in mm: (5.7899, 1.86) (5.5148, 2.1775) (5.5148, 2.4625) (5.7899, 2.78) (6.2101, 2.78) (6.4852, 2.4625) (6.4852, 2.1775) (6.2101, 1.86) (5.928, 1.8195) (5.7899, 1.86), closed, covered)
  P14_DCP_L3_h3 = polyline(z=-1.27mm, xy in mm: (-38.1754, -0.96) (-38.3908, -0.7734) (-38.5342, -0.4988) (-38.3908, -0.2266) (-38.1754, -0.04) (-37.7553, -0.04) (-37.54, -0.2266) (-37.3966, -0.5012) (-37.6343, -0.8821) (-38.0373, -1.0005) (-38.1754, -0.96), closed, covered)
  P14_DCP_L3_h4 = polyline(z=-1.27mm, xy in mm: (-36.9908, -0.96) (-37.2061, -0.7734) (-37.3496, -0.4988) (-37.2061, -0.2266) (-36.9908, -0.04) (-36.5707, -0.04) (-36.3554, -0.2266) (-36.212, -0.5012) (-36.4496, -0.8821) (-36.8527, -1.0005) (-36.9908, -0.96), closed, covered)
  P14_DCP_L3_h5 = polyline(z=-1.27mm, xy in mm: (-35.8062, -0.96) (-36.0215, -0.7734) (-36.165, -0.4988) (-36.0215, -0.2266) (-35.8062, -0.04) (-35.3861, -0.04) (-35.1708, -0.2266) (-35.0273, -0.5012) (-35.265, -0.8821) (-35.6681, -1.0005) (-35.8062, -0.96), closed, covered)
  P14_DCP_L3_h6 = polyline(z=-1.27mm, xy in mm: (-34.6216, -0.96) (-34.8369, -0.7734) (-34.9804, -0.4988) (-34.8369, -0.2266) (-34.6216, -0.04) (-34.2015, -0.04) (-33.9862, -0.2266) (-33.8427, -0.5012) (-34.0804, -0.8821) (-34.4835, -1.0005) (-34.6216, -0.96), closed, covered)
  P14_DCP_L3_h7 = polyline(z=-1.27mm, xy in mm: (-33.437, -0.96) (-33.6523, -0.7734) (-33.7957, -0.4988) (-33.6523, -0.2266) (-33.437, -0.04) (-33.0169, -0.04) (-32.8015, -0.2266) (-32.6581, -0.5012) (-32.8958, -0.8821) (-33.2989, -1.0005) (-33.437, -0.96), closed, covered)
  P14_DCP_L3_h8 = polyline(z=-1.27mm, xy in mm: (-32.2524, -0.96) (-32.4677, -0.7734) (-32.6111, -0.4988) (-32.4677, -0.2266) (-32.2524, -0.04) (-31.8323, -0.04) (-31.6169, -0.2266) (-31.4735, -0.5012) (-31.7112, -0.8821) (-32.1143, -1.0005) (-32.2524, -0.96), closed, covered)
  P14_DCP_L3_h9 = polyline(z=-1.27mm, xy in mm: (-31.0677, -0.96) (-31.2831, -0.7734) (-31.4265, -0.4988) (-31.2831, -0.2266) (-31.0678, -0.04) (-30.6476, -0.04) (-30.4323, -0.2266) (-30.2889, -0.5012) (-30.5266, -0.8821) (-30.9297, -1.0005) (-31.0677, -0.96), closed, covered)
  P14_DCP_L3_h10 = polyline(z=-1.27mm, xy in mm: (-29.8831, -0.96) (-30.0985, -0.7734) (-30.2419, -0.4988) (-30.0985, -0.2266) (-29.8831, -0.04) (-29.463, -0.04) (-29.2477, -0.2266) (-29.1043, -0.5012) (-29.3419, -0.8821) (-29.745, -1.0005) (-29.8831, -0.96), closed, covered)
  P14_DCP_L3_h11 = polyline(z=-1.27mm, xy in mm: (-28.6985, -0.96) (-28.9138, -0.7734) (-29.0573, -0.4988) (-28.9138, -0.2266) (-28.6985, -0.04) (-28.2784, -0.04) (-28.0631, -0.2266) (-27.9196, -0.5012) (-28.1573, -0.8821) (-28.5604, -1.0005) (-28.6985, -0.96), closed, covered)
  P14_DCP_L3_h12 = polyline(z=-1.27mm, xy in mm: (-27.5139, -0.96) (-27.7292, -0.7734) (-27.8727, -0.4988) (-27.7292, -0.2266) (-27.5139, -0.04) (-27.0938, -0.04) (-26.8785, -0.2266) (-26.735, -0.5012) (-26.9727, -0.8821) (-27.3758, -1.0005) (-27.5139, -0.96), closed, covered)
  P14_DCP_L3_h13 = polyline(z=-1.27mm, xy in mm: (-26.3293, -0.96) (-26.5446, -0.7734) (-26.688, -0.4988) (-26.5446, -0.2266) (-26.3293, -0.04) (-25.9092, -0.04) (-25.6939, -0.2266) (-25.5504, -0.5012) (-25.7881, -0.8821) (-26.1912, -1.0005) (-26.3293, -0.96), closed, covered)
  P14_DCP_L3_h14 = polyline(z=-1.27mm, xy in mm: (-25.1447, -0.96) (-25.36, -0.7734) (-25.5034, -0.4988) (-25.36, -0.2266) (-25.1447, -0.04) (-24.7246, -0.04) (-24.5092, -0.2266) (-24.3658, -0.5012) (-24.6035, -0.8821) (-25.0066, -1.0005) (-25.1447, -0.96), closed, covered)
  P14_DCP_L3_h15 = polyline(z=-1.27mm, xy in mm: (-23.9601, -0.96) (-24.1754, -0.7734) (-24.3188, -0.4988) (-24.1754, -0.2266) (-23.9601, -0.04) (-23.5399, -0.04) (-23.3246, -0.2266) (-23.1812, -0.5012) (-23.4189, -0.8821) (-23.822, -1.0005) (-23.9601, -0.96), closed, covered)
  P14_DCP_L3_h16 = polyline(z=-1.27mm, xy in mm: (-22.7754, -0.96) (-22.9908, -0.7734) (-23.1342, -0.4988) (-22.9908, -0.2266) (-22.7754, -0.04) (-22.3553, -0.04) (-22.14, -0.2266) (-21.9966, -0.5012) (-22.2343, -0.8821) (-22.6373, -1.0005) (-22.7754, -0.96), closed, covered)
  P14_DCP_L3_h17 = polyline(z=-1.27mm, xy in mm: (-21.5908, -0.96) (-21.8061, -0.7734) (-21.9496, -0.4988) (-21.8061, -0.2266) (-21.5908, -0.04) (-21.1707, -0.04) (-20.9554, -0.2266) (-20.812, -0.5012) (-21.0496, -0.8821) (-21.4527, -1.0005) (-21.5908, -0.96), closed, covered)
  P14_DCP_L3_h18 = polyline(z=-1.27mm, xy in mm: (-20.4062, -0.96) (-20.6215, -0.7734) (-20.765, -0.4988) (-20.6215, -0.2266) (-20.4062, -0.04) (-19.9861, -0.04) (-19.7708, -0.2266) (-19.6273, -0.5012) (-19.865, -0.8821) (-20.2681, -1.0005) (-20.4062, -0.96), closed, covered)
  P14_DCP_L3_h19 = polyline(z=-1.27mm, xy in mm: (-19.2216, -0.96) (-19.4369, -0.7734) (-19.5804, -0.4988) (-19.4369, -0.2266) (-19.2216, -0.04) (-18.8015, -0.04) (-18.5862, -0.2266) (-18.4427, -0.5012) (-18.6804, -0.8821) (-19.0835, -1.0005) (-19.2216, -0.96), closed, covered)
  P14_DCP_L3_h20 = polyline(z=-1.27mm, xy in mm: (-18.037, -0.96) (-18.2523, -0.7734) (-18.3957, -0.4988) (-18.2523, -0.2266) (-18.037, -0.04) (-17.6169, -0.04) (-17.4015, -0.2266) (-17.2581, -0.5012) (-17.4958, -0.8821) (-17.8989, -1.0005) (-18.037, -0.96), closed, covered)
  P14_DCP_L3_h21 = polyline(z=-1.27mm, xy in mm: (-16.8524, -0.96) (-17.0677, -0.7734) (-17.2111, -0.4988) (-17.0677, -0.2266) (-16.8524, -0.04) (-16.4323, -0.04) (-16.2169, -0.2266) (-16.0735, -0.5012) (-16.3112, -0.8821) (-16.7143, -1.0005) (-16.8524, -0.96), closed, covered)
  P14_DCP_L3_h22 = polyline(z=-1.27mm, xy in mm: (-15.6677, -0.96) (-15.8831, -0.7734) (-16.0265, -0.4988) (-15.8831, -0.2266) (-15.6678, -0.04) (-15.2476, -0.04) (-15.0323, -0.2266) (-14.8889, -0.5012) (-15.1266, -0.8821) (-15.5297, -1.0005) (-15.6677, -0.96), closed, covered)
  P14_DCP_L3_h23 = polyline(z=-1.27mm, xy in mm: (-14.4831, -0.96) (-14.6985, -0.7734) (-14.8419, -0.4988) (-14.6985, -0.2266) (-14.4831, -0.04) (-14.063, -0.04) (-13.8477, -0.2266) (-13.7043, -0.5012) (-13.9419, -0.8821) (-14.345, -1.0005) (-14.4831, -0.96), closed, covered)
  P14_DCP_L3_h24 = polyline(z=-1.27mm, xy in mm: (-13.2985, -0.96) (-13.5138, -0.7734) (-13.6573, -0.4988) (-13.5138, -0.2266) (-13.2985, -0.04) (-12.8784, -0.04) (-12.6631, -0.2266) (-12.5196, -0.5012) (-12.7573, -0.8821) (-13.1604, -1.0005) (-13.2985, -0.96), closed, covered)
  P14_DCP_L3_h25 = polyline(z=-1.27mm, xy in mm: (-12.1139, -0.96) (-12.3292, -0.7734) (-12.4727, -0.4988) (-12.3292, -0.2266) (-12.1139, -0.04) (-11.6938, -0.04) (-11.4785, -0.2266) (-11.335, -0.5012) (-11.5727, -0.8821) (-11.9758, -1.0005) (-12.1139, -0.96), closed, covered)
  P14_DCP_L3_h26 = polyline(z=-1.27mm, xy in mm: (-10.9293, -0.96) (-11.1446, -0.7734) (-11.288, -0.4988) (-11.1446, -0.2266) (-10.9293, -0.04) (-10.5092, -0.04) (-10.2939, -0.2266) (-10.1504, -0.5012) (-10.3881, -0.8821) (-10.7912, -1.0005) (-10.9293, -0.96), closed, covered)
  P14_DCP_L3_h27 = polyline(z=-1.27mm, xy in mm: (-9.7447, -0.96) (-9.96, -0.7734) (-10.1034, -0.4988) (-9.96, -0.2266) (-9.7447, -0.04) (-9.3246, -0.04) (-9.1092, -0.2266) (-8.9658, -0.5012) (-9.2035, -0.8821) (-9.6066, -1.0005) (-9.7447, -0.96), closed, covered)
  P14_DCP_L3_h28 = polyline(z=-1.27mm, xy in mm: (-8.56, -0.96) (-8.7754, -0.7734) (-8.9188, -0.4988) (-8.7754, -0.2266) (-8.5601, -0.04) (-8.1399, -0.04) (-7.8648, -0.3575) (-7.8648, -0.6425) (-8.1399, -0.96) (-8.422, -1.0005) (-8.56, -0.96), closed, covered)
  P14_DCP_L3_h29 = polyline(z=-1.27mm, xy in mm: (-7.3601, -0.96) (-7.6352, -0.6425) (-7.6352, -0.3575) (-7.3601, -0.04) (-6.9399, -0.04) (-6.6648, -0.3575) (-6.6648, -0.6425) (-6.9399, -0.96) (-7.222, -1.0005) (-7.3601, -0.96), closed, covered)
  P14_DCP_L3_h30 = polyline(z=-1.27mm, xy in mm: (-6.1601, -0.96) (-6.4352, -0.6425) (-6.4352, -0.3575) (-6.1601, -0.04) (-5.7399, -0.04) (-5.4648, -0.3575) (-5.4648, -0.6425) (-5.7399, -0.96) (-6.022, -1.0005) (-6.1601, -0.96), closed, covered)
  P14_DCP_L3_h31 = polyline(z=-1.27mm, xy in mm: (-4.9601, -0.96) (-5.2352, -0.6425) (-5.2352, -0.3575) (-4.9601, -0.04) (-4.5399, -0.04) (-4.2648, -0.3575) (-4.2648, -0.6425) (-4.5399, -0.96) (-4.822, -1.0005) (-4.9601, -0.96), closed, covered)
  P14_DCP_L3_h32 = polyline(z=-1.27mm, xy in mm: (-3.7601, -0.96) (-4.0352, -0.6425) (-4.0352, -0.3575) (-3.7601, -0.04) (-3.3399, -0.04) (-3.0648, -0.3575) (-3.0648, -0.6425) (-3.3399, -0.96) (-3.622, -1.0005) (-3.7601, -0.96), closed, covered)
  P14_DCP_L3_h33 = polyline(z=-1.27mm, xy in mm: (-2.56, -0.96) (-2.8352, -0.6425) (-2.8352, -0.3575) (-2.5601, -0.04) (-2.1399, -0.04) (-1.8648, -0.3575) (-1.8648, -0.6425) (-2.1399, -0.96) (-2.422, -1.0005) (-2.56, -0.96), closed, covered)
  P14_DCP_L3_h34 = polyline(z=-1.27mm, xy in mm: (-1.3601, -0.96) (-1.6352, -0.6425) (-1.6352, -0.3575) (-1.3601, -0.04) (-0.9399, -0.04) (-0.6648, -0.3575) (-0.6648, -0.6425) (-0.9399, -0.96) (-1.222, -1.0005) (-1.3601, -0.96), closed, covered)
  P14_DCP_L3_h35 = polyline(z=-1.27mm, xy in mm: (-0.1601, -0.96) (-0.4352, -0.6425) (-0.4352, -0.3575) (-0.1601, -0.04) (0.2601, -0.04) (0.5352, -0.3575) (0.5352, -0.6425) (0.2601, -0.96) (-0.022, -1.0005) (-0.1601, -0.96), closed, covered)
  P14_DCP_L3_h36 = polyline(z=-1.27mm, xy in mm: (1.0399, -0.96) (0.7648, -0.6425) (0.7648, -0.3575) (1.0399, -0.04) (1.4601, -0.04) (1.7352, -0.3575) (1.7352, -0.6425) (1.4601, -0.96) (1.178, -1.0005) (1.0399, -0.96), closed, covered)
  P14_DCP_L3_h37 = polyline(z=-1.27mm, xy in mm: (2.2399, -0.96) (1.9648, -0.6425) (1.9648, -0.3575) (2.2399, -0.04) (2.6601, -0.04) (2.9352, -0.3575) (2.9352, -0.6425) (2.6601, -0.96) (2.378, -1.0005) (2.2399, -0.96), closed, covered)
  P14_DCP_L3_h38 = polyline(z=-1.27mm, xy in mm: (3.4399, -0.96) (3.1648, -0.6425) (3.1648, -0.3575) (3.4399, -0.04) (3.8601, -0.04) (4.1352, -0.3575) (4.1352, -0.6425) (3.8601, -0.96) (3.578, -1.0005) (3.4399, -0.96), closed, covered)
  P14_DCP_L3_h39 = polyline(z=-1.27mm, xy in mm: (4.6399, -0.96) (4.3648, -0.6425) (4.3648, -0.3575) (4.6399, -0.04) (5.0601, -0.04) (5.3352, -0.3575) (5.3352, -0.6425) (5.0601, -0.96) (4.778, -1.0005) (4.6399, -0.96), closed, covered)
  P14_DCP_L3_h40 = polyline(z=-1.27mm, xy in mm: (5.8399, -0.96) (5.5648, -0.6425) (5.5648, -0.3575) (5.8399, -0.04) (6.2601, -0.04) (6.5352, -0.3575) (6.5352, -0.6425) (6.2601, -0.96) (5.978, -1.0005) (5.8399, -0.96), closed, covered)
  P14_DCP_L3_h41 = polyline(z=-1.27mm, xy in mm: (8.1399, -0.96) (7.8648, -0.6425) (7.8648, -0.3575) (8.1399, -0.04) (8.5601, -0.04) (8.7754, -0.2266) (8.9188, -0.5012) (8.6811, -0.8821) (8.278, -1.0005) (8.1399, -0.96), closed, covered)
  P14_DCP_L3_h42 = polyline(z=-1.27mm, xy in mm: (9.3246, -0.96) (9.1092, -0.7734) (8.9658, -0.4988) (9.1092, -0.2266) (9.3246, -0.04) (9.7447, -0.04) (9.96, -0.2266) (10.1034, -0.5012) (9.8657, -0.8821) (9.4626, -1.0005) (9.3246, -0.96), closed, covered)
  P14_DCP_L3_h43 = polyline(z=-1.27mm, xy in mm: (10.5092, -0.96) (10.2939, -0.7734) (10.1504, -0.4988) (10.2939, -0.2266) (10.5092, -0.04) (10.9293, -0.04) (11.1446, -0.2266) (11.288, -0.5012) (11.0504, -0.8821) (10.6473, -1.0005) (10.5092, -0.96), closed, covered)
  P14_DCP_L3_h44 = polyline(z=-1.27mm, xy in mm: (11.6938, -0.96) (11.4785, -0.7734) (11.335, -0.4988) (11.4785, -0.2266) (11.6938, -0.04) (12.1139, -0.04) (12.3292, -0.2266) (12.4727, -0.5012) (12.235, -0.8821) (11.8319, -1.0005) (11.6938, -0.96), closed, covered)
  P14_DCP_L3_h45 = polyline(z=-1.27mm, xy in mm: (12.8784, -0.96) (12.6631, -0.7734) (12.5196, -0.4988) (12.6631, -0.2266) (12.8784, -0.04) (13.2985, -0.04) (13.5138, -0.2266) (13.6573, -0.5012) (13.4196, -0.8821) (13.0165, -1.0005) (12.8784, -0.96), closed, covered)
  P14_DCP_L3_h46 = polyline(z=-1.27mm, xy in mm: (14.063, -0.96) (13.8477, -0.7734) (13.7043, -0.4988) (13.8477, -0.2266) (14.063, -0.04) (14.4831, -0.04) (14.6985, -0.2266) (14.8419, -0.5012) (14.6042, -0.8821) (14.2011, -1.0005) (14.063, -0.96), closed, covered)
  P14_DCP_L3_h47 = polyline(z=-1.27mm, xy in mm: (15.2476, -0.96) (15.0323, -0.7734) (14.8889, -0.4988) (15.0323, -0.2266) (15.2476, -0.04) (15.6677, -0.04) (15.8831, -0.2266) (16.0265, -0.5012) (15.7888, -0.8821) (15.3857, -1.0005) (15.2476, -0.96), closed, covered)
  P14_DCP_L3_h48 = polyline(z=-1.27mm, xy in mm: (16.4323, -0.96) (16.2169, -0.7734) (16.0735, -0.4988) (16.2169, -0.2266) (16.4322, -0.04) (16.8524, -0.04) (17.0677, -0.2266) (17.2111, -0.5012) (16.9734, -0.8821) (16.5703, -1.0005) (16.4323, -0.96), closed, covered)
  P14_DCP_L3_h49 = polyline(z=-1.27mm, xy in mm: (17.6169, -0.96) (17.4015, -0.7734) (17.2581, -0.4988) (17.4015, -0.2266) (17.6169, -0.04) (18.037, -0.04) (18.2523, -0.2266) (18.3957, -0.5012) (18.1581, -0.8821) (17.755, -1.0005) (17.6169, -0.96), closed, covered)
  P14_DCP_L3_h50 = polyline(z=-1.27mm, xy in mm: (18.8015, -0.96) (18.5862, -0.7734) (18.4427, -0.4988) (18.5862, -0.2266) (18.8015, -0.04) (19.2216, -0.04) (19.4369, -0.2266) (19.5804, -0.5012) (19.3427, -0.8821) (18.9396, -1.0005) (18.8015, -0.96), closed, covered)
  P14_DCP_L3_h51 = polyline(z=-1.27mm, xy in mm: (19.9861, -0.96) (19.7708, -0.7734) (19.6273, -0.4988) (19.7708, -0.2266) (19.9861, -0.04) (20.4062, -0.04) (20.6215, -0.2266) (20.765, -0.5012) (20.5273, -0.8821) (20.1242, -1.0005) (19.9861, -0.96), closed, covered)
  P14_DCP_L3_h52 = polyline(z=-1.27mm, xy in mm: (21.1707, -0.96) (20.9554, -0.7734) (20.812, -0.4988) (20.9554, -0.2266) (21.1707, -0.04) (21.5908, -0.04) (21.8061, -0.2266) (21.9496, -0.5012) (21.7119, -0.8821) (21.3088, -1.0005) (21.1707, -0.96), closed, covered)
  P14_DCP_L3_h53 = polyline(z=-1.27mm, xy in mm: (22.3553, -0.96) (22.14, -0.7734) (21.9966, -0.4988) (22.14, -0.2266) (22.3553, -0.04) (22.7754, -0.04) (22.9908, -0.2266) (23.1342, -0.5012) (22.8965, -0.8821) (22.4934, -1.0005) (22.3553, -0.96), closed, covered)
  P14_DCP_L3_h54 = polyline(z=-1.27mm, xy in mm: (23.5399, -0.96) (23.3246, -0.7734) (23.1812, -0.4988) (23.3246, -0.2266) (23.5399, -0.04) (23.9601, -0.04) (24.1754, -0.2266) (24.3188, -0.5012) (24.0811, -0.8821) (23.678, -1.0005) (23.5399, -0.96), closed, covered)
  P14_DCP_L3_h55 = polyline(z=-1.27mm, xy in mm: (24.7246, -0.96) (24.5092, -0.7734) (24.3658, -0.4988) (24.5092, -0.2266) (24.7246, -0.04) (25.1447, -0.04) (25.36, -0.2266) (25.5034, -0.5012) (25.2657, -0.8821) (24.8627, -1.0005) (24.7246, -0.96), closed, covered)
  P14_DCP_L3_h56 = polyline(z=-1.27mm, xy in mm: (25.9092, -0.96) (25.6939, -0.7734) (25.5504, -0.4988) (25.6939, -0.2266) (25.9092, -0.04) (26.3293, -0.04) (26.5446, -0.2266) (26.688, -0.5012) (26.4504, -0.8821) (26.0473, -1.0005) (25.9092, -0.96), closed, covered)
  P14_DCP_L3_h57 = polyline(z=-1.27mm, xy in mm: (27.0938, -0.96) (26.8785, -0.7734) (26.735, -0.4988) (26.8785, -0.2266) (27.0938, -0.04) (27.5139, -0.04) (27.7292, -0.2266) (27.8727, -0.5012) (27.635, -0.8821) (27.2319, -1.0005) (27.0938, -0.96), closed, covered)
  P14_DCP_L3_h58 = polyline(z=-1.27mm, xy in mm: (28.2784, -0.96) (28.0631, -0.7734) (27.9196, -0.4988) (28.0631, -0.2266) (28.2784, -0.04) (28.6985, -0.04) (28.9138, -0.2266) (29.0573, -0.5012) (28.8196, -0.8821) (28.4165, -1.0005) (28.2784, -0.96), closed, covered)
  P14_DCP_L3_h59 = polyline(z=-1.27mm, xy in mm: (29.463, -0.96) (29.2477, -0.7734) (29.1043, -0.4988) (29.2477, -0.2266) (29.463, -0.04) (29.8831, -0.04) (30.0985, -0.2266) (30.2419, -0.5012) (30.0042, -0.8821) (29.6011, -1.0005) (29.463, -0.96), closed, covered)
  P14_DCP_L3_h60 = polyline(z=-1.27mm, xy in mm: (30.6476, -0.96) (30.4323, -0.7734) (30.2889, -0.4988) (30.4323, -0.2266) (30.6476, -0.04) (31.0677, -0.04) (31.2831, -0.2266) (31.4265, -0.5012) (31.1888, -0.8821) (30.7857, -1.0005) (30.6476, -0.96), closed, covered)
  P14_DCP_L3_h61 = polyline(z=-1.27mm, xy in mm: (31.8323, -0.96) (31.6169, -0.7734) (31.4735, -0.4988) (31.6169, -0.2266) (31.8322, -0.04) (32.2524, -0.04) (32.4677, -0.2266) (32.6111, -0.5012) (32.3734, -0.8821) (31.9703, -1.0005) (31.8323, -0.96), closed, covered)
  P14_DCP_L3_h62 = polyline(z=-1.27mm, xy in mm: (33.0169, -0.96) (32.8015, -0.7734) (32.6581, -0.4988) (32.8015, -0.2266) (33.0169, -0.04) (33.437, -0.04) (33.6523, -0.2266) (33.7957, -0.5012) (33.5581, -0.8821) (33.155, -1.0005) (33.0169, -0.96), closed, covered)
  P14_DCP_L3_h63 = polyline(z=-1.27mm, xy in mm: (34.2015, -0.96) (33.9862, -0.7734) (33.8427, -0.4988) (33.9862, -0.2266) (34.2015, -0.04) (34.6216, -0.04) (34.8369, -0.2266) (34.9804, -0.5012) (34.7427, -0.8821) (34.3396, -1.0005) (34.2015, -0.96), closed, covered)
  P14_DCP_L3_h64 = polyline(z=-1.27mm, xy in mm: (35.3861, -0.96) (35.1708, -0.7734) (35.0273, -0.4988) (35.1708, -0.2266) (35.3861, -0.04) (35.8062, -0.04) (36.0215, -0.2266) (36.165, -0.5012) (35.9273, -0.8821) (35.5242, -1.0005) (35.3861, -0.96), closed, covered)
  P14_DCP_L3_h65 = polyline(z=-1.27mm, xy in mm: (36.5707, -0.96) (36.3554, -0.7734) (36.212, -0.4988) (36.3554, -0.2266) (36.5707, -0.04) (36.9908, -0.04) (37.2061, -0.2266) (37.3496, -0.5012) (37.1119, -0.8821) (36.7088, -1.0005) (36.5707, -0.96), closed, covered)
  P14_DCP_L3_h66 = polyline(z=-1.27mm, xy in mm: (37.7553, -0.96) (37.54, -0.7734) (37.3966, -0.4988) (37.54, -0.2266) (37.7553, -0.04) (38.1754, -0.04) (38.3908, -0.2266) (38.5342, -0.5012) (38.2965, -0.8821) (37.8934, -1.0005) (37.7553, -0.96), closed, covered)
  P14_DCP_L3_h67 = polyline(z=-1.27mm, xy in mm: (-38.1754, -11.21) (-38.3908, -11.0234) (-38.5342, -10.7488) (-38.3908, -10.4766) (-38.1754, -10.29) (-37.7553, -10.29) (-37.54, -10.4766) (-37.3966, -10.7512) (-37.6343, -11.1321) (-38.0373, -11.2505) (-38.1754, -11.21), closed, covered)
  P14_DCP_L3_h68 = polyline(z=-1.27mm, xy in mm: (-36.9908, -11.21) (-37.2061, -11.0234) (-37.3496, -10.7488) (-37.2061, -10.4766) (-36.9908, -10.29) (-36.5707, -10.29) (-36.3554, -10.4766) (-36.212, -10.7512) (-36.4496, -11.1321) (-36.8527, -11.2505) (-36.9908, -11.21), closed, covered)
  P14_DCP_L3_h69 = polyline(z=-1.27mm, xy in mm: (-35.8062, -11.21) (-36.0215, -11.0234) (-36.165, -10.7488) (-36.0215, -10.4766) (-35.8062, -10.29) (-35.3861, -10.29) (-35.1708, -10.4766) (-35.0273, -10.7512) (-35.265, -11.1321) (-35.6681, -11.2505) (-35.8062, -11.21), closed, covered)
  P14_DCP_L3_h70 = polyline(z=-1.27mm, xy in mm: (-34.6216, -11.21) (-34.8369, -11.0234) (-34.9804, -10.7488) (-34.8369, -10.4766) (-34.6216, -10.29) (-34.2015, -10.29) (-33.9862, -10.4766) (-33.8427, -10.7512) (-34.0804, -11.1321) (-34.4835, -11.2505) (-34.6216, -11.21), closed, covered)
  P14_DCP_L3_h71 = polyline(z=-1.27mm, xy in mm: (-33.437, -11.21) (-33.6523, -11.0234) (-33.7957, -10.7488) (-33.6523, -10.4766) (-33.437, -10.29) (-33.0169, -10.29) (-32.8015, -10.4766) (-32.6581, -10.7512) (-32.8958, -11.1321) (-33.2989, -11.2505) (-33.437, -11.21), closed, covered)
  P14_DCP_L3_h72 = polyline(z=-1.27mm, xy in mm: (-32.2524, -11.21) (-32.4677, -11.0234) (-32.6111, -10.7488) (-32.4677, -10.4766) (-32.2524, -10.29) (-31.8323, -10.29) (-31.6169, -10.4766) (-31.4735, -10.7512) (-31.7112, -11.1321) (-32.1143, -11.2505) (-32.2524, -11.21), closed, covered)
  P14_DCP_L3_h73 = polyline(z=-1.27mm, xy in mm: (-31.0677, -11.21) (-31.2831, -11.0234) (-31.4265, -10.7488) (-31.2831, -10.4766) (-31.0678, -10.29) (-30.6476, -10.29) (-30.4323, -10.4766) (-30.2889, -10.7512) (-30.5266, -11.1321) (-30.9297, -11.2505) (-31.0677, -11.21), closed, covered)
  P14_DCP_L3_h74 = polyline(z=-1.27mm, xy in mm: (-29.8831, -11.21) (-30.0985, -11.0234) (-30.2419, -10.7488) (-30.0985, -10.4766) (-29.8831, -10.29) (-29.463, -10.29) (-29.2477, -10.4766) (-29.1043, -10.7512) (-29.3419, -11.1321) (-29.745, -11.2505) (-29.8831, -11.21), closed, covered)
  P14_DCP_L3_h75 = polyline(z=-1.27mm, xy in mm: (-28.6985, -11.21) (-28.9138, -11.0234) (-29.0573, -10.7488) (-28.9138, -10.4766) (-28.6985, -10.29) (-28.2784, -10.29) (-28.0631, -10.4766) (-27.9196, -10.7512) (-28.1573, -11.1321) (-28.5604, -11.2505) (-28.6985, -11.21), closed, covered)
  P14_DCP_L3_h76 = polyline(z=-1.27mm, xy in mm: (-27.5139, -11.21) (-27.7292, -11.0234) (-27.8727, -10.7488) (-27.7292, -10.4766) (-27.5139, -10.29) (-27.0938, -10.29) (-26.8785, -10.4766) (-26.735, -10.7512) (-26.9727, -11.1321) (-27.3758, -11.2505) (-27.5139, -11.21), closed, covered)
  P14_DCP_L3_h77 = polyline(z=-1.27mm, xy in mm: (-26.3293, -11.21) (-26.5446, -11.0234) (-26.688, -10.7488) (-26.5446, -10.4766) (-26.3293, -10.29) (-25.9092, -10.29) (-25.6939, -10.4766) (-25.5504, -10.7512) (-25.7881, -11.1321) (-26.1912, -11.2505) (-26.3293, -11.21), closed, covered)
  P14_DCP_L3_h78 = polyline(z=-1.27mm, xy in mm: (-25.1447, -11.21) (-25.36, -11.0234) (-25.5034, -10.7488) (-25.36, -10.4766) (-25.1447, -10.29) (-24.7246, -10.29) (-24.5092, -10.4766) (-24.3658, -10.7512) (-24.6035, -11.1321) (-25.0066, -11.2505) (-25.1447, -11.21), closed, covered)
  P14_DCP_L3_h79 = polyline(z=-1.27mm, xy in mm: (-23.9601, -11.21) (-24.1754, -11.0234) (-24.3188, -10.7488) (-24.1754, -10.4766) (-23.9601, -10.29) (-23.5399, -10.29) (-23.3246, -10.4766) (-23.1812, -10.7512) (-23.4189, -11.1321) (-23.822, -11.2505) (-23.9601, -11.21), closed, covered)
  P14_DCP_L3_h80 = polyline(z=-1.27mm, xy in mm: (-22.7754, -11.21) (-22.9908, -11.0234) (-23.1342, -10.7488) (-22.9908, -10.4766) (-22.7754, -10.29) (-22.3553, -10.29) (-22.14, -10.4766) (-21.9966, -10.7512) (-22.2343, -11.1321) (-22.6373, -11.2505) (-22.7754, -11.21), closed, covered)
  P14_DCP_L3_h81 = polyline(z=-1.27mm, xy in mm: (-21.5908, -11.21) (-21.8061, -11.0234) (-21.9496, -10.7488) (-21.8061, -10.4766) (-21.5908, -10.29) (-21.1707, -10.29) (-20.9554, -10.4766) (-20.812, -10.7512) (-21.0496, -11.1321) (-21.4527, -11.2505) (-21.5908, -11.21), closed, covered)
  P14_DCP_L3_h82 = polyline(z=-1.27mm, xy in mm: (-20.4062, -11.21) (-20.6215, -11.0234) (-20.765, -10.7488) (-20.6215, -10.4766) (-20.4062, -10.29) (-19.9861, -10.29) (-19.7708, -10.4766) (-19.6273, -10.7512) (-19.865, -11.1321) (-20.2681, -11.2505) (-20.4062, -11.21), closed, covered)
  P14_DCP_L3_h83 = polyline(z=-1.27mm, xy in mm: (-19.2216, -11.21) (-19.4369, -11.0234) (-19.5804, -10.7488) (-19.4369, -10.4766) (-19.2216, -10.29) (-18.8015, -10.29) (-18.5862, -10.4766) (-18.4427, -10.7512) (-18.6804, -11.1321) (-19.0835, -11.2505) (-19.2216, -11.21), closed, covered)
  P14_DCP_L3_h84 = polyline(z=-1.27mm, xy in mm: (-18.037, -11.21) (-18.2523, -11.0234) (-18.3957, -10.7488) (-18.2523, -10.4766) (-18.037, -10.29) (-17.6169, -10.29) (-17.4015, -10.4766) (-17.2581, -10.7512) (-17.4958, -11.1321) (-17.8989, -11.2505) (-18.037, -11.21), closed, covered)
  P14_DCP_L3_h85 = polyline(z=-1.27mm, xy in mm: (-16.8524, -11.21) (-17.0677, -11.0234) (-17.2111, -10.7488) (-17.0677, -10.4766) (-16.8524, -10.29) (-16.4323, -10.29) (-16.2169, -10.4766) (-16.0735, -10.7512) (-16.3112, -11.1321) (-16.7143, -11.2505) (-16.8524, -11.21), closed, covered)
  P14_DCP_L3_h86 = polyline(z=-1.27mm, xy in mm: (-15.6677, -11.21) (-15.8831, -11.0234) (-16.0265, -10.7488) (-15.8831, -10.4766) (-15.6678, -10.29) (-15.2476, -10.29) (-15.0323, -10.4766) (-14.8889, -10.7512) (-15.1266, -11.1321) (-15.5297, -11.2505) (-15.6677, -11.21), closed, covered)
  P14_DCP_L3_h87 = polyline(z=-1.27mm, xy in mm: (-14.4831, -11.21) (-14.6985, -11.0234) (-14.8419, -10.7488) (-14.6985, -10.4766) (-14.4831, -10.29) (-14.063, -10.29) (-13.8477, -10.4766) (-13.7043, -10.7512) (-13.9419, -11.1321) (-14.345, -11.2505) (-14.4831, -11.21), closed, covered)
  P14_DCP_L3_h88 = polyline(z=-1.27mm, xy in mm: (-13.2985, -11.21) (-13.5138, -11.0234) (-13.6573, -10.7488) (-13.5138, -10.4766) (-13.2985, -10.29) (-12.8784, -10.29) (-12.6631, -10.4766) (-12.5196, -10.7512) (-12.7573, -11.1321) (-13.1604, -11.2505) (-13.2985, -11.21), closed, covered)
  P14_DCP_L3_h89 = polyline(z=-1.27mm, xy in mm: (-12.1139, -11.21) (-12.3292, -11.0234) (-12.4727, -10.7488) (-12.3292, -10.4766) (-12.1139, -10.29) (-11.6938, -10.29) (-11.4785, -10.4766) (-11.335, -10.7512) (-11.5727, -11.1321) (-11.9758, -11.2505) (-12.1139, -11.21), closed, covered)
  P14_DCP_L3_h90 = polyline(z=-1.27mm, xy in mm: (-10.9293, -11.21) (-11.1446, -11.0234) (-11.288, -10.7488) (-11.1446, -10.4766) (-10.9293, -10.29) (-10.5092, -10.29) (-10.2939, -10.4766) (-10.1504, -10.7512) (-10.3881, -11.1321) (-10.7912, -11.2505) (-10.9293, -11.21), closed, covered)
  P14_DCP_L3_h91 = polyline(z=-1.27mm, xy in mm: (-9.7447, -11.21) (-9.96, -11.0234) (-10.1034, -10.7488) (-9.96, -10.4766) (-9.7447, -10.29) (-9.3246, -10.29) (-9.1092, -10.4766) (-8.9658, -10.7512) (-9.2035, -11.1321) (-9.6066, -11.2505) (-9.7447, -11.21), closed, covered)
  P14_DCP_L3_h92 = polyline(z=-1.27mm, xy in mm: (-8.56, -11.21) (-8.7754, -11.0234) (-8.9188, -10.7488) (-8.7754, -10.4766) (-8.5601, -10.29) (-8.1399, -10.29) (-7.8648, -10.6075) (-7.8648, -10.8925) (-8.1399, -11.21) (-8.422, -11.2505) (-8.56, -11.21), closed, covered)
  P14_DCP_L3_h93 = polyline(z=-1.27mm, xy in mm: (-7.3601, -11.21) (-7.6352, -10.8925) (-7.6352, -10.6075) (-7.3601, -10.29) (-6.9399, -10.29) (-6.6648, -10.6075) (-6.6648, -10.8925) (-6.9399, -11.21) (-7.222, -11.2505) (-7.3601, -11.21), closed, covered)
  P14_DCP_L3_h94 = polyline(z=-1.27mm, xy in mm: (-6.1601, -11.21) (-6.4352, -10.8925) (-6.4352, -10.6075) (-6.1601, -10.29) (-5.7399, -10.29) (-5.4648, -10.6075) (-5.4648, -10.8925) (-5.7399, -11.21) (-6.022, -11.2505) (-6.1601, -11.21), closed, covered)
  P14_DCP_L3_h95 = polyline(z=-1.27mm, xy in mm: (-4.9601, -11.21) (-5.2352, -10.8925) (-5.2352, -10.6075) (-4.9601, -10.29) (-4.5399, -10.29) (-4.2648, -10.6075) (-4.2648, -10.8925) (-4.5399, -11.21) (-4.822, -11.2505) (-4.9601, -11.21), closed, covered)
  P14_DCP_L3_h96 = polyline(z=-1.27mm, xy in mm: (-3.7601, -11.21) (-4.0352, -10.8925) (-4.0352, -10.6075) (-3.7601, -10.29) (-3.3399, -10.29) (-3.0648, -10.6075) (-3.0648, -10.8925) (-3.3399, -11.21) (-3.622, -11.2505) (-3.7601, -11.21), closed, covered)
  P14_DCP_L3_h97 = polyline(z=-1.27mm, xy in mm: (-2.56, -11.21) (-2.8352, -10.8925) (-2.8352, -10.6075) (-2.5601, -10.29) (-2.1399, -10.29) (-1.8648, -10.6075) (-1.8648, -10.8925) (-2.1399, -11.21) (-2.422, -11.2505) (-2.56, -11.21), closed, covered)
  P14_DCP_L3_h98 = polyline(z=-1.27mm, xy in mm: (-1.3601, -11.21) (-1.6352, -10.8925) (-1.6352, -10.6075) (-1.3601, -10.29) (-0.9399, -10.29) (-0.6648, -10.6075) (-0.6648, -10.8925) (-0.9399, -11.21) (-1.222, -11.2505) (-1.3601, -11.21), closed, covered)
  P14_DCP_L3_h99 = polyline(z=-1.27mm, xy in mm: (-0.1601, -11.21) (-0.4352, -10.8925) (-0.4352, -10.6075) (-0.1601, -10.29) (0.2601, -10.29) (0.5352, -10.6075) (0.5352, -10.8925) (0.2601, -11.21) (-0.022, -11.2505) (-0.1601, -11.21), closed, covered)
  P14_DCP_L3_h100 = polyline(z=-1.27mm, xy in mm: (1.0399, -11.21) (0.7648, -10.8925) (0.7648, -10.6075) (1.0399, -10.29) (1.4601, -10.29) (1.7352, -10.6075) (1.7352, -10.8925) (1.4601, -11.21) (1.178, -11.2505) (1.0399, -11.21), closed, covered)
  P14_DCP_L3_h101 = polyline(z=-1.27mm, xy in mm: (2.2399, -11.21) (1.9648, -10.8925) (1.9648, -10.6075) (2.2399, -10.29) (2.6601, -10.29) (2.9352, -10.6075) (2.9352, -10.8925) (2.6601, -11.21) (2.378, -11.2505) (2.2399, -11.21), closed, covered)
  P14_DCP_L3_h102 = polyline(z=-1.27mm, xy in mm: (3.4399, -11.21) (3.1648, -10.8925) (3.1648, -10.6075) (3.4399, -10.29) (3.8601, -10.29) (4.1352, -10.6075) (4.1352, -10.8925) (3.8601, -11.21) (3.578, -11.2505) (3.4399, -11.21), closed, covered)
  P14_DCP_L3_h103 = polyline(z=-1.27mm, xy in mm: (4.6399, -11.21) (4.3648, -10.8925) (4.3648, -10.6075) (4.6399, -10.29) (5.0601, -10.29) (5.3352, -10.6075) (5.3352, -10.8925) (5.0601, -11.21) (4.778, -11.2505) (4.6399, -11.21), closed, covered)
  P14_DCP_L3_h104 = polyline(z=-1.27mm, xy in mm: (5.8399, -11.21) (5.5648, -10.8925) (5.5648, -10.6075) (5.8399, -10.29) (6.2601, -10.29) (6.5352, -10.6075) (6.5352, -10.8925) (6.2601, -11.21) (5.978, -11.2505) (5.8399, -11.21), closed, covered)
  P14_DCP_L3_h105 = polyline(z=-1.27mm, xy in mm: (8.1399, -11.21) (7.8648, -10.8925) (7.8648, -10.6075) (8.1399, -10.29) (8.5601, -10.29) (8.7754, -10.4766) (8.9188, -10.7512) (8.6811, -11.1321) (8.278, -11.2505) (8.1399, -11.21), closed, covered)
  P14_DCP_L3_h106 = polyline(z=-1.27mm, xy in mm: (9.3246, -11.21) (9.1092, -11.0234) (8.9658, -10.7488) (9.1092, -10.4766) (9.3246, -10.29) (9.7447, -10.29) (9.96, -10.4766) (10.1034, -10.7512) (9.8657, -11.1321) (9.4626, -11.2505) (9.3246, -11.21), closed, covered)
  P14_DCP_L3_h107 = polyline(z=-1.27mm, xy in mm: (10.5092, -11.21) (10.2939, -11.0234) (10.1504, -10.7488) (10.2939, -10.4766) (10.5092, -10.29) (10.9293, -10.29) (11.1446, -10.4766) (11.288, -10.7512) (11.0504, -11.1321) (10.6473, -11.2505) (10.5092, -11.21), closed, covered)
  P14_DCP_L3_h108 = polyline(z=-1.27mm, xy in mm: (11.6938, -11.21) (11.4785, -11.0234) (11.335, -10.7488) (11.4785, -10.4766) (11.6938, -10.29) (12.1139, -10.29) (12.3292, -10.4766) (12.4727, -10.7512) (12.235, -11.1321) (11.8319, -11.2505) (11.6938, -11.21), closed, covered)
  P14_DCP_L3_h109 = polyline(z=-1.27mm, xy in mm: (12.8784, -11.21) (12.6631, -11.0234) (12.5196, -10.7488) (12.6631, -10.4766) (12.8784, -10.29) (13.2985, -10.29) (13.5138, -10.4766) (13.6573, -10.7512) (13.4196, -11.1321) (13.0165, -11.2505) (12.8784, -11.21), closed, covered)
  P14_DCP_L3_h110 = polyline(z=-1.27mm, xy in mm: (14.063, -11.21) (13.8477, -11.0234) (13.7043, -10.7488) (13.8477, -10.4766) (14.063, -10.29) (14.4831, -10.29) (14.6985, -10.4766) (14.8419, -10.7512) (14.6042, -11.1321) (14.2011, -11.2505) (14.063, -11.21), closed, covered)
  P14_DCP_L3_h111 = polyline(z=-1.27mm, xy in mm: (15.2476, -11.21) (15.0323, -11.0234) (14.8889, -10.7488) (15.0323, -10.4766) (15.2476, -10.29) (15.6677, -10.29) (15.8831, -10.4766) (16.0265, -10.7512) (15.7888, -11.1321) (15.3857, -11.2505) (15.2476, -11.21), closed, covered)
  P14_DCP_L3_h112 = polyline(z=-1.27mm, xy in mm: (16.4323, -11.21) (16.2169, -11.0234) (16.0735, -10.7488) (16.2169, -10.4766) (16.4322, -10.29) (16.8524, -10.29) (17.0677, -10.4766) (17.2111, -10.7512) (16.9734, -11.1321) (16.5703, -11.2505) (16.4323, -11.21), closed, covered)
  P14_DCP_L3_h113 = polyline(z=-1.27mm, xy in mm: (17.6169, -11.21) (17.4015, -11.0234) (17.2581, -10.7488) (17.4015, -10.4766) (17.6169, -10.29) (18.037, -10.29) (18.2523, -10.4766) (18.3957, -10.7512) (18.1581, -11.1321) (17.755, -11.2505) (17.6169, -11.21), closed, covered)
  P14_DCP_L3_h114 = polyline(z=-1.27mm, xy in mm: (18.8015, -11.21) (18.5862, -11.0234) (18.4427, -10.7488) (18.5862, -10.4766) (18.8015, -10.29) (19.2216, -10.29) (19.4369, -10.4766) (19.5804, -10.7512) (19.3427, -11.1321) (18.9396, -11.2505) (18.8015, -11.21), closed, covered)
  P14_DCP_L3_h115 = polyline(z=-1.27mm, xy in mm: (19.9861, -11.21) (19.7708, -11.0234) (19.6273, -10.7488) (19.7708, -10.4766) (19.9861, -10.29) (20.4062, -10.29) (20.6215, -10.4766) (20.765, -10.7512) (20.5273, -11.1321) (20.1242, -11.2505) (19.9861, -11.21), closed, covered)
  P14_DCP_L3_h116 = polyline(z=-1.27mm, xy in mm: (21.1707, -11.21) (20.9554, -11.0234) (20.812, -10.7488) (20.9554, -10.4766) (21.1707, -10.29) (21.5908, -10.29) (21.8061, -10.4766) (21.9496, -10.7512) (21.7119, -11.1321) (21.3088, -11.2505) (21.1707, -11.21), closed, covered)
  P14_DCP_L3_h117 = polyline(z=-1.27mm, xy in mm: (22.3553, -11.21) (22.14, -11.0234) (21.9966, -10.7488) (22.14, -10.4766) (22.3553, -10.29) (22.7754, -10.29) (22.9908, -10.4766) (23.1342, -10.7512) (22.8965, -11.1321) (22.4934, -11.2505) (22.3553, -11.21), closed, covered)
  P14_DCP_L3_h118 = polyline(z=-1.27mm, xy in mm: (23.5399, -11.21) (23.3246, -11.0234) (23.1812, -10.7488) (23.3246, -10.4766) (23.5399, -10.29) (23.9601, -10.29) (24.1754, -10.4766) (24.3188, -10.7512) (24.0811, -11.1321) (23.678, -11.2505) (23.5399, -11.21), closed, covered)
  P14_DCP_L3_h119 = polyline(z=-1.27mm, xy in mm: (24.7246, -11.21) (24.5092, -11.0234) (24.3658, -10.7488) (24.5092, -10.4766) (24.7246, -10.29) (25.1447, -10.29) (25.36, -10.4766) (25.5034, -10.7512) (25.2657, -11.1321) (24.8627, -11.2505) (24.7246, -11.21), closed, covered)
  P14_DCP_L3_h120 = polyline(z=-1.27mm, xy in mm: (25.9092, -11.21) (25.6939, -11.0234) (25.5504, -10.7488) (25.6939, -10.4766) (25.9092, -10.29) (26.3293, -10.29) (26.5446, -10.4766) (26.688, -10.7512) (26.4504, -11.1321) (26.0473, -11.2505) (25.9092, -11.21), closed, covered)
  P14_DCP_L3_h121 = polyline(z=-1.27mm, xy in mm: (27.0938, -11.21) (26.8785, -11.0234) (26.735, -10.7488) (26.8785, -10.4766) (27.0938, -10.29) (27.5139, -10.29) (27.7292, -10.4766) (27.8727, -10.7512) (27.635, -11.1321) (27.2319, -11.2505) (27.0938, -11.21), closed, covered)
  P14_DCP_L3_h122 = polyline(z=-1.27mm, xy in mm: (28.2784, -11.21) (28.0631, -11.0234) (27.9196, -10.7488) (28.0631, -10.4766) (28.2784, -10.29) (28.6985, -10.29) (28.9138, -10.4766) (29.0573, -10.7512) (28.8196, -11.1321) (28.4165, -11.2505) (28.2784, -11.21), closed, covered)
  P14_DCP_L3_h123 = polyline(z=-1.27mm, xy in mm: (29.463, -11.21) (29.2477, -11.0234) (29.1043, -10.7488) (29.2477, -10.4766) (29.463, -10.29) (29.8831, -10.29) (30.0985, -10.4766) (30.2419, -10.7512) (30.0042, -11.1321) (29.6011, -11.2505) (29.463, -11.21), closed, covered)
  P14_DCP_L3_h124 = polyline(z=-1.27mm, xy in mm: (30.6476, -11.21) (30.4323, -11.0234) (30.2889, -10.7488) (30.4323, -10.4766) (30.6476, -10.29) (31.0677, -10.29) (31.2831, -10.4766) (31.4265, -10.7512) (31.1888, -11.1321) (30.7857, -11.2505) (30.6476, -11.21), closed, covered)
  P14_DCP_L3_h125 = polyline(z=-1.27mm, xy in mm: (31.8323, -11.21) (31.6169, -11.0234) (31.4735, -10.7488) (31.6169, -10.4766) (31.8322, -10.29) (32.2524, -10.29) (32.4677, -10.4766) (32.6111, -10.7512) (32.3734, -11.1321) (31.9703, -11.2505) (31.8323, -11.21), closed, covered)
  P14_DCP_L3_h126 = polyline(z=-1.27mm, xy in mm: (33.0169, -11.21) (32.8015, -11.0234) (32.6581, -10.7488) (32.8015, -10.4766) (33.0169, -10.29) (33.437, -10.29) (33.6523, -10.4766) (33.7957, -10.7512) (33.5581, -11.1321) (33.155, -11.2505) (33.0169, -11.21), closed, covered)
  P14_DCP_L3_h127 = polyline(z=-1.27mm, xy in mm: (34.2015, -11.21) (33.9862, -11.0234) (33.8427, -10.7488) (33.9862, -10.4766) (34.2015, -10.29) (34.6216, -10.29) (34.8369, -10.4766) (34.9804, -10.7512) (34.7427, -11.1321) (34.3396, -11.2505) (34.2015, -11.21), closed, covered)
  P14_DCP_L3_h128 = polyline(z=-1.27mm, xy in mm: (35.3861, -11.21) (35.1708, -11.0234) (35.0273, -10.7488) (35.1708, -10.4766) (35.3861, -10.29) (35.8062, -10.29) (36.0215, -10.4766) (36.165, -10.7512) (35.9273, -11.1321) (35.5242, -11.2505) (35.3861, -11.21), closed, covered)
  P14_DCP_L3_h129 = polyline(z=-1.27mm, xy in mm: (36.5707, -11.21) (36.3554, -11.0234) (36.212, -10.7488) (36.3554, -10.4766) (36.5707, -10.29) (36.9908, -10.29) (37.2061, -10.4766) (37.3496, -10.7512) (37.1119, -11.1321) (36.7088, -11.2505) (36.5707, -11.21), closed, covered)
  P14_DCP_L3_h130 = polyline(z=-1.27mm, xy in mm: (37.7553, -11.21) (37.54, -11.0234) (37.3966, -10.7488) (37.54, -10.4766) (37.7553, -10.29) (38.1754, -10.29) (38.3908, -10.4766) (38.5342, -10.7512) (38.2965, -11.1321) (37.8934, -11.2505) (37.7553, -11.21), closed, covered)
  P14_DCP_L3_h131 = polyline(z=-1.27mm, xy in mm: (2.6632, -17.6253) (2.1622, -17.4287) (1.5732, -16.8821) (1.2796, -16.1341) (1.2796, -15.5959) (1.5732, -14.8479) (2.1622, -14.3013) (2.6632, -14.1047) (3.4668, -14.1047) (3.9678, -14.3013) (4.5568, -14.8479) (4.8504, -15.5959) (4.8504, -16.1341) (4.5568, -16.8821) (4.1907, -17.2766) (3.4668, -17.6253) (2.9301, -17.6655) (2.6632, -17.6253), closed, covered)
  P14_DCP_L3_h132 = polyline(z=-1.27mm, xy in mm: (8.5332, -17.6253) (8.0322, -17.4287) (7.4432, -16.8821) (7.1496, -16.1341) (7.1496, -15.5959) (7.4432, -14.8479) (8.0322, -14.3013) (8.5332, -14.1047) (9.3368, -14.1047) (9.8378, -14.3013) (10.4268, -14.8479) (10.7204, -15.5959) (10.7204, -16.1341) (10.4268, -16.8821) (10.0607, -17.2766) (9.3368, -17.6253) (8.8001, -17.6655) (8.5332, -17.6253), closed, covered)
  P14_DCP_L3.subtract(P14_DCP_L3_h0..P14_DCP_L3_h132)
  P14_DCP_L3.sweep_along_vector((0mm, 0mm, 0.07mm))
  P15_DCP_L4 = polyline(z=-1.44mm, xy in mm: (-28.4908, 1.4689) (-28.45, 3.201) (-28.5184, 3.2952) (-37.951, 3.3) (-38.0452, 3.2316) (-38.05, 1.549) (-37.9816, 1.4548) (-28.549, 1.45) (-28.4908, 1.4689), closed, covered)
  P15_DCP_L4.sweep_along_vector((0mm, 0mm, 0.07mm))
  P16_DCP_L4 = polyline(z=-1.44mm, xy in mm: (-11.4759, 1.4689) (-11.44, 1.5796) (-11.5755, 1.8657) (-11.5755, 2.5243) (-11.4138, 2.9018) (-11.5077, 2.9695) (-12.1597, 2.9724) (-12.5805, 3.3) (-13.1745, 3.3) (-13.4657, 3.1495) (-13.8632, 3.1559) (-14.1055, 3.3) (-14.4857, 3.1495) (-14.8832, 3.1559) (-15.1255, 3.3) (-18.1152, 3.3) (-18.35, 3.2392) (-18.951, 3.3) (-19.0452, 3.2316) (-19.05, 1.549) (-18.9816, 1.4548) (-11.5341, 1.45) (-11.4759, 1.4689), closed, covered)
  P16_DCP_L4.sweep_along_vector((0mm, 0mm, 0.07mm))
  P17_DCP_L4 = polyline(z=-1.44mm, xy in mm: (19.0092, 1.4689) (19.05, 3.201) (18.9816, 3.2952) (9.549, 3.3) (9.4548, 3.2316) (9.45, 1.549) (9.5184, 1.4548) (18.951, 1.45) (19.0092, 1.4689), closed, covered)
  P17_DCP_L4.sweep_along_vector((0mm, 0mm, 0.07mm))
  P18_DCP_L4 = polyline(z=-1.44mm, xy in mm: (36.0241, 1.4689) (36.06, 1.5796) (35.9245, 1.8657) (35.9245, 2.5243) (36.0862, 2.9018) (35.9923, 2.9695) (35.3403, 2.9724) (34.9195, 3.3) (34.3255, 3.3) (34.0343, 3.1495) (33.6368, 3.1559) (33.3945, 3.3) (33.0143, 3.1495) (32.6168, 3.1559) (32.3745, 3.3) (29.3848, 3.3) (29.15, 3.2392) (28.549, 3.3) (28.4548, 3.2316) (28.45, 1.549) (28.5184, 1.4548) (35.9659, 1.45) (36.0241, 1.4689), closed, covered)
  P18_DCP_L4.sweep_along_vector((0mm, 0mm, 0.07mm))
  V0_DCP = cylinder(axis=Z, base_centre=(17.8269mm, -12.65mm, -1.44mm), radius=0.15mm, height=1.68mm)
  V1_DCP = cylinder(axis=Z, base_centre=(29.6731mm, -5.5mm, -1.44mm), radius=0.15mm, height=1.68mm)
  V2_DCP = cylinder(axis=Z, base_centre=(-12.9mm, 2.5mm, -1.44mm), radius=0.15mm, height=1.68mm)
  V3_DCP = cylinder(axis=Z, base_centre=(21.3808mm, -12.65mm, -1.44mm), radius=0.15mm, height=1.68mm)
  V4_DCP = cylinder(axis=Z, base_centre=(17.4mm, 2.5mm, -1.44mm), radius=0.15mm, height=1.68mm)
  V5_DCP = cylinder(axis=Z, base_centre=(30.8577mm, -5.5mm, -1.44mm), radius=0.15mm, height=1.68mm)
  V6_DCP = cylinder(axis=Z, base_centre=(0.05mm, -12.65mm, -1.44mm), radius=0.15mm, height=1.68mm)
  V7_DCP = cylinder(axis=Z, base_centre=(-8.35mm, -5.5mm, -1.44mm), radius=0.15mm, height=1.68mm)
  V8_DCP = cylinder(axis=Z, base_centre=(29.6731mm, -12.65mm, -1.44mm), radius=0.15mm, height=1.68mm)
  V9_DCP = cylinder(axis=Z, base_centre=(-10.7192mm, -5.5mm, -1.44mm), radius=0.15mm, height=1.68mm)
  V10_DCP = cylinder(axis=Z, base_centre=(-19.0115mm, -12.65mm, -1.44mm), radius=0.15mm, height=1.68mm)
  V11_DCP = cylinder(axis=Z, base_centre=(-11.9038mm, -5.5mm, -1.44mm), radius=0.15mm, height=1.68mm)
  V12_DCP = cylinder(axis=Z, base_centre=(-9.5346mm, -5.5mm, -1.44mm), radius=0.15mm, height=1.68mm)
  V13_DCP = cylinder(axis=Z, base_centre=(20.1962mm, -5.5mm, -1.44mm), radius=0.15mm, height=1.68mm)
  V14_DCP = cylinder(axis=Z, base_centre=(27.3038mm, -5.5mm, -1.44mm), radius=0.15mm, height=1.68mm)
  V15_DCP = cylinder(axis=Z, base_centre=(34.4115mm, -5.5mm, -1.44mm), radius=0.15mm, height=1.68mm)
  V16_DCP = cylinder(axis=Z, base_centre=(-8.35mm, -12.65mm, -1.44mm), radius=0.15mm, height=1.68mm)
  V17_DCP = cylinder(axis=Z, base_centre=(34.6mm, 2.5mm, -1.44mm), radius=0.15mm, height=1.68mm)
  V18_DCP = cylinder(axis=Z, base_centre=(-28.4885mm, -12.65mm, -1.44mm), radius=0.15mm, height=1.68mm)
  V19_DCP = cylinder(axis=Z, base_centre=(24.9346mm, -12.65mm, -1.44mm), radius=0.15mm, height=1.68mm)
  V20_DCP = cylinder(axis=Z, base_centre=(-14.2731mm, -5.5mm, -1.44mm), radius=0.15mm, height=1.68mm)
  V21_DCP = cylinder(axis=Z, base_centre=(-20.1962mm, -5.5mm, -1.44mm), radius=0.15mm, height=1.68mm)
  V22_DCP = cylinder(axis=Z, base_centre=(-33.2269mm, -12.65mm, -1.44mm), radius=0.15mm, height=1.68mm)
  V23_DCP = cylinder(axis=Z, base_centre=(-1.15mm, -12.65mm, -1.44mm), radius=0.15mm, height=1.68mm)
  V24_DCP = cylinder(axis=Z, base_centre=(33.2269mm, -12.65mm, -1.44mm), radius=0.15mm, height=1.68mm)
  V25_DCP = cylinder(axis=Z, base_centre=(2.45mm, -5.5mm, -1.44mm), radius=0.15mm, height=1.68mm)
  V26_DCP = cylinder(axis=Z, base_centre=(3.65mm, -5.5mm, -1.44mm), radius=0.15mm, height=1.68mm)
  V27_DCP = cylinder(axis=Z, base_centre=(-3.55mm, -5.5mm, -1.44mm), radius=0.15mm, height=1.68mm)
  V28_DCP = cylinder(axis=Z, base_centre=(32.0423mm, -12.65mm, -1.44mm), radius=0.15mm, height=1.68mm)
  V29_DCP = cylinder(axis=Z, base_centre=(23.75mm, -12.65mm, -1.44mm), radius=0.15mm, height=1.68mm)
  V30_DCP = cylinder(axis=Z, base_centre=(36.7808mm, -5.5mm, -1.44mm), radius=0.15mm, height=1.68mm)
  V31_DCP = cylinder(axis=Z, base_centre=(-33.7mm, 2.5mm, -1.44mm), radius=0.15mm, height=1.68mm)
  V32_DCP = cylinder(axis=Z, base_centre=(11.9038mm, -12.65mm, -1.44mm), radius=0.15mm, height=1.68mm)
  V33_DCP = cylinder(axis=Z, base_centre=(13.0885mm, -5.5mm, -1.44mm), radius=0.15mm, height=1.68mm)
  V34_DCP = cylinder(axis=Z, base_centre=(37.9654mm, -12.65mm, -1.44mm), radius=0.15mm, height=1.68mm)
  V35_DCP = cylinder(axis=Z, base_centre=(28.4885mm, -5.5mm, -1.44mm), radius=0.15mm, height=1.68mm)
  V36_DCP = cylinder(axis=Z, base_centre=(15.4577mm, -5.5mm, -1.44mm), radius=0.15mm, height=1.68mm)
  V37_DCP = cylinder(axis=Z, base_centre=(-36.7808mm, -5.5mm, -1.44mm), radius=0.15mm, height=1.68mm)
  V38_DCP = cylinder(axis=Z, base_centre=(-4.75mm, -12.65mm, -1.44mm), radius=0.15mm, height=1.68mm)
  V39_DCP = cylinder(axis=Z, base_centre=(-35.5962mm, -5.5mm, -1.44mm), radius=0.15mm, height=1.68mm)
  V40_DCP = cylinder(axis=Z, base_centre=(-13.0885mm, -12.65mm, -1.44mm), radius=0.15mm, height=1.68mm)
  V41_DCP = cylinder(axis=Z, base_centre=(16.6423mm, -12.65mm, -1.44mm), radius=0.15mm, height=1.68mm)
  V42_DCP = cylinder(axis=Z, base_centre=(-2.35mm, -5.5mm, -1.44mm), radius=0.15mm, height=1.68mm)
  V43_DCP = cylinder(axis=Z, base_centre=(-5.95mm, -5.5mm, -1.44mm), radius=0.15mm, height=1.68mm)
  V44_DCP = cylinder(axis=Z, base_centre=(26.1192mm, -5.5mm, -1.44mm), radius=0.15mm, height=1.68mm)
  V45_DCP = cylinder(axis=Z, base_centre=(35.5962mm, -12.65mm, -1.44mm), radius=0.15mm, height=1.68mm)
  V46_DCP = cylinder(axis=Z, base_centre=(-31.9mm, 2.5mm, -1.44mm), radius=0.15mm, height=1.68mm)
  V47_DCP = cylinder(axis=Z, base_centre=(34.4115mm, -12.65mm, -1.44mm), radius=0.15mm, height=1.68mm)
  V48_DCP = cylinder(axis=Z, base_centre=(32.0423mm, -5.5mm, -1.44mm), radius=0.15mm, height=1.68mm)
  V49_DCP = cylinder(axis=Z, base_centre=(23.75mm, -5.5mm, -1.44mm), radius=0.15mm, height=1.68mm)
  V50_DCP = cylinder(axis=Z, base_centre=(9.5346mm, -5.5mm, -1.44mm), radius=0.15mm, height=1.68mm)
  V51_DCP = cylinder(axis=Z, base_centre=(26.1192mm, -12.65mm, -1.44mm), radius=0.15mm, height=1.68mm)
  V52_DCP = cylinder(axis=Z, base_centre=(32.8mm, 2.5mm, -1.44mm), radius=0.15mm, height=1.68mm)
  V53_DCP = cylinder(axis=Z, base_centre=(-27.3038mm, -5.5mm, -1.44mm), radius=0.15mm, height=1.68mm)
  V54_DCP = cylinder(axis=Z, base_centre=(39.15mm, -5.5mm, -1.44mm), radius=0.15mm, height=1.68mm)
  V55_DCP = cylinder(axis=Z, base_centre=(22.5654mm, -5.5mm, -1.44mm), radius=0.15mm, height=1.68mm)
  V56_DCP = cylinder(axis=Z, base_centre=(-5.95mm, -12.65mm, -1.44mm), radius=0.15mm, height=1.68mm)
  V57_DCP = cylinder(axis=Z, base_centre=(-15.6mm, 2.5mm, -1.44mm), radius=0.15mm, height=1.68mm)
  V58_DCP = cylinder(axis=Z, base_centre=(-33.2269mm, -5.5mm, -1.44mm), radius=0.15mm, height=1.68mm)
  V59_DCP = cylinder(axis=Z, base_centre=(-28.4885mm, -5.5mm, -1.44mm), radius=0.15mm, height=1.68mm)
  V60_DCP = cylinder(axis=Z, base_centre=(6.05mm, -12.65mm, -1.44mm), radius=0.15mm, height=1.68mm)
  V61_DCP = cylinder(axis=Z, base_centre=(-23.75mm, -12.65mm, -1.44mm), radius=0.15mm, height=1.68mm)
  V62_DCP = cylinder(axis=Z, base_centre=(10.7192mm, -5.5mm, -1.44mm), radius=0.15mm, height=1.68mm)
  V63_DCP = cylinder(axis=Z, base_centre=(19.0115mm, -5.5mm, -1.44mm), radius=0.15mm, height=1.68mm)
  V64_DCP = cylinder(axis=Z, base_centre=(13.8mm, 2.5mm, -1.44mm), radius=0.15mm, height=1.68mm)
  V65_DCP = cylinder(axis=Z, base_centre=(30.1mm, 2.5mm, -1.44mm), radius=0.15mm, height=1.68mm)
  V66_DCP = cylinder(axis=Z, base_centre=(-3.55mm, -12.65mm, -1.44mm), radius=0.15mm, height=1.68mm)
  V67_DCP = cylinder(axis=Z, base_centre=(21.3808mm, -5.5mm, -1.44mm), radius=0.15mm, height=1.68mm)
  V68_DCP = cylinder(axis=Z, base_centre=(-14.2731mm, -12.65mm, -1.44mm), radius=0.15mm, height=1.68mm)
  V69_DCP = cylinder(axis=Z, base_centre=(-15.4577mm, -12.65mm, -1.44mm), radius=0.15mm, height=1.68mm)
  V70_DCP = cylinder(axis=Z, base_centre=(-7.15mm, -12.65mm, -1.44mm), radius=0.15mm, height=1.68mm)
  V71_DCP = cylinder(axis=Z, base_centre=(4.85mm, -12.65mm, -1.44mm), radius=0.15mm, height=1.68mm)
  V72_DCP = cylinder(axis=Z, base_centre=(1.25mm, -12.65mm, -1.44mm), radius=0.15mm, height=1.68mm)
  V73_DCP = cylinder(axis=Z, base_centre=(-31mm, 2.5mm, -1.44mm), radius=0.15mm, height=1.68mm)
  V74_DCP = cylinder(axis=Z, base_centre=(37.9654mm, -5.5mm, -1.44mm), radius=0.15mm, height=1.68mm)
  V75_DCP = cylinder(axis=Z, base_centre=(-26.1192mm, -5.5mm, -1.44mm), radius=0.15mm, height=1.68mm)
  V76_DCP = cylinder(axis=Z, base_centre=(-30.1mm, 2.5mm, -1.44mm), radius=0.15mm, height=1.68mm)
  V77_DCP = cylinder(axis=Z, base_centre=(9.5346mm, -12.65mm, -1.44mm), radius=0.15mm, height=1.68mm)
  V78_DCP = cylinder(axis=Z, base_centre=(36.7808mm, -12.65mm, -1.44mm), radius=0.15mm, height=1.68mm)
  V79_DCP = cylinder(axis=Z, base_centre=(-17.8269mm, -5.5mm, -1.44mm), radius=0.15mm, height=1.68mm)
  V80_DCP = cylinder(axis=Z, base_centre=(29.2mm, 2.5mm, -1.44mm), radius=0.15mm, height=1.68mm)
  V81_DCP = cylinder(axis=Z, base_centre=(-2.35mm, -12.65mm, -1.44mm), radius=0.15mm, height=1.68mm)
  V82_DCP = cylinder(axis=Z, base_centre=(19.0115mm, -12.65mm, -1.44mm), radius=0.15mm, height=1.68mm)
  V83_DCP = cylinder(axis=Z, base_centre=(-9.5346mm, -12.65mm, -1.44mm), radius=0.15mm, height=1.68mm)
  V84_DCP = cylinder(axis=Z, base_centre=(-26.1192mm, -12.65mm, -1.44mm), radius=0.15mm, height=1.68mm)
  V85_DCP = cylinder(axis=Z, base_centre=(33.2269mm, -5.5mm, -1.44mm), radius=0.15mm, height=1.68mm)
  V86_DCP = cylinder(axis=Z, base_centre=(-21.3808mm, -5.5mm, -1.44mm), radius=0.15mm, height=1.68mm)
  V87_DCP = cylinder(axis=Z, base_centre=(24.9346mm, -5.5mm, -1.44mm), radius=0.15mm, height=1.68mm)
  V88_DCP = cylinder(axis=Z, base_centre=(16.5mm, 2.5mm, -1.44mm), radius=0.15mm, height=1.68mm)
  V89_DCP = cylinder(axis=Z, base_centre=(-10.7192mm, -12.65mm, -1.44mm), radius=0.15mm, height=1.68mm)
  V90_DCP = cylinder(axis=Z, base_centre=(4.85mm, -5.5mm, -1.44mm), radius=0.15mm, height=1.68mm)
  V91_DCP = cylinder(axis=Z, base_centre=(-34.4115mm, -5.5mm, -1.44mm), radius=0.15mm, height=1.68mm)
  V92_DCP = cylinder(axis=Z, base_centre=(11.9038mm, -5.5mm, -1.44mm), radius=0.15mm, height=1.68mm)
  V93_DCP = cylinder(axis=Z, base_centre=(-17.8269mm, -12.65mm, -1.44mm), radius=0.15mm, height=1.68mm)
  V94_DCP = cylinder(axis=Z, base_centre=(14.7mm, 2.5mm, -1.44mm), radius=0.15mm, height=1.68mm)
  V95_DCP = cylinder(axis=Z, base_centre=(30.8577mm, -12.65mm, -1.44mm), radius=0.15mm, height=1.68mm)
  V96_DCP = cylinder(axis=Z, base_centre=(-30.8577mm, -12.65mm, -1.44mm), radius=0.15mm, height=1.68mm)
  V97_DCP = cylinder(axis=Z, base_centre=(-29.6731mm, -5.5mm, -1.44mm), radius=0.15mm, height=1.68mm)
  V98_DCP = cylinder(axis=Z, base_centre=(6.05mm, -5.5mm, -1.44mm), radius=0.15mm, height=1.68mm)
  V99_DCP = cylinder(axis=Z, base_centre=(28.4885mm, -12.65mm, -1.44mm), radius=0.15mm, height=1.68mm)
  V100_DCP = cylinder(axis=Z, base_centre=(-29.2mm, 2.5mm, -1.44mm), radius=0.15mm, height=1.68mm)
  V101_DCP = cylinder(axis=Z, base_centre=(-13.8mm, 2.5mm, -1.44mm), radius=0.15mm, height=1.68mm)
  V102_DCP = cylinder(axis=Z, base_centre=(12.9mm, 2.5mm, -1.44mm), radius=0.15mm, height=1.68mm)
  V103_DCP = cylinder(axis=Z, base_centre=(31.9mm, 2.5mm, -1.44mm), radius=0.15mm, height=1.68mm)
  V104_DCP = cylinder(axis=Z, base_centre=(20.1962mm, -12.65mm, -1.44mm), radius=0.15mm, height=1.68mm)
  V105_DCP = cylinder(axis=Z, base_centre=(-24.9346mm, -5.5mm, -1.44mm), radius=0.15mm, height=1.68mm)
  V106_DCP = cylinder(axis=Z, base_centre=(18.3mm, 2.5mm, -1.44mm), radius=0.15mm, height=1.68mm)
  V107_DCP = cylinder(axis=Z, base_centre=(-35.5962mm, -12.65mm, -1.44mm), radius=0.15mm, height=1.68mm)
  V108_DCP = cylinder(axis=Z, base_centre=(-1.15mm, -5.5mm, -1.44mm), radius=0.15mm, height=1.68mm)
  V109_DCP = cylinder(axis=Z, base_centre=(13.0885mm, -12.65mm, -1.44mm), radius=0.15mm, height=1.68mm)
  V110_DCP = cylinder(axis=Z, base_centre=(3.65mm, -12.65mm, -1.44mm), radius=0.15mm, height=1.68mm)
  V111_DCP = cylinder(axis=Z, base_centre=(17.8269mm, -5.5mm, -1.44mm), radius=0.15mm, height=1.68mm)
  V112_DCP = cylinder(axis=Z, base_centre=(-30.8577mm, -5.5mm, -1.44mm), radius=0.15mm, height=1.68mm)
  V113_DCP = cylinder(axis=Z, base_centre=(-27.3038mm, -12.65mm, -1.44mm), radius=0.15mm, height=1.68mm)
  V114_DCP = cylinder(axis=Z, base_centre=(0.05mm, -5.5mm, -1.44mm), radius=0.15mm, height=1.68mm)
  V115_DCP = cylinder(axis=Z, base_centre=(-16.5mm, 2.5mm, -1.44mm), radius=0.15mm, height=1.68mm)
  V116_DCP = cylinder(axis=Z, base_centre=(-32.0423mm, -12.65mm, -1.44mm), radius=0.15mm, height=1.68mm)
  V117_DCP = cylinder(axis=Z, base_centre=(-16.6423mm, -5.5mm, -1.44mm), radius=0.15mm, height=1.68mm)
  V118_DCP = cylinder(axis=Z, base_centre=(-13.0885mm, -5.5mm, -1.44mm), radius=0.15mm, height=1.68mm)
  V119_DCP = cylinder(axis=Z, base_centre=(-23.75mm, -5.5mm, -1.44mm), radius=0.15mm, height=1.68mm)
  V120_DCP = cylinder(axis=Z, base_centre=(15.6mm, 2.5mm, -1.44mm), radius=0.15mm, height=1.68mm)
  V121_DCP = cylinder(axis=Z, base_centre=(-11.9038mm, -12.65mm, -1.44mm), radius=0.15mm, height=1.68mm)
  V122_DCP = cylinder(axis=Z, base_centre=(-39.15mm, -12.65mm, -1.44mm), radius=0.15mm, height=1.68mm)
  V123_DCP = cylinder(axis=Z, base_centre=(-37.9654mm, -5.5mm, -1.44mm), radius=0.15mm, height=1.68mm)
  V124_DCP = cylinder(axis=Z, base_centre=(27.3038mm, -12.65mm, -1.44mm), radius=0.15mm, height=1.68mm)
  V125_DCP = cylinder(axis=Z, base_centre=(-32.0423mm, -5.5mm, -1.44mm), radius=0.15mm, height=1.68mm)
  V126_DCP = cylinder(axis=Z, base_centre=(-20.1962mm, -12.65mm, -1.44mm), radius=0.15mm, height=1.68mm)
  V127_DCP = cylinder(axis=Z, base_centre=(-16.6423mm, -12.65mm, -1.44mm), radius=0.15mm, height=1.68mm)
  V128_DCP = cylinder(axis=Z, base_centre=(-37.9654mm, -12.65mm, -1.44mm), radius=0.15mm, height=1.68mm)
  V129_DCP = cylinder(axis=Z, base_centre=(-14.7mm, 2.5mm, -1.44mm), radius=0.15mm, height=1.68mm)
  V130_DCP = cylinder(axis=Z, base_centre=(-34.4115mm, -12.65mm, -1.44mm), radius=0.15mm, height=1.68mm)
  V131_DCP = cylinder(axis=Z, base_centre=(-39.15mm, -5.5mm, -1.44mm), radius=0.15mm, height=1.68mm)
  V132_DCP = cylinder(axis=Z, base_centre=(22.5654mm, -12.65mm, -1.44mm), radius=0.15mm, height=1.68mm)
  V133_DCP = cylinder(axis=Z, base_centre=(8.35mm, -12.65mm, -1.44mm), radius=0.15mm, height=1.68mm)
  V134_DCP = cylinder(axis=Z, base_centre=(39.15mm, -12.65mm, -1.44mm), radius=0.15mm, height=1.68mm)
  V135_DCP = cylinder(axis=Z, base_centre=(35.5962mm, -5.5mm, -1.44mm), radius=0.15mm, height=1.68mm)
  V136_DCP = cylinder(axis=Z, base_centre=(-12mm, 2.5mm, -1.44mm), radius=0.15mm, height=1.68mm)
  V137_DCP = cylinder(axis=Z, base_centre=(-24.9346mm, -12.65mm, -1.44mm), radius=0.15mm, height=1.68mm)
  V138_DCP = cylinder(axis=Z, base_centre=(-34.6mm, 2.5mm, -1.44mm), radius=0.15mm, height=1.68mm)
  V139_DCP = cylinder(axis=Z, base_centre=(-15.4577mm, -5.5mm, -1.44mm), radius=0.15mm, height=1.68mm)
  V140_DCP = cylinder(axis=Z, base_centre=(-21.3808mm, -12.65mm, -1.44mm), radius=0.15mm, height=1.68mm)
  V141_DCP = cylinder(axis=Z, base_centre=(12mm, 2.5mm, -1.44mm), radius=0.15mm, height=1.68mm)
  V142_DCP = cylinder(axis=Z, base_centre=(1.25mm, -5.5mm, -1.44mm), radius=0.15mm, height=1.68mm)
  V143_DCP = cylinder(axis=Z, base_centre=(-19.0115mm, -5.5mm, -1.44mm), radius=0.15mm, height=1.68mm)
  V144_DCP = cylinder(axis=Z, base_centre=(-17.4mm, 2.5mm, -1.44mm), radius=0.15mm, height=1.68mm)
  V145_DCP = cylinder(axis=Z, base_centre=(-18.3mm, 2.5mm, -1.44mm), radius=0.15mm, height=1.68mm)
  V146_DCP = cylinder(axis=Z, base_centre=(35.5mm, 2.5mm, -1.44mm), radius=0.15mm, height=1.68mm)
  V147_DCP = cylinder(axis=Z, base_centre=(-22.5654mm, -5.5mm, -1.44mm), radius=0.15mm, height=1.68mm)
  V148_DCP = cylinder(axis=Z, base_centre=(16.6423mm, -5.5mm, -1.44mm), radius=0.15mm, height=1.68mm)
  V149_DCP = cylinder(axis=Z, base_centre=(14.2731mm, -5.5mm, -1.44mm), radius=0.15mm, height=1.68mm)
  V150_DCP = cylinder(axis=Z, base_centre=(-7.15mm, -5.5mm, -1.44mm), radius=0.15mm, height=1.68mm)
  V151_DCP = cylinder(axis=Z, base_centre=(10.7192mm, -12.65mm, -1.44mm), radius=0.15mm, height=1.68mm)
  V152_DCP = cylinder(axis=Z, base_centre=(15.4577mm, -12.65mm, -1.44mm), radius=0.15mm, height=1.68mm)
  V153_DCP = cylinder(axis=Z, base_centre=(8.35mm, -5.5mm, -1.44mm), radius=0.15mm, height=1.68mm)
  V154_DCP = cylinder(axis=Z, base_centre=(31mm, 2.5mm, -1.44mm), radius=0.15mm, height=1.68mm)
  V155_DCP = cylinder(axis=Z, base_centre=(-32.8mm, 2.5mm, -1.44mm), radius=0.15mm, height=1.68mm)
  V156_DCP = cylinder(axis=Z, base_centre=(-36.7808mm, -12.65mm, -1.44mm), radius=0.15mm, height=1.68mm)
  V157_DCP = cylinder(axis=Z, base_centre=(-35.5mm, 2.5mm, -1.44mm), radius=0.15mm, height=1.68mm)
  V158_DCP = cylinder(axis=Z, base_centre=(14.2731mm, -12.65mm, -1.44mm), radius=0.15mm, height=1.68mm)
  V159_DCP = cylinder(axis=Z, base_centre=(33.7mm, 2.5mm, -1.44mm), radius=0.15mm, height=1.68mm)
  V160_DCP = cylinder(axis=Z, base_centre=(2.45mm, -12.65mm, -1.44mm), radius=0.15mm, height=1.68mm)
  V161_DCP = cylinder(axis=Z, base_centre=(-4.75mm, -5.5mm, -1.44mm), radius=0.15mm, height=1.68mm)
  V162_DCP = cylinder(axis=Z, base_centre=(-22.5654mm, -12.65mm, -1.44mm), radius=0.15mm, height=1.68mm)
  V163_DCP = cylinder(axis=Z, base_centre=(-29.6731mm, -12.65mm, -1.44mm), radius=0.15mm, height=1.68mm)
  V164_DCN = cylinder(axis=Z, base_centre=(13.0885mm, -10.75mm, -1.44mm), radius=0.15mm, height=1.68mm)
  V165_DCN = cylinder(axis=Z, base_centre=(-29.6731mm, -10.75mm, -1.44mm), radius=0.15mm, height=1.68mm)
  V166_DCN = cylinder(axis=Z, base_centre=(-27.3038mm, -10.75mm, -1.44mm), radius=0.15mm, height=1.68mm)
  V167_DCN = cylinder(axis=Z, base_centre=(1.25mm, -10.75mm, -1.44mm), radius=0.15mm, height=1.68mm)
  V168_DCN = cylinder(axis=Z, base_centre=(-17.8269mm, -0.5mm, -1.44mm), radius=0.15mm, height=1.68mm)
  V169_DCN = cylinder(axis=Z, base_centre=(0.05mm, -10.75mm, -1.44mm), radius=0.15mm, height=1.68mm)
  V170_DCN = cylinder(axis=Z, base_centre=(10.7192mm, -0.5mm, -1.44mm), radius=0.15mm, height=1.68mm)
  V171_DCN = cylinder(axis=Z, base_centre=(-5.95mm, -0.5mm, -1.44mm), radius=0.15mm, height=1.68mm)
  V172_DCN = cylinder(axis=Z, base_centre=(26.1192mm, -10.75mm, -1.44mm), radius=0.15mm, height=1.68mm)
  V173_DCN = cylinder(axis=Z, base_centre=(11.9038mm, -0.5mm, -1.44mm), radius=0.15mm, height=1.68mm)
  V174_DCN = cylinder(axis=Z, base_centre=(-30.8577mm, -10.75mm, -1.44mm), radius=0.15mm, height=1.68mm)
  V175_DCN = cylinder(axis=Z, base_centre=(27.3038mm, -10.75mm, -1.44mm), radius=0.15mm, height=1.68mm)
  V176_DCN = cylinder(axis=Z, base_centre=(-11.9038mm, -0.5mm, -1.44mm), radius=0.15mm, height=1.68mm)
  V177_DCN = cylinder(axis=Z, base_centre=(-35.5962mm, -10.75mm, -1.44mm), radius=0.15mm, height=1.68mm)
  V178_DCN = cylinder(axis=Z, base_centre=(28.4885mm, -10.75mm, -1.44mm), radius=0.15mm, height=1.68mm)
  V179_DCN = cylinder(axis=Z, base_centre=(36.7808mm, -0.5mm, -1.44mm), radius=0.15mm, height=1.68mm)
  V180_DCN = cylinder(axis=Z, base_centre=(-14.2731mm, -10.75mm, -1.44mm), radius=0.15mm, height=1.68mm)
  V181_DCN = cylinder(axis=Z, base_centre=(37.9654mm, -10.75mm, -1.44mm), radius=0.15mm, height=1.68mm)
  V182_DCN = cylinder(axis=Z, base_centre=(3.65mm, -10.75mm, -1.44mm), radius=0.15mm, height=1.68mm)
  V183_DCN = cylinder(axis=Z, base_centre=(29.6731mm, -10.75mm, -1.44mm), radius=0.15mm, height=1.68mm)
  V184_DCN = cylinder(axis=Z, base_centre=(-15.4577mm, -0.5mm, -1.44mm), radius=0.15mm, height=1.68mm)
  V185_DCN = cylinder(axis=Z, base_centre=(-3.55mm, -10.75mm, -1.44mm), radius=0.15mm, height=1.68mm)
  V186_DCN = cylinder(axis=Z, base_centre=(39.15mm, -10.75mm, -1.44mm), radius=0.15mm, height=1.68mm)
  V187_DCN = cylinder(axis=Z, base_centre=(39.15mm, -0.5mm, -1.44mm), radius=0.15mm, height=1.68mm)
  V188_DCN = cylinder(axis=Z, base_centre=(24.9346mm, -10.75mm, -1.44mm), radius=0.15mm, height=1.68mm)
  V189_DCN = cylinder(axis=Z, base_centre=(21.3808mm, -10.75mm, -1.44mm), radius=0.15mm, height=1.68mm)
  V190_DCN = cylinder(axis=Z, base_centre=(22.5654mm, -10.75mm, -1.44mm), radius=0.15mm, height=1.68mm)
  V191_DCN = cylinder(axis=Z, base_centre=(-14.2731mm, -0.5mm, -1.44mm), radius=0.15mm, height=1.68mm)
  V192_DCN = cylinder(axis=Z, base_centre=(-20.1962mm, -0.5mm, -1.44mm), radius=0.15mm, height=1.68mm)
  V193_DCN = cylinder(axis=Z, base_centre=(32.0423mm, -10.75mm, -1.44mm), radius=0.15mm, height=1.68mm)
  V194_DCN = cylinder(axis=Z, base_centre=(-19.0115mm, -10.75mm, -1.44mm), radius=0.15mm, height=1.68mm)
  V195_DCN = cylinder(axis=Z, base_centre=(23.75mm, -10.75mm, -1.44mm), radius=0.15mm, height=1.68mm)
  V196_DCN = cylinder(axis=Z, base_centre=(22.5654mm, -0.5mm, -1.44mm), radius=0.15mm, height=1.68mm)
  V197_DCN = cylinder(axis=Z, base_centre=(-33.2269mm, -10.75mm, -1.44mm), radius=0.15mm, height=1.68mm)
  V198_DCN = cylinder(axis=Z, base_centre=(-21.3808mm, -0.5mm, -1.44mm), radius=0.15mm, height=1.68mm)
  V199_DCN = cylinder(axis=Z, base_centre=(33.2269mm, -10.75mm, -1.44mm), radius=0.15mm, height=1.68mm)
  V200_DCN = cylinder(axis=Z, base_centre=(-22.5654mm, -10.75mm, -1.44mm), radius=0.15mm, height=1.68mm)
  V201_DCN = cylinder(axis=Z, base_centre=(30.8577mm, -10.75mm, -1.44mm), radius=0.15mm, height=1.68mm)
  V202_DCN = cylinder(axis=Z, base_centre=(9.5346mm, -0.5mm, -1.44mm), radius=0.15mm, height=1.68mm)
  V203_DCN = cylinder(axis=Z, base_centre=(26.1192mm, -0.5mm, -1.44mm), radius=0.15mm, height=1.68mm)
  V204_DCN = cylinder(axis=Z, base_centre=(36.7808mm, -10.75mm, -1.44mm), radius=0.15mm, height=1.68mm)
  V205_DCN = cylinder(axis=Z, base_centre=(34.4115mm, -0.5mm, -1.44mm), radius=0.15mm, height=1.68mm)
  V206_DCN = cylinder(axis=Z, base_centre=(13.0885mm, -0.5mm, -1.44mm), radius=0.15mm, height=1.68mm)
  V207_DCN = cylinder(axis=Z, base_centre=(35.5962mm, -0.5mm, -1.44mm), radius=0.15mm, height=1.68mm)
  V208_DCN = cylinder(axis=Z, base_centre=(-24.9346mm, -10.75mm, -1.44mm), radius=0.15mm, height=1.68mm)
  V209_DCN = cylinder(axis=Z, base_centre=(-19.0115mm, -0.5mm, -1.44mm), radius=0.15mm, height=1.68mm)
  V210_DCN = cylinder(axis=Z, base_centre=(-27.3038mm, -0.5mm, -1.44mm), radius=0.15mm, height=1.68mm)
  V211_DCN = cylinder(axis=Z, base_centre=(-33.2269mm, -0.5mm, -1.44mm), radius=0.15mm, height=1.68mm)
  V212_DCN = cylinder(axis=Z, base_centre=(-39.15mm, -0.5mm, -1.44mm), radius=0.15mm, height=1.68mm)
  V213_DCN = cylinder(axis=Z, base_centre=(-32.0423mm, -0.5mm, -1.44mm), radius=0.15mm, height=1.68mm)
  V214_DCN = cylinder(axis=Z, base_centre=(-7.15mm, -0.5mm, -1.44mm), radius=0.15mm, height=1.68mm)
  V215_DCN = cylinder(axis=Z, base_centre=(19.0115mm, -0.5mm, -1.44mm), radius=0.15mm, height=1.68mm)
  V216_DCN = cylinder(axis=Z, base_centre=(16.6423mm, -10.75mm, -1.44mm), radius=0.15mm, height=1.68mm)
  V217_DCN = cylinder(axis=Z, base_centre=(4.85mm, -0.5mm, -1.44mm), radius=0.15mm, height=1.68mm)
  V218_DCN = cylinder(axis=Z, base_centre=(-24.9346mm, -0.5mm, -1.44mm), radius=0.15mm, height=1.68mm)
  V219_DCN = cylinder(axis=Z, base_centre=(8.35mm, -0.5mm, -1.44mm), radius=0.15mm, height=1.68mm)
  V220_DCN = cylinder(axis=Z, base_centre=(-22.5654mm, -0.5mm, -1.44mm), radius=0.15mm, height=1.68mm)
  V221_DCN = cylinder(axis=Z, base_centre=(-26.1192mm, -0.5mm, -1.44mm), radius=0.15mm, height=1.68mm)
  V222_DCN = cylinder(axis=Z, base_centre=(-10.7192mm, -10.75mm, -1.44mm), radius=0.15mm, height=1.68mm)
  V223_DCN = cylinder(axis=Z, base_centre=(-1.15mm, -10.75mm, -1.44mm), radius=0.15mm, height=1.68mm)
  V224_DCN = cylinder(axis=Z, base_centre=(-11.9038mm, -10.75mm, -1.44mm), radius=0.15mm, height=1.68mm)
  V225_DCN = cylinder(axis=Z, base_centre=(1.25mm, -0.5mm, -1.44mm), radius=0.15mm, height=1.68mm)
  V226_DCN = cylinder(axis=Z, base_centre=(8.35mm, -10.75mm, -1.44mm), radius=0.15mm, height=1.68mm)
  V227_DCN = cylinder(axis=Z, base_centre=(-13.0885mm, -0.5mm, -1.44mm), radius=0.15mm, height=1.68mm)
  V228_DCN = cylinder(axis=Z, base_centre=(-2.35mm, -0.5mm, -1.44mm), radius=0.15mm, height=1.68mm)
  V229_DCN = cylinder(axis=Z, base_centre=(-4.75mm, -10.75mm, -1.44mm), radius=0.15mm, height=1.68mm)
  V230_DCN = cylinder(axis=Z, base_centre=(-4.75mm, -0.5mm, -1.44mm), radius=0.15mm, height=1.68mm)
  V231_DCN = cylinder(axis=Z, base_centre=(-29.6731mm, -0.5mm, -1.44mm), radius=0.15mm, height=1.68mm)
  V232_DCN = cylinder(axis=Z, base_centre=(29.6731mm, -0.5mm, -1.44mm), radius=0.15mm, height=1.68mm)
  V233_DCN = cylinder(axis=Z, base_centre=(-23.75mm, -10.75mm, -1.44mm), radius=0.15mm, height=1.68mm)
  V234_DCN = cylinder(axis=Z, base_centre=(-21.3808mm, -10.75mm, -1.44mm), radius=0.15mm, height=1.68mm)
  V235_DCN = cylinder(axis=Z, base_centre=(6.05mm, -0.5mm, -1.44mm), radius=0.15mm, height=1.68mm)
  V236_DCN = cylinder(axis=Z, base_centre=(-23.75mm, -0.5mm, -1.44mm), radius=0.15mm, height=1.68mm)
  V237_DCN = cylinder(axis=Z, base_centre=(0.05mm, -0.5mm, -1.44mm), radius=0.15mm, height=1.68mm)
  V238_DCN = cylinder(axis=Z, base_centre=(2.45mm, -10.75mm, -1.44mm), radius=0.15mm, height=1.68mm)
  V239_DCN = cylinder(axis=Z, base_centre=(-37.9654mm, -10.75mm, -1.44mm), radius=0.15mm, height=1.68mm)
  V240_DCN = cylinder(axis=Z, base_centre=(35.5962mm, -10.75mm, -1.44mm), radius=0.15mm, height=1.68mm)
  V241_DCN = cylinder(axis=Z, base_centre=(20.1962mm, -10.75mm, -1.44mm), radius=0.15mm, height=1.68mm)
  V242_DCN = cylinder(axis=Z, base_centre=(28.4885mm, -0.5mm, -1.44mm), radius=0.15mm, height=1.68mm)
  V243_DCN = cylinder(axis=Z, base_centre=(3.65mm, -0.5mm, -1.44mm), radius=0.15mm, height=1.68mm)
  V244_DCN = cylinder(axis=Z, base_centre=(15.4577mm, -0.5mm, -1.44mm), radius=0.15mm, height=1.68mm)
  V245_DCN = cylinder(axis=Z, base_centre=(-34.4115mm, -0.5mm, -1.44mm), radius=0.15mm, height=1.68mm)
  V246_DCN = cylinder(axis=Z, base_centre=(-28.4885mm, -10.75mm, -1.44mm), radius=0.15mm, height=1.68mm)
  V247_DCN = cylinder(axis=Z, base_centre=(-7.15mm, -10.75mm, -1.44mm), radius=0.15mm, height=1.68mm)
  V248_DCN = cylinder(axis=Z, base_centre=(9.5346mm, -10.75mm, -1.44mm), radius=0.15mm, height=1.68mm)
  V249_DCN = cylinder(axis=Z, base_centre=(-30.8577mm, -0.5mm, -1.44mm), radius=0.15mm, height=1.68mm)
  V250_DCN = cylinder(axis=Z, base_centre=(-8.35mm, -0.5mm, -1.44mm), radius=0.15mm, height=1.68mm)
  V251_DCN = cylinder(axis=Z, base_centre=(14.2731mm, -0.5mm, -1.44mm), radius=0.15mm, height=1.68mm)
  V252_DCN = cylinder(axis=Z, base_centre=(19.0115mm, -10.75mm, -1.44mm), radius=0.15mm, height=1.68mm)
  V253_DCN = cylinder(axis=Z, base_centre=(-16.6423mm, -10.75mm, -1.44mm), radius=0.15mm, height=1.68mm)
  V254_DCN = cylinder(axis=Z, base_centre=(-1.15mm, -0.5mm, -1.44mm), radius=0.15mm, height=1.68mm)
  V255_DCN = cylinder(axis=Z, base_centre=(-39.15mm, -10.75mm, -1.44mm), radius=0.15mm, height=1.68mm)
  V256_DCN = cylinder(axis=Z, base_centre=(-26.1192mm, -10.75mm, -1.44mm), radius=0.15mm, height=1.68mm)
  V257_DCN = cylinder(axis=Z, base_centre=(11.9038mm, -10.75mm, -1.44mm), radius=0.15mm, height=1.68mm)
  V258_DCN = cylinder(axis=Z, base_centre=(-36.7808mm, -10.75mm, -1.44mm), radius=0.15mm, height=1.68mm)
  V259_DCN = cylinder(axis=Z, base_centre=(10.7192mm, -10.75mm, -1.44mm), radius=0.15mm, height=1.68mm)
  V260_DCN = cylinder(axis=Z, base_centre=(-16.6423mm, -0.5mm, -1.44mm), radius=0.15mm, height=1.68mm)
  V261_DCN = cylinder(axis=Z, base_centre=(-32.0423mm, -10.75mm, -1.44mm), radius=0.15mm, height=1.68mm)
  V262_DCN = cylinder(axis=Z, base_centre=(15.4577mm, -10.75mm, -1.44mm), radius=0.15mm, height=1.68mm)
  V263_DCN = cylinder(axis=Z, base_centre=(-28.4885mm, -0.5mm, -1.44mm), radius=0.15mm, height=1.68mm)
  V264_DCN = cylinder(axis=Z, base_centre=(17.8269mm, -0.5mm, -1.44mm), radius=0.15mm, height=1.68mm)
  V265_DCN = cylinder(axis=Z, base_centre=(-36.7808mm, -0.5mm, -1.44mm), radius=0.15mm, height=1.68mm)
  V266_DCN = cylinder(axis=Z, base_centre=(23.75mm, -0.5mm, -1.44mm), radius=0.15mm, height=1.68mm)
  V267_DCN = cylinder(axis=Z, base_centre=(16.6423mm, -0.5mm, -1.44mm), radius=0.15mm, height=1.68mm)
  V268_DCN = cylinder(axis=Z, base_centre=(-20.1962mm, -10.75mm, -1.44mm), radius=0.15mm, height=1.68mm)
  V269_DCN = cylinder(axis=Z, base_centre=(-10.7192mm, -0.5mm, -1.44mm), radius=0.15mm, height=1.68mm)
  V270_DCN = cylinder(axis=Z, base_centre=(30.8577mm, -0.5mm, -1.44mm), radius=0.15mm, height=1.68mm)
  V271_DCN = cylinder(axis=Z, base_centre=(-35.5962mm, -0.5mm, -1.44mm), radius=0.15mm, height=1.68mm)
  V272_DCN = cylinder(axis=Z, base_centre=(37.9654mm, -0.5mm, -1.44mm), radius=0.15mm, height=1.68mm)
  V273_DCN = cylinder(axis=Z, base_centre=(-13.0885mm, -10.75mm, -1.44mm), radius=0.15mm, height=1.68mm)
  V274_DCN = cylinder(axis=Z, base_centre=(32.0423mm, -0.5mm, -1.44mm), radius=0.15mm, height=1.68mm)
  V275_DCN = cylinder(axis=Z, base_centre=(-37.9654mm, -0.5mm, -1.44mm), radius=0.15mm, height=1.68mm)
  V276_DCN = cylinder(axis=Z, base_centre=(-8.35mm, -10.75mm, -1.44mm), radius=0.15mm, height=1.68mm)
  V277_DCN = cylinder(axis=Z, base_centre=(-9.5346mm, -10.75mm, -1.44mm), radius=0.15mm, height=1.68mm)
  V278_DCN = cylinder(axis=Z, base_centre=(-9.5346mm, -0.5mm, -1.44mm), radius=0.15mm, height=1.68mm)
  V279_DCN = cylinder(axis=Z, base_centre=(14.2731mm, -10.75mm, -1.44mm), radius=0.15mm, height=1.68mm)
  V280_DCN = cylinder(axis=Z, base_centre=(20.1962mm, -0.5mm, -1.44mm), radius=0.15mm, height=1.68mm)
  V281_DCN = cylinder(axis=Z, base_centre=(24.9346mm, -0.5mm, -1.44mm), radius=0.15mm, height=1.68mm)
  V282_DCN = cylinder(axis=Z, base_centre=(21.3808mm, -0.5mm, -1.44mm), radius=0.15mm, height=1.68mm)
  V283_DCN = cylinder(axis=Z, base_centre=(-2.35mm, -10.75mm, -1.44mm), radius=0.15mm, height=1.68mm)
  V284_DCN = cylinder(axis=Z, base_centre=(4.85mm, -10.75mm, -1.44mm), radius=0.15mm, height=1.68mm)
  V285_DCN = cylinder(axis=Z, base_centre=(6.05mm, -10.75mm, -1.44mm), radius=0.15mm, height=1.68mm)
  V286_DCN = cylinder(axis=Z, base_centre=(-15.4577mm, -10.75mm, -1.44mm), radius=0.15mm, height=1.68mm)
  V287_DCN = cylinder(axis=Z, base_centre=(-3.55mm, -0.5mm, -1.44mm), radius=0.15mm, height=1.68mm)
  V288_DCN = cylinder(axis=Z, base_centre=(-5.95mm, -10.75mm, -1.44mm), radius=0.15mm, height=1.68mm)
  V289_DCN = cylinder(axis=Z, base_centre=(17.8269mm, -10.75mm, -1.44mm), radius=0.15mm, height=1.68mm)
  V290_DCN = cylinder(axis=Z, base_centre=(33.2269mm, -0.5mm, -1.44mm), radius=0.15mm, height=1.68mm)
  V291_DCN = cylinder(axis=Z, base_centre=(-17.8269mm, -10.75mm, -1.44mm), radius=0.15mm, height=1.68mm)
  V292_DCN = cylinder(axis=Z, base_centre=(27.3038mm, -0.5mm, -1.44mm), radius=0.15mm, height=1.68mm)
  V293_DCN = cylinder(axis=Z, base_centre=(-34.4115mm, -10.75mm, -1.44mm), radius=0.15mm, height=1.68mm)
  V294_DCN = cylinder(axis=Z, base_centre=(7mm, 4mm, -1.44mm), radius=0.15mm, height=1.68mm)
  V295_DCN = cylinder(axis=Z, base_centre=(34.4115mm, -10.75mm, -1.44mm), radius=0.15mm, height=1.68mm)
  V296_DCN = cylinder(axis=Z, base_centre=(2.45mm, -0.5mm, -1.44mm), radius=0.15mm, height=1.68mm)
  V297_DCN = cylinder(axis=Z, base_centre=(3.065mm, -21.735mm, -1.44mm), radius=0.925mm, height=1.68mm)
  V298_DCN = cylinder(axis=Z, base_centre=(3.065mm, -15.865mm, -1.44mm), radius=0.925mm, height=1.68mm)
  V299_DCN = cylinder(axis=Z, base_centre=(8.935mm, -21.735mm, -1.44mm), radius=0.925mm, height=1.68mm)
  V300_DCN = cylinder(axis=Z, base_centre=(8.935mm, -15.865mm, -1.44mm), radius=0.925mm, height=1.68mm)
  V301_DCP = cylinder(axis=Z, base_centre=(-8.935mm, -21.735mm, -1.44mm), radius=0.925mm, height=1.68mm)
  V302_DCP = cylinder(axis=Z, base_centre=(-8.935mm, -15.865mm, -1.44mm), radius=0.925mm, height=1.68mm)
  V303_DCP = cylinder(axis=Z, base_centre=(-3.065mm, -21.735mm, -1.44mm), radius=0.925mm, height=1.68mm)
  V304_DCP = cylinder(axis=Z, base_centre=(-3.065mm, -15.865mm, -1.44mm), radius=0.925mm, height=1.68mm)
  C2_1 = box(corner=(-36.375mm, 1.65mm, 0.17mm), size=(1.45mm, 1mm, 0.105mm))
  C2_2 = box(corner=(-36.375mm, -0.25mm, 0.17mm), size=(1.45mm, 1mm, 0.105mm))
  C82_1 = box(corner=(12.3mm, -2.85mm, 0.17mm), size=(5.4mm, 1.8mm, 0.105mm))
  C82_2 = box(corner=(12.3mm, -7.95mm, 0.17mm), size=(5.4mm, 1.8mm, 0.105mm))
  C73_1 = box(corner=(-29.7mm, -10.05mm, 0.17mm), size=(5.4mm, 1.8mm, 0.105mm))
  C73_2 = box(corner=(-29.7mm, -15.15mm, 0.17mm), size=(5.4mm, 1.8mm, 0.105mm))
  C88_1 = box(corner=(30.3mm, -2.85mm, 0.17mm), size=(5.4mm, 1.8mm, 0.105mm))
  C88_2 = box(corner=(30.3mm, -7.95mm, 0.17mm), size=(5.4mm, 1.8mm, 0.105mm))
  C45_1 = box(corner=(34.925mm, 1.65mm, 0.17mm), size=(1.45mm, 1mm, 0.105mm))
  C45_2 = box(corner=(34.925mm, -0.25mm, 0.17mm), size=(1.45mm, 1mm, 0.105mm))
  C12_1 = box(corner=(-10.975mm, 1.65mm, 0.17mm), size=(1.45mm, 1mm, 0.105mm))
  C12_2 = box(corner=(-10.975mm, -0.25mm, 0.17mm), size=(1.45mm, 1mm, 0.105mm))
  C37_1 = box(corner=(12.725mm, 1.65mm, 0.17mm), size=(1.45mm, 1mm, 0.105mm))
  C37_2 = box(corner=(12.725mm, -0.25mm, 0.17mm), size=(1.45mm, 1mm, 0.105mm))
  C74_1 = box(corner=(24.3mm, -10.05mm, 0.17mm), size=(5.4mm, 1.8mm, 0.105mm))
  C74_2 = box(corner=(24.3mm, -15.15mm, 0.17mm), size=(5.4mm, 1.8mm, 0.105mm))
  C8_1 = box(corner=(-17.375mm, 1.65mm, 0.17mm), size=(1.45mm, 1mm, 0.105mm))
  C8_2 = box(corner=(-17.375mm, -0.25mm, 0.17mm), size=(1.45mm, 1mm, 0.105mm))
  C7_1 = box(corner=(-18.975mm, 1.65mm, 0.17mm), size=(1.45mm, 1mm, 0.105mm))
  C7_2 = box(corner=(-18.975mm, -0.25mm, 0.17mm), size=(1.45mm, 1mm, 0.105mm))
  C77_1 = box(corner=(-5.7mm, -2.85mm, 0.17mm), size=(5.4mm, 1.8mm, 0.105mm))
  C77_2 = box(corner=(-5.7mm, -7.95mm, 0.17mm), size=(5.4mm, 1.8mm, 0.105mm))
  C46_1 = box(corner=(36.525mm, 1.65mm, 0.17mm), size=(1.45mm, 1mm, 0.105mm))
  C46_2 = box(corner=(36.525mm, -0.25mm, 0.17mm), size=(1.45mm, 1mm, 0.105mm))
  C79_1 = box(corner=(-11.7mm, -2.85mm, 0.17mm), size=(5.4mm, 1.8mm, 0.105mm))
  C79_2 = box(corner=(-11.7mm, -7.95mm, 0.17mm), size=(5.4mm, 1.8mm, 0.105mm))
  C78_1 = box(corner=(0.3mm, -2.85mm, 0.17mm), size=(5.4mm, 1.8mm, 0.105mm))
  C78_2 = box(corner=(0.3mm, -7.95mm, 0.17mm), size=(5.4mm, 1.8mm, 0.105mm))
  C81_1 = box(corner=(-17.7mm, -2.85mm, 0.17mm), size=(5.4mm, 1.8mm, 0.105mm))
  C81_2 = box(corner=(-17.7mm, -7.95mm, 0.17mm), size=(5.4mm, 1.8mm, 0.105mm))
  C38_1 = box(corner=(14.325mm, 1.65mm, 0.17mm), size=(1.45mm, 1mm, 0.105mm))
  C38_2 = box(corner=(14.325mm, -0.25mm, 0.17mm), size=(1.45mm, 1mm, 0.105mm))
  C43_1 = box(corner=(31.725mm, 1.65mm, 0.17mm), size=(1.45mm, 1mm, 0.105mm))
  C43_2 = box(corner=(31.725mm, -0.25mm, 0.17mm), size=(1.45mm, 1mm, 0.105mm))
  C84_1 = box(corner=(18.3mm, -2.85mm, 0.17mm), size=(5.4mm, 1.8mm, 0.105mm))
  C84_2 = box(corner=(18.3mm, -7.95mm, 0.17mm), size=(5.4mm, 1.8mm, 0.105mm))
  C83_1 = box(corner=(-23.7mm, -2.85mm, 0.17mm), size=(5.4mm, 1.8mm, 0.105mm))
  C83_2 = box(corner=(-23.7mm, -7.95mm, 0.17mm), size=(5.4mm, 1.8mm, 0.105mm))
  C41_1 = box(corner=(28.525mm, 1.65mm, 0.17mm), size=(1.45mm, 1mm, 0.105mm))
  C41_2 = box(corner=(28.525mm, -0.25mm, 0.17mm), size=(1.45mm, 1mm, 0.105mm))
  C70_1 = box(corner=(12.3mm, -10.05mm, 0.17mm), size=(5.4mm, 1.8mm, 0.105mm))
  C70_2 = box(corner=(12.3mm, -15.15mm, 0.17mm), size=(5.4mm, 1.8mm, 0.105mm))
  C11_1 = box(corner=(-12.575mm, 1.65mm, 0.17mm), size=(1.45mm, 1mm, 0.105mm))
  C11_2 = box(corner=(-12.575mm, -0.25mm, 0.17mm), size=(1.45mm, 1mm, 0.105mm))
  C69_1 = box(corner=(-17.7mm, -10.05mm, 0.17mm), size=(5.4mm, 1.8mm, 0.105mm))
  C69_2 = box(corner=(-17.7mm, -15.15mm, 0.17mm), size=(5.4mm, 1.8mm, 0.105mm))
  C3_1 = box(corner=(-34.775mm, 1.65mm, 0.17mm), size=(1.45mm, 1mm, 0.105mm))
  C3_2 = box(corner=(-34.775mm, -0.25mm, 0.17mm), size=(1.45mm, 1mm, 0.105mm))
  C85_1 = box(corner=(-29.7mm, -2.85mm, 0.17mm), size=(5.4mm, 1.8mm, 0.105mm))
  C85_2 = box(corner=(-29.7mm, -7.95mm, 0.17mm), size=(5.4mm, 1.8mm, 0.105mm))
  C36_1 = box(corner=(11.125mm, 1.65mm, 0.17mm), size=(1.45mm, 1mm, 0.105mm))
  C36_2 = box(corner=(11.125mm, -0.25mm, 0.17mm), size=(1.45mm, 1mm, 0.105mm))
  C6_1 = box(corner=(-29.975mm, 1.65mm, 0.17mm), size=(1.45mm, 1mm, 0.105mm))
  C6_2 = box(corner=(-29.975mm, -0.25mm, 0.17mm), size=(1.45mm, 1mm, 0.105mm))
  C86_1 = box(corner=(24.3mm, -2.85mm, 0.17mm), size=(5.4mm, 1.8mm, 0.105mm))
  C86_2 = box(corner=(24.3mm, -7.95mm, 0.17mm), size=(5.4mm, 1.8mm, 0.105mm))
  C75_1 = box(corner=(-35.7mm, -10.05mm, 0.17mm), size=(5.4mm, 1.8mm, 0.105mm))
  C75_2 = box(corner=(-35.7mm, -15.15mm, 0.17mm), size=(5.4mm, 1.8mm, 0.105mm))
  C71_1 = box(corner=(-23.7mm, -10.05mm, 0.17mm), size=(5.4mm, 1.8mm, 0.105mm))
  C71_2 = box(corner=(-23.7mm, -15.15mm, 0.17mm), size=(5.4mm, 1.8mm, 0.105mm))
  C1_1 = box(corner=(-37.975mm, 1.65mm, 0.17mm), size=(1.45mm, 1mm, 0.105mm))
  C1_2 = box(corner=(-37.975mm, -0.25mm, 0.17mm), size=(1.45mm, 1mm, 0.105mm))
  C44_1 = box(corner=(33.325mm, 1.65mm, 0.17mm), size=(1.45mm, 1mm, 0.105mm))
  C44_2 = box(corner=(33.325mm, -0.25mm, 0.17mm), size=(1.45mm, 1mm, 0.105mm))
  C35_1 = box(corner=(9.525mm, 1.65mm, 0.17mm), size=(1.45mm, 1mm, 0.105mm))
  C35_2 = box(corner=(9.525mm, -0.25mm, 0.17mm), size=(1.45mm, 1mm, 0.105mm))
  C72_1 = box(corner=(18.3mm, -10.05mm, 0.17mm), size=(5.4mm, 1.8mm, 0.105mm))
  C72_2 = box(corner=(18.3mm, -15.15mm, 0.17mm), size=(5.4mm, 1.8mm, 0.105mm))
  C39_1 = box(corner=(15.925mm, 1.65mm, 0.17mm), size=(1.45mm, 1mm, 0.105mm))
  C39_2 = box(corner=(15.925mm, -0.25mm, 0.17mm), size=(1.45mm, 1mm, 0.105mm))
  C40_1 = box(corner=(17.525mm, 1.65mm, 0.17mm), size=(1.45mm, 1mm, 0.105mm))
  C40_2 = box(corner=(17.525mm, -0.25mm, 0.17mm), size=(1.45mm, 1mm, 0.105mm))
  C4_1 = box(corner=(-33.175mm, 1.65mm, 0.17mm), size=(1.45mm, 1mm, 0.105mm))
  C4_2 = box(corner=(-33.175mm, -0.25mm, 0.17mm), size=(1.45mm, 1mm, 0.105mm))
  C5_1 = box(corner=(-31.575mm, 1.65mm, 0.17mm), size=(1.45mm, 1mm, 0.105mm))
  C5_2 = box(corner=(-31.575mm, -0.25mm, 0.17mm), size=(1.45mm, 1mm, 0.105mm))
  C76_1 = box(corner=(30.3mm, -10.05mm, 0.17mm), size=(5.4mm, 1.8mm, 0.105mm))
  C76_2 = box(corner=(30.3mm, -15.15mm, 0.17mm), size=(5.4mm, 1.8mm, 0.105mm))
  C9_1 = box(corner=(-15.775mm, 1.65mm, 0.17mm), size=(1.45mm, 1mm, 0.105mm))
  C9_2 = box(corner=(-15.775mm, -0.25mm, 0.17mm), size=(1.45mm, 1mm, 0.105mm))
  C10_1 = box(corner=(-14.175mm, 1.65mm, 0.17mm), size=(1.45mm, 1mm, 0.105mm))
  C10_2 = box(corner=(-14.175mm, -0.25mm, 0.17mm), size=(1.45mm, 1mm, 0.105mm))
  C80_1 = box(corner=(6.3mm, -2.85mm, 0.17mm), size=(5.4mm, 1.8mm, 0.105mm))
  C80_2 = box(corner=(6.3mm, -7.95mm, 0.17mm), size=(5.4mm, 1.8mm, 0.105mm))
  C42_1 = box(corner=(30.125mm, 1.65mm, 0.17mm), size=(1.45mm, 1mm, 0.105mm))
  C42_2 = box(corner=(30.125mm, -0.25mm, 0.17mm), size=(1.45mm, 1mm, 0.105mm))
  C87_1 = box(corner=(-35.7mm, -2.85mm, 0.17mm), size=(5.4mm, 1.8mm, 0.105mm))
  C87_2 = box(corner=(-35.7mm, -7.95mm, 0.17mm), size=(5.4mm, 1.8mm, 0.105mm))
  C65_1 = box(corner=(33.325mm, -0.25mm, -1.475mm), size=(1.45mm, 1mm, 0.105mm))
  C65_2 = box(corner=(33.325mm, 1.65mm, -1.475mm), size=(1.45mm, 1mm, 0.105mm))
  C66_1 = box(corner=(31.725mm, -0.25mm, -1.475mm), size=(1.45mm, 1mm, 0.105mm))
  C66_2 = box(corner=(31.725mm, 1.65mm, -1.475mm), size=(1.45mm, 1mm, 0.105mm))
  C27_1 = box(corner=(-34.775mm, -0.25mm, -1.475mm), size=(1.45mm, 1mm, 0.105mm))
  C27_2 = box(corner=(-34.775mm, 1.65mm, -1.475mm), size=(1.45mm, 1mm, 0.105mm))
  C34_1 = box(corner=(-18.975mm, -0.25mm, -1.475mm), size=(1.45mm, 1mm, 0.105mm))
  C34_2 = box(corner=(-18.975mm, 1.65mm, -1.475mm), size=(1.45mm, 1mm, 0.105mm))
  C31_1 = box(corner=(-14.175mm, -0.25mm, -1.475mm), size=(1.45mm, 1mm, 0.105mm))
  C31_2 = box(corner=(-14.175mm, 1.65mm, -1.475mm), size=(1.45mm, 1mm, 0.105mm))
  C68_1 = box(corner=(28.525mm, -0.25mm, -1.475mm), size=(1.45mm, 1mm, 0.105mm))
  C68_2 = box(corner=(28.525mm, 1.65mm, -1.475mm), size=(1.45mm, 1mm, 0.105mm))
  C64_1 = box(corner=(17.525mm, -0.25mm, -1.475mm), size=(1.45mm, 1mm, 0.105mm))
  C64_2 = box(corner=(17.525mm, 1.65mm, -1.475mm), size=(1.45mm, 1mm, 0.105mm))
  C62_1 = box(corner=(14.325mm, -0.25mm, -1.475mm), size=(1.45mm, 1mm, 0.105mm))
  C62_2 = box(corner=(14.325mm, 1.65mm, -1.475mm), size=(1.45mm, 1mm, 0.105mm))
  C30_1 = box(corner=(-29.975mm, -0.25mm, -1.475mm), size=(1.45mm, 1mm, 0.105mm))
  C30_2 = box(corner=(-29.975mm, 1.65mm, -1.475mm), size=(1.45mm, 1mm, 0.105mm))
  C33_1 = box(corner=(-17.375mm, -0.25mm, -1.475mm), size=(1.45mm, 1mm, 0.105mm))
  C33_2 = box(corner=(-17.375mm, 1.65mm, -1.475mm), size=(1.45mm, 1mm, 0.105mm))
  J_DCN = box(corner=(2.5mm, -22.3mm, -1.475mm), size=(7mm, 7mm, 0.105mm))
  C67_1 = box(corner=(30.125mm, -0.25mm, -1.475mm), size=(1.45mm, 1mm, 0.105mm))
  C67_2 = box(corner=(30.125mm, 1.65mm, -1.475mm), size=(1.45mm, 1mm, 0.105mm))
  C61_1 = box(corner=(12.725mm, -0.25mm, -1.475mm), size=(1.45mm, 1mm, 0.105mm))
  C61_2 = box(corner=(12.725mm, 1.65mm, -1.475mm), size=(1.45mm, 1mm, 0.105mm))
  C63_1 = box(corner=(15.925mm, -0.25mm, -1.475mm), size=(1.45mm, 1mm, 0.105mm))
  C63_2 = box(corner=(15.925mm, 1.65mm, -1.475mm), size=(1.45mm, 1mm, 0.105mm))
  C32_1 = box(corner=(-15.775mm, -0.25mm, -1.475mm), size=(1.45mm, 1mm, 0.105mm))
  C32_2 = box(corner=(-15.775mm, 1.65mm, -1.475mm), size=(1.45mm, 1mm, 0.105mm))
  C29_1 = box(corner=(-31.575mm, -0.25mm, -1.475mm), size=(1.45mm, 1mm, 0.105mm))
  C29_2 = box(corner=(-31.575mm, 1.65mm, -1.475mm), size=(1.45mm, 1mm, 0.105mm))
  C28_1 = box(corner=(-33.175mm, -0.25mm, -1.475mm), size=(1.45mm, 1mm, 0.105mm))
  C28_2 = box(corner=(-33.175mm, 1.65mm, -1.475mm), size=(1.45mm, 1mm, 0.105mm))
  J_DCP = box(corner=(-9.5mm, -22.3mm, -1.475mm), size=(7mm, 7mm, 0.105mm))
  P8_DCP_L1.unite(P9_DCP_L1, P10_DCP_L1, P11_DCP_L1, P12_DCP_L1, P13_DCP_L1, P14_DCP_L3, P15_DCP_L4, P16_DCP_L4, P17_DCP_L4, P18_DCP_L4, V0_DCP, V1_DCP, V2_DCP, V3_DCP, V4_DCP, V5_DCP, V6_DCP, V7_DCP, V8_DCP, V9_DCP, V10_DCP, V11_DCP, V12_DCP, V13_DCP, V14_DCP, V15_DCP, V16_DCP, V17_DCP, V18_DCP, V19_DCP, V20_DCP, V21_DCP, V22_DCP, V23_DCP, V24_DCP, V25_DCP, V26_DCP, V27_DCP, V28_DCP, V29_DCP, V30_DCP, V31_DCP, V32_DCP, V33_DCP, V34_DCP, V35_DCP, V36_DCP, V37_DCP, V38_DCP, V39_DCP, V40_DCP, V41_DCP, V42_DCP, V43_DCP, V44_DCP, V45_DCP, V46_DCP, V47_DCP, V48_DCP, V49_DCP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)
  P8_DCP_L1.separate_bodies()
  P0_DCN_L1.unite(P1_DCN_L1, P2_DCN_L2, P3_DCN_L4, P4_DCN_L4, P5_DCN_L4, P6_DCN_L4, P7_DCN_L4, V164_DCN, V165_DCN, V166_DCN, V167_DCN, V168_DCN, V169_DCN, V170_DCN, V171_DCN, V172_DCN, V173_DCN, V174_DCN, V175_DCN, V176_DCN, V177_DCN, V178_DCN, V179_DCN, V180_DCN, V181_DCN, V182_DCN, V183_DCN, V184_DCN, V185_DCN, V186_DCN, V187_DCN, V188_DCN, V189_DCN, V190_DCN, V191_DCN, V192_DCN, V193_DCN, V194_DCN, V195_DCN, V196_DCN, V197_DCN, V198_DCN, V199_DCN, V200_DCN, V201_DCN, V202_DCN, V203_DCN, V204_DCN, V205_DCN, V206_DCN, V207_DCN, V208_DCN, V209_DCN, V210_DCN, V211_DCN, V212_DCN, V213_DCN, V214_DCN, V215_DCN, V216_DCN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)
  P0_DCN_L1.separate_bodies()
boundaries and excitations:
  DCP: SignalNet Objects=P8_DCP_L1
  DCN: SignalNet Objects=P0_DCN_L1
  BankN_1: Source Faces=P0_DCN_L1.face(at (-27, -9.15, 0.275), at (-27, -1.95, 0.275), at (-33, -9.15, 0.275), at (-33, -1.95, 0.275)) TerminalType=ConstantVoltage Net=DCN
  BankN_2: Source Faces=P0_DCN_L1.face(at (-9, -1.95, 0.275), at (-15, -1.95, 0.275), at (-21, -1.95, 0.275), at (-15, -9.15, 0.275), at (-21, -9.15, 0.275)) TerminalType=ConstantVoltage Net=DCN
  BankN_3: Source Faces=P0_DCN_L1.face(at (15, -1.95, 0.275), at (21, -1.95, 0.275), at (15, -9.15, 0.275), at (21, -9.15, 0.275), at (9, -1.95, 0.275)) TerminalType=ConstantVoltage Net=DCN
  BankN_4: Source Faces=P0_DCN_L1.face(at (33, -1.95, 0.275), at (27, -9.15, 0.275), at (27, -1.95, 0.275), at (33, -9.15, 0.275)) TerminalType=ConstantVoltage Net=DCN
  BankN_C: Source Faces=P0_DCN_L1.face(at (-3, -1.95, 0.275), at (3, -1.95, 0.275)) TerminalType=ConstantVoltage Net=DCN
  BankP_1: Source Faces=P8_DCP_L1.face(at (-27, -14.25, 0.275), at (-27, -7.05, 0.275), at (-33, -14.25, 0.275), at (-33, -7.05, 0.275)) TerminalType=ConstantVoltage Net=DCP
  BankP_2: Source Faces=P8_DCP_L1.face(at (-9, -7.05, 0.275), at (-15, -7.05, 0.275), at (-21, -7.05, 0.275), at (-15, -14.25, 0.275), at (-21, -14.25, 0.275)) TerminalType=ConstantVoltage Net=DCP
  BankP_3: Source Faces=P8_DCP_L1.face(at (15, -7.05, 0.275), at (21, -7.05, 0.275), at (15, -14.25, 0.275), at (21, -14.25, 0.275), at (9, -7.05, 0.275)) TerminalType=ConstantVoltage Net=DCP
  BankP_4: Source Faces=P8_DCP_L1.face(at (33, -7.05, 0.275), at (27, -14.25, 0.275), at (27, -7.05, 0.275), at (33, -14.25, 0.275)) TerminalType=ConstantVoltage Net=DCP
  BankP_C: Source Faces=P8_DCP_L1.face(at (-3, -7.05, 0.275), at (3, -7.05, 0.275)) TerminalType=ConstantVoltage Net=DCP
  CapN_1: Source Faces=P0_DCN_L1.face(at (-35.65, 0.25, 0.275), at (-34.05, 0.25, 0.275), at (-29.25, 0.25, 0.275), at (-37.25, 0.25, 0.275), at (-32.45, 0.25, 0.275), at (-30.85, 0.25, 0.275)) TerminalType=ConstantVoltage Net=DCN
  CapN_2: Source Faces=P0_DCN_L1.face(at (-10.25, 0.25, 0.275), at (-16.65, 0.25, 0.275), at (-18.25, 0.25, 0.275), at (-11.85, 0.25, 0.275), at (-15.05, 0.25, 0.275), at (-13.45, 0.25, 0.275)) TerminalType=ConstantVoltage Net=DCN
  CapN_3: Source Faces=P0_DCN_L1.face(at (13.45, 0.25, 0.275), at (15.05, 0.25, 0.275), at (11.85, 0.25, 0.275), at (10.25, 0.25, 0.275), at (16.65, 0.25, 0.275), at (18.25, 0.25, 0.275)) TerminalType=ConstantVoltage Net=DCN
  CapN_4: Source Faces=P0_DCN_L1.face(at (35.65, 0.25, 0.275), at (37.25, 0.25, 0.275), at (32.45, 0.25, 0.275), at (29.25, 0.25, 0.275), at (34.05, 0.25, 0.275), at (30.85, 0.25, 0.275)) TerminalType=ConstantVoltage Net=DCN
  CapNb_1: Source Faces=P0_DCN_L1.face(at (-34.05, 0.25, -1.475), at (-29.25, 0.25, -1.475), at (-30.85, 0.25, -1.475), at (-32.45, 0.25, -1.475)) TerminalType=ConstantVoltage Net=DCN
  CapNb_2: Source Faces=P0_DCN_L1.face(at (-18.25, 0.25, -1.475), at (-13.45, 0.25, -1.475), at (-16.65, 0.25, -1.475), at (-15.05, 0.25, -1.475)) TerminalType=ConstantVoltage Net=DCN
  CapNb_3: Source Faces=P0_DCN_L1.face(at (18.25, 0.25, -1.475), at (15.05, 0.25, -1.475), at (13.45, 0.25, -1.475), at (16.65, 0.25, -1.475)) TerminalType=ConstantVoltage Net=DCN
  CapNb_4: Source Faces=P0_DCN_L1.face(at (34.05, 0.25, -1.475), at (32.45, 0.25, -1.475), at (29.25, 0.25, -1.475), at (30.85, 0.25, -1.475)) TerminalType=ConstantVoltage Net=DCN
  CapP_1: Source Faces=P8_DCP_L1.face(at (-35.65, 2.15, 0.275), at (-34.05, 2.15, 0.275), at (-29.25, 2.15, 0.275), at (-37.25, 2.15, 0.275), at (-32.45, 2.15, 0.275), at (-30.85, 2.15, 0.275)) TerminalType=ConstantVoltage Net=DCP
  CapP_2: Source Faces=P8_DCP_L1.face(at (-10.25, 2.15, 0.275), at (-16.65, 2.15, 0.275), at (-18.25, 2.15, 0.275), at (-11.85, 2.15, 0.275), at (-15.05, 2.15, 0.275), at (-13.45, 2.15, 0.275)) TerminalType=ConstantVoltage Net=DCP
  CapP_3: Source Faces=P8_DCP_L1.face(at (13.45, 2.15, 0.275), at (15.05, 2.15, 0.275), at (11.85, 2.15, 0.275), at (10.25, 2.15, 0.275), at (16.65, 2.15, 0.275), at (18.25, 2.15, 0.275)) TerminalType=ConstantVoltage Net=DCP
  CapP_4: Source Faces=P8_DCP_L1.face(at (35.65, 2.15, 0.275), at (37.25, 2.15, 0.275), at (32.45, 2.15, 0.275), at (29.25, 2.15, 0.275), at (34.05, 2.15, 0.275), at (30.85, 2.15, 0.275)) TerminalType=ConstantVoltage Net=DCP
  CapPb_1: Source Faces=P8_DCP_L1.face(at (-34.05, 2.15, -1.475), at (-29.25, 2.15, -1.475), at (-30.85, 2.15, -1.475), at (-32.45, 2.15, -1.475)) TerminalType=ConstantVoltage Net=DCP
  CapPb_2: Source Faces=P8_DCP_L1.face(at (-18.25, 2.15, -1.475), at (-13.45, 2.15, -1.475), at (-16.65, 2.15, -1.475), at (-15.05, 2.15, -1.475)) TerminalType=ConstantVoltage Net=DCP
  CapPb_3: Source Faces=P8_DCP_L1.face(at (18.25, 2.15, -1.475), at (15.05, 2.15, -1.475), at (13.45, 2.15, -1.475), at (16.65, 2.15, -1.475)) TerminalType=ConstantVoltage Net=DCP
  CapPb_4: Source Faces=P8_DCP_L1.face(at (34.05, 2.15, -1.475), at (32.45, 2.15, -1.475), at (29.25, 2.15, -1.475), at (30.85, 2.15, -1.475)) TerminalType=ConstantVoltage Net=DCP
  J_DCN: Sink Faces=P0_DCN_L1.face(at (6, -18.8, -1.475)) TerminalType=ConstantVoltage Net=DCN
  J_DCP: Sink Faces=P8_DCP_L1.face(at (-6, -18.8, -1.475)) TerminalType=ConstantVoltage Net=DCP
setups:
  Setup1: Matrix AdaptiveFreq=1MHz Cap{MaxPass=1 MinPass=1 MinConvPass=1 PerError=30 PerRefine=30 AutoIncreaseAccuracy AccuracyLevel=High Solver_Type=Iterative} DC{SolveResOnly Cond{MaxPass=3 MinPass=1 MinConvPass=1 PerError=5 PerRefine=30} Mult{MaxPass=1 MinPass=1 MinConvPass=1 PerError=1 PerRefine=30} AccuracyLevel=Normal} AC{MaxPass=8 MinPass=2 MinConvPass=1 PerError=2 PerRefine=30 ACRLSolverType=ACA} ErrorValue=0.1
source amplitudes:
  DCN:BankN_1: AC R/L Fields 1A
  DCN:BankN_2, DCN:BankN_3, DCN:BankN_4, DCN:BankN_C, DCN:CapN_1..DCN:CapN_4, DCN:CapNb_1..DCN:CapNb_4, DCP:BankP_1..DCP:BankP_4, DCP:BankP_C, DCP:CapP_1..DCP:CapP_4, DCP:CapPb_1..DCP:CapPb_4: AC R/L Fields 0A
  DCN: CG Fields 0V 0deg
  DCP: CG Fields 1V 0deg
  DCN:BankN_1: DC R/L Fields 1A
  DCN:BankN_2, DCN:BankN_3, DCN:BankN_4, DCN:BankN_C, DCN:CapN_1..DCN:CapN_4, DCN:CapNb_1..DCN:CapNb_4, DCP:BankP_1..DCP:BankP_4, DCP:BankP_C, DCP:CapP_1..DCP:CapP_4, DCP:CapPb_1..DCP:CapPb_4: DC R/L Fields 0A
