* DPT 1 uH/80 V study, case DIE2_LOW_V20_R1p5_s0 (generated from revb_q3d_spice.netlist): Leg board 'dpt': double-pulse test with the Q3D copper BB_PL_LOOP_dpt_swv1 (30 branches, 428 couplings)
.param VBUS=20 IPK=322 TON1=2.56e-06 LLOAD=1e-06
.param RGON=3.5 RGOFF=0 RPU=0.85 RPD=0.35 VDRV=5 VOFF=-1.9 LGO=1.2n LGK=0.5n
.param TSTART=0.5u TOFF=7.5e-07 TON2=3e-07
.param T1={TSTART+TON1} T2={T1+TOFF} TEND={T2+TON2+0.3u}
.include ../../LMG1210-EPC2361/EPC2361.lib
.model DID D(Ron=1m Roff=1G Vfwd=0)
.subckt BB_PL_LOOP_dpt_swv1 CapN_1 CapN_2 CapN_3 CapN_4 CapNb_1 CapNb_2 CapNb_3 CapNb_4 CapP_1 CapP_2 CapP_3 CapP_4 CapPb_1 CapPb_2 CapPb_3 CapPb_4 QH_D_1 QH_D_2 QH_D_3 QH_D_4 QH_S_1 QH_S_2 QH_S_3 QH_S_4 QL_D_1 QL_D_2 QL_D_3 QL_D_4 QL_S_1 QL_S_2 QL_S_3 QL_S_4 RSI_1 RSI_2 RSI_3 RSI_4 RSN_1 RSN_2 RSN_3 RSN_4
* Q3D AC partial inductance (100 MHz, K for every mutual) and full DC resistance matrix,
* branch = source terminal -> net sink
L0 QL_D_1 m0 0.06159817n
B0 m0 QH_S_1 V=0.000140405*I(L0)
L1 QL_D_2 m1 0.0639207769n
B1 m1 QH_S_2 V=0.000142117*I(L1)
L2 QL_D_3 m2 0.0616933478n
B2 m2 QH_S_3 V=0.000141037*I(L2)
L3 QL_D_4 m3 0.0637872859n
B3 m3 QH_S_4 V=0.00014343*I(L3)
L4 CapN_2 m4 2.25057002n
B4 m4 CapN_1 V=0.000248352*I(L4)+0.000237124*I(L5)+0.000236997*I(L6)+8.121e-06*I(L7)+0.00024035*I(L8)+0.000237109*I(L9)+0.000236997*I(L10)+2.79012e-05*I(L11)+0.000230008*I(L12)+0.000235153*I(L13)+0.000236992*I(L14)
L5 CapN_3 m5 4.22853901n
B5 m5 CapN_1 V=0.000237124*I(L4)+0.000532813*I(L5)+0.000521783*I(L6)+8.12801e-06*I(L7)+0.000234843*I(L8)+0.000527055*I(L9)+0.000521776*I(L10)+2.81957e-05*I(L11)+0.000329554*I(L12)+0.000418102*I(L13)+0.000521484*I(L14)
L6 CapN_4 m6 6.57387406n
B6 m6 CapN_1 V=0.000236997*I(L4)+0.000521783*I(L5)+0.000758795*I(L6)+8.1281e-06*I(L7)+0.000234731*I(L8)+0.000523978*I(L9)+0.000750774*I(L10)+2.82e-05*I(L11)+0.000331291*I(L12)+0.000424754*I(L13)+0.000729845*I(L14)
L7 CapNb_1 m7 0.215704805n
B7 m7 CapN_1 V=8.121e-06*I(L4)+8.12801e-06*I(L5)+8.1281e-06*I(L6)+6.98535e-05*I(L7)+8.12324e-06*I(L8)+8.12802e-06*I(L9)+8.1281e-06*I(L10)+7.7824e-06*I(L11)+8.13304e-06*I(L12)+8.1294e-06*I(L13)+8.1281e-06*I(L14)
L8 CapNb_2 m8 2.41050221n
B8 m8 CapN_1 V=0.00024035*I(L4)+0.000234843*I(L5)+0.000234731*I(L6)+8.12324e-06*I(L7)+0.000301892*I(L8)+0.00023483*I(L9)+0.000234731*I(L10)+2.79162e-05*I(L11)+0.000228505*I(L12)+0.0002331*I(L13)+0.000234727*I(L14)
L9 CapNb_3 m9 4.42929562n
B9 m9 CapN_1 V=0.000237109*I(L4)+0.000527055*I(L5)+0.000523978*I(L6)+8.12802e-06*I(L7)+0.00023483*I(L8)+0.000591175*I(L9)+0.000523974*I(L10)+2.81962e-05*I(L11)+0.000329759*I(L12)+0.000418839*I(L13)+0.000523696*I(L14)
L10 CapNb_4 m10 6.72891957n
B10 m10 CapN_1 V=0.000236997*I(L4)+0.000521776*I(L5)+0.000750774*I(L6)+8.1281e-06*I(L7)+0.000234731*I(L8)+0.000523974*I(L9)+0.000812449*I(L10)+2.82e-05*I(L11)+0.000331293*I(L12)+0.000424759*I(L13)+0.000729519*I(L14)
L11 RSN_1 m11 0.457071825n
B11 m11 CapN_1 V=2.79012e-05*I(L4)+2.81957e-05*I(L5)+2.82e-05*I(L6)+7.7824e-06*I(L7)+2.79162e-05*I(L8)+2.81962e-05*I(L9)+2.82e-05*I(L10)+0.000377099*I(L11)+2.84358e-05*I(L12)+2.82623e-05*I(L13)+2.82001e-05*I(L14)
L12 RSN_2 m12 2.63112048n
B12 m12 CapN_1 V=0.000230008*I(L4)+0.000329554*I(L5)+0.000331291*I(L6)+8.13304e-06*I(L7)+0.000228505*I(L8)+0.000329759*I(L9)+0.000331293*I(L10)+2.84358e-05*I(L11)+0.000433741*I(L12)+0.000356651*I(L13)+0.000331352*I(L14)
L13 RSN_3 m13 3.94354081n
B13 m13 CapN_1 V=0.000235153*I(L4)+0.000418102*I(L5)+0.000424754*I(L6)+8.1294e-06*I(L7)+0.0002331*I(L8)+0.000418839*I(L9)+0.000424759*I(L10)+2.82623e-05*I(L11)+0.000356651*I(L12)+0.000528305*I(L13)+0.000424987*I(L14)
L14 RSN_4 m14 6.95719273n
B14 m14 CapN_1 V=0.000236992*I(L4)+0.000521484*I(L5)+0.000729845*I(L6)+8.1281e-06*I(L7)+0.000234727*I(L8)+0.000523696*I(L9)+0.000729519*I(L10)+2.82001e-05*I(L11)+0.000331352*I(L12)+0.000424987*I(L13)+0.0010711*I(L14)
L15 CapP_2 m15 2.54090354n
B15 m15 CapP_1 V=0.000544725*I(L15)+0.000482336*I(L16)+0.000482333*I(L17)+4.6023e-05*I(L18)+0.000498541*I(L19)+0.000482335*I(L20)+0.000482333*I(L21)+1.01822e-06*I(L22)+0.000543709*I(L23)+0.000482336*I(L24)+0.000482333*I(L25)
L16 CapP_3 m16 6.79653335n
B16 m16 CapP_1 V=0.000482336*I(L15)+0.00133946*I(L16)+0.00127673*I(L17)+4.60194e-05*I(L18)+0.000479303*I(L19)+0.00129587*I(L20)+0.00127673*I(L21)+1.01858e-06*I(L22)+0.000482506*I(L23)+0.00133827*I(L24)+0.00127673*I(L25)
L17 CapP_4 m17 9.20449398n
B17 m17 CapP_1 V=0.000482333*I(L15)+0.00127673*I(L16)+0.0017587*I(L17)+4.60194e-05*I(L18)+0.0004793*I(L19)+0.00127923*I(L20)+0.00171252*I(L21)+1.01858e-06*I(L22)+0.000482503*I(L23)+0.00127656*I(L24)+0.0017577*I(L25)
L18 CapPb_1 m18 0.224455746n
B18 m18 CapP_1 V=4.6023e-05*I(L15)+4.60194e-05*I(L16)+4.60194e-05*I(L17)+5.26604e-05*I(L18)+4.60231e-05*I(L19)+4.60194e-05*I(L20)+4.60194e-05*I(L21)+1.06372e-06*I(L22)+4.6023e-05*I(L23)+4.60194e-05*I(L24)+4.60194e-05*I(L25)
L19 CapPb_2 m19 2.39712513n
B19 m19 CapP_1 V=0.000498541*I(L15)+0.000479303*I(L16)+0.0004793*I(L17)+4.60231e-05*I(L18)+0.000505373*I(L19)+0.000479303*I(L20)+0.0004793*I(L21)+1.01821e-06*I(L22)+0.000498582*I(L23)+0.000479303*I(L24)+0.0004793*I(L25)
L20 CapPb_3 m20 6.69188509n
B20 m20 CapP_1 V=0.000482335*I(L15)+0.00129587*I(L16)+0.00127923*I(L17)+4.60194e-05*I(L18)+0.000479303*I(L19)+0.00130506*I(L20)+0.00127923*I(L21)+1.01858e-06*I(L22)+0.000482506*I(L23)+0.00129575*I(L24)+0.00127923*I(L25)
L21 CapPb_4 m21 9.04357435n
B21 m21 CapP_1 V=0.000482333*I(L15)+0.00127673*I(L16)+0.00171252*I(L17)+4.60194e-05*I(L18)+0.0004793*I(L19)+0.00127923*I(L20)+0.00171934*I(L21)+1.01858e-06*I(L22)+0.000482503*I(L23)+0.00127657*I(L24)+0.00171256*I(L25)
L22 QH_D_1 m22 0.0222232783n
B22 m22 CapP_1 V=1.01822e-06*I(L15)+1.01858e-06*I(L16)+1.01858e-06*I(L17)+1.06372e-06*I(L18)+1.01821e-06*I(L19)+1.01858e-06*I(L20)+1.01858e-06*I(L21)+3.86492e-05*I(L22)+1.01822e-06*I(L23)+1.01858e-06*I(L24)+1.01858e-06*I(L25)
L23 QH_D_2 m23 2.56449076n
B23 m23 CapP_1 V=0.000543709*I(L15)+0.000482506*I(L16)+0.000482503*I(L17)+4.6023e-05*I(L18)+0.000498582*I(L19)+0.000482506*I(L20)+0.000482503*I(L21)+1.01822e-06*I(L22)+0.000582911*I(L23)+0.000482506*I(L24)+0.000482503*I(L25)
L24 QH_D_3 m24 6.8027586n
B24 m24 CapP_1 V=0.000482336*I(L15)+0.00133827*I(L16)+0.00127656*I(L17)+4.60194e-05*I(L18)+0.000479303*I(L19)+0.00129575*I(L20)+0.00127657*I(L21)+1.01858e-06*I(L22)+0.000482506*I(L23)+0.00137655*I(L24)+0.00127656*I(L25)
L25 QH_D_4 m25 9.22794204n
B25 m25 CapP_1 V=0.000482333*I(L15)+0.00127673*I(L16)+0.0017577*I(L17)+4.60194e-05*I(L18)+0.0004793*I(L19)+0.00127923*I(L20)+0.00171256*I(L21)+1.01858e-06*I(L22)+0.000482503*I(L23)+0.00127656*I(L24)+0.00179627*I(L25)
L26 QL_S_1 m26 0.0105162734n
B26 m26 RSI_1 V=4.72692e-05*I(L26)
L27 QL_S_2 m27 0.00994935139n
B27 m27 RSI_2 V=4.72769e-05*I(L27)
L28 QL_S_3 m28 0.0104797647n
B28 m28 RSI_3 V=4.77649e-05*I(L28)
L29 QL_S_4 m29 0.00997903348n
B29 m29 RSI_4 V=4.67382e-05*I(L29)
K0_1 L0 L1 0.000524372
K0_2 L0 L2 0.000104761
K0_3 L0 L3 0.000050302
K0_4 L0 L4 0.002743158
K0_5 L0 L5 0.002526932
K0_6 L0 L6 0.002028193
K0_7 L0 L7 0.000695099
K0_8 L0 L8 0.002669659
K0_9 L0 L9 0.002477156
K0_10 L0 L10 0.002007234
K0_11 L0 L11 0.162110016
K0_12 L0 L12 0.003628247
K0_13 L0 L13 0.002810999
K0_14 L0 L14 0.002030564
K0_15 L0 L15 0.002500046
K0_16 L0 L16 0.001773681
K0_17 L0 L17 0.001516011
K0_18 L0 L18 0.001298476
K0_19 L0 L19 0.002548629
K0_20 L0 L20 0.001783940
K0_21 L0 L21 0.001528055
K0_22 L0 L22 0.000572796
K0_23 L0 L23 0.002536857
K0_24 L0 L24 0.001779589
K0_25 L0 L25 0.001516533
K0_26 L0 L26 -0.000106989
K0_27 L0 L27 -0.000119584
K0_28 L0 L28 -0.000032550
K0_29 L0 L29 -0.000018654
K1_2 L1 L2 0.001250855
K1_3 L1 L3 0.000105932
K1_4 L1 L4 -0.001921703
K1_5 L1 L5 0.037076236
K1_6 L1 L6 0.030369390
K1_7 L1 L7 0.000147470
K1_8 L1 L8 -0.001821146
K1_9 L1 L9 0.036378892
K1_10 L1 L10 0.030014949
K1_11 L1 L11 0.002464097
K1_12 L1 L12 0.059197302
K1_13 L1 L13 0.040831450
K1_14 L1 L14 0.029643548
K1_15 L1 L15 -0.001961056
K1_16 L1 L16 0.024558160
K1_17 L1 L17 0.021492244
K1_18 L1 L18 -0.000029715
K1_19 L1 L19 -0.001612285
K1_20 L1 L20 0.024747726
K1_21 L1 L21 0.021677711
K1_22 L1 L22 0.000465774
K1_23 L1 L23 -0.002109705
K1_24 L1 L24 0.024631498
K1_25 L1 L25 0.021470550
K1_26 L1 L26 -0.000120188
K1_27 L1 L27 0.000339846
K1_28 L1 L28 -0.000312759
K1_29 L1 L29 -0.000015349
K2_3 L2 L3 0.000553995
K2_4 L2 L4 -0.001048557
K2_5 L2 L5 -0.040311225
K2_6 L2 L6 -0.031463773
K2_8 L2 L8 -0.000794649
K2_9 L2 L9 -0.039370813
K2_10 L2 L10 -0.031079349
K2_11 L2 L11 0.000508335
K2_12 L2 L12 0.002082583
K2_13 L2 L13 0.009520947
K2_14 L2 L14 -0.029921062
K2_15 L2 L15 -0.000706137
K2_16 L2 L16 -0.026681221
K2_17 L2 L17 -0.022112762
K2_18 L2 L18 -0.000019611
K2_19 L2 L19 -0.000721307
K2_20 L2 L20 -0.026703604
K2_21 L2 L21 -0.022318831
K2_22 L2 L22 0.000103956
K2_23 L2 L23 -0.000563061
K2_24 L2 L24 -0.026741608
K2_25 L2 L25 -0.022059583
K2_26 L2 L26 -0.000011584
K2_27 L2 L27 -0.000313413
K2_28 L2 L28 0.000600247
K2_29 L2 L29 -0.000122840
K3_4 L3 L4 -0.000023981
K3_5 L3 L5 -0.000570386
K3_6 L3 L6 -0.002323905
K3_7 L3 L7 0.000010472
K3_8 L3 L8 -0.000010831
K3_9 L3 L9 -0.000544327
K3_10 L3 L10 -0.002137398
K3_11 L3 L11 0.000234551
K3_12 L3 L12 0.000217847
K3_13 L3 L13 0.000324580
K3_14 L3 L14 0.040083444
K3_15 L3 L15 -0.000029557
K3_16 L3 L16 -0.000321228
K3_17 L3 L17 -0.001805164
K3_18 L3 L18 -0.000023735
K3_19 L3 L19 -0.000036756
K3_20 L3 L20 -0.000337134
K3_21 L3 L21 -0.001543766
K3_22 L3 L22 0.000047679
K3_23 L3 L23 -0.000018173
K3_24 L3 L24 -0.000290463
K3_25 L3 L25 -0.001772026
K3_26 L3 L26 -0.000012539
K3_27 L3 L27 -0.000028380
K3_28 L3 L28 -0.000128854
K3_29 L3 L29 -0.000626714
K4_5 L4 L5 0.738090625
K4_6 L4 L6 0.594958465
K4_7 L4 L7 0.040219281
K4_8 L4 L8 0.954188215
K4_9 L4 L9 0.721120134
K4_10 L4 L10 0.587951360
K4_11 L4 L11 0.028428190
K4_12 L4 L12 0.914286798
K4_13 L4 L13 0.762039693
K4_14 L4 L14 0.578198863
K4_15 L4 L15 0.600888605
K4_16 L4 L16 0.384458668
K4_17 L4 L17 0.332917482
K4_18 L4 L18 0.014366004
K4_19 L4 L19 0.614188589
K4_20 L4 L20 0.387422196
K4_21 L4 L21 0.335816799
K4_22 L4 L22 0.004007906
K4_23 L4 L23 0.597823454
K4_24 L4 L24 0.384216356
K4_25 L4 L25 0.332498988
K4_26 L4 L26 -0.000518008
K4_27 L4 L27 0.000530813
K4_28 L4 L28 0.000286376
K4_29 L4 L29 0.000088462
K5_6 L5 L6 0.809813289
K5_7 L5 L7 0.030564118
K5_8 L5 L8 0.706848623
K5_9 L5 L9 0.975276964
K5_10 L5 L10 0.800128030
K5_11 L5 L11 0.023230902
K5_12 L5 L12 0.780166098
K5_13 L5 L13 0.947384115
K5_14 L5 L14 0.786365010
K5_15 L5 L15 0.455547910
K5_16 L5 L16 0.581902428
K5_17 L5 L17 0.510962809
K5_18 L5 L18 0.011042642
K5_19 L5 L19 0.466192938
K5_20 L5 L20 0.586209264
K5_21 L5 L21 0.515369661
K5_22 L5 L22 0.003397805
K5_23 L5 L23 0.457009715
K5_24 L5 L24 0.579274551
K5_25 L5 L25 0.510295084
K5_26 L5 L26 -0.000512140
K5_27 L5 L27 -0.009993327
K5_28 L5 L28 0.010727649
K5_29 L5 L29 0.000221447
K6_7 L6 L7 0.024865862
K6_8 L6 L8 0.569827875
K6_9 L6 L9 0.795078748
K6_10 L6 L10 0.983772403
K6_11 L6 L11 0.018647936
K6_12 L6 L12 0.630048681
K6_13 L6 L13 0.772247739
K6_14 L6 L14 0.966340662
K6_15 L6 L15 0.368253585
K6_16 L6 L16 0.478833179
K6_17 L6 L17 0.605612208
K6_18 L6 L18 0.009049550
K6_19 L6 L19 0.376917942
K6_20 L6 L20 0.483966069
K6_21 L6 L21 0.609522310
K6_22 L6 L22 0.002758109
K6_23 L6 L23 0.369471371
K6_24 L6 L24 0.476831852
K6_25 L6 L25 0.604685663
K6_26 L6 L26 -0.000414032
K6_27 L6 L27 -0.008192340
K6_28 L6 L28 0.008436239
K6_29 L6 L29 0.000601208
K7_8 L7 L8 0.065101012
K7_9 L7 L9 0.036558594
K7_10 L7 L10 0.028537156
K7_11 L7 L11 0.048936819
K7_12 L7 L12 0.037909322
K7_13 L7 L13 0.031646766
K7_14 L7 L14 0.024193295
K7_15 L7 L15 0.060669391
K7_16 L7 L16 0.043566757
K7_17 L7 L17 0.038585676
K7_18 L7 L18 0.353731535
K7_19 L7 L19 0.088066485
K7_20 L7 L20 0.049321700
K7_21 L7 L21 0.042347413
K7_22 L7 L22 0.005885165
K7_23 L7 L23 0.060425359
K7_24 L7 L24 0.043545834
K7_25 L7 L25 0.038538444
K7_26 L7 L26 -0.000174738
K7_27 L7 L27 -0.000046108
K8_9 L8 L9 0.693783480
K8_10 L8 L10 0.564741675
K8_11 L8 L11 0.027881272
K8_12 L8 L12 0.878125194
K8_13 L8 L13 0.730211993
K8_14 L8 L14 0.553796896
K8_15 L8 L15 0.562464795
K8_16 L8 L16 0.358197029
K8_17 L8 L17 0.310806135
K8_18 L8 L18 0.038927181
K8_19 L8 L19 0.607226460
K8_20 L8 L20 0.363502305
K8_21 L8 L21 0.314910797
K8_22 L8 L22 0.003975237
K8_23 L8 L23 0.559763322
K8_24 L8 L24 0.357981406
K8_25 L8 L25 0.310416467
K8_26 L8 L26 -0.000511171
K8_27 L8 L27 0.000513263
K8_28 L8 L28 0.000219846
K8_29 L8 L29 0.000081571
K9_10 L9 L10 0.789037691
K9_11 L9 L11 0.022758209
K9_12 L9 L12 0.762632607
K9_13 L9 L13 0.927266465
K9_14 L9 L14 0.772134819
K9_15 L9 L15 0.444327768
K9_16 L9 L16 0.569714167
K9_17 L9 L17 0.507301414
K9_18 L9 L18 0.017342103
K9_19 L9 L19 0.457844847
K9_20 L9 L20 0.588272183
K9_21 L9 L21 0.514589641
K9_22 L9 L22 0.003337282
K9_23 L9 L23 0.445774407
K9_24 L9 L24 0.567212234
K9_25 L9 L25 0.506642162
K9_26 L9 L26 -0.000503059
K9_27 L9 L27 -0.009805837
K9_28 L9 L28 0.010486585
K9_29 L9 L29 0.000209992
K10_11 L10 L11 0.018448508
K10_12 L10 L12 0.622641465
K10_13 L10 L13 0.763085399
K10_14 L10 L14 0.952873480
K10_15 L10 L15 0.363585091
K10_16 L10 L16 0.471864273
K10_17 L10 L17 0.591603427
K10_18 L10 L18 0.012828801
K10_19 L10 L19 0.373756948
K10_20 L10 L20 0.479672805
K10_21 L10 L21 0.605407394
K10_22 L10 L22 0.002730354
K10_23 L10 L23 0.364790190
K10_24 L10 L24 0.469890320
K10_25 L10 L25 0.590750069
K10_26 L10 L26 -0.000410068
K10_27 L10 L27 -0.008096702
K10_28 L10 L28 0.008330225
K10_29 L10 L29 0.000564910
K11_12 L11 L12 0.031621146
K11_13 L11 L13 0.024977040
K11_14 L11 L14 0.018400838
K11_15 L11 L15 -0.005618785
K11_16 L11 L16 -0.002261957
K11_17 L11 L17 -0.001969427
K11_18 L11 L18 0.007092712
K11_19 L11 L19 -0.005641815
K11_20 L11 L20 -0.002282581
K11_21 L11 L21 -0.001990628
K11_22 L11 L22 0.161649646
K11_23 L11 L23 -0.005358870
K11_24 L11 L24 -0.002229760
K11_25 L11 L25 -0.001955393
K11_26 L11 L26 -0.042877379
K11_27 L11 L27 -0.000576015
K11_28 L11 L28 -0.000130667
K11_29 L11 L29 -0.000057549
K12_13 L12 L13 0.811790887
K12_14 L12 L14 0.612596391
K12_15 L12 L15 0.560172051
K12_16 L12 L16 0.414187225
K12_17 L12 L17 0.359239747
K12_18 L12 L18 0.013510964
K12_19 L12 L19 0.573444269
K12_20 L12 L20 0.417394706
K12_21 L12 L21 0.362367432
K12_22 L12 L22 0.004711070
K12_23 L12 L23 0.563606143
K12_24 L12 L24 0.414144159
K12_25 L12 L25 0.358800235
K12_26 L12 L26 -0.000733786
K12_27 L12 L27 -0.015661636
K12_28 L12 L28 -0.000505600
K12_29 L12 L29 0.000029138
K13_14 L13 L14 0.750964882
K13_15 L13 L15 0.470141909
K13_16 L13 L16 0.555967466
K13_17 L13 L17 0.487078022
K13_18 L13 L18 0.011370379
K13_19 L13 L19 0.481141145
K13_20 L13 L20 0.560411606
K13_21 L13 L21 0.491295844
K13_22 L13 L22 0.003703018
K13_23 L13 L23 0.471937066
K13_24 L13 L24 0.556430388
K13_25 L13 L25 0.486483030
K13_26 L13 L26 -0.000576381
K13_27 L13 L27 -0.010971672
K13_28 L13 L28 -0.002304773
K13_29 L13 L29 0.000017021
K14_15 L14 L15 0.357892653
K14_16 L14 L16 0.465045889
K14_17 L14 L17 0.588986727
K14_18 L14 L18 0.008786041
K14_19 L14 L19 0.366311077
K14_20 L14 L20 0.470052204
K14_21 L14 L21 0.593107661
K14_22 L14 L22 0.002737782
K14_23 L14 L23 0.359089481
K14_24 L14 L24 0.463139097
K14_25 L14 L25 0.590339442
K14_26 L14 L26 -0.000417608
K14_27 L14 L27 -0.007995565
K14_28 L14 L28 0.008048271
K14_29 L14 L29 -0.010183057
K15_16 L15 L16 0.592196618
K15_17 L15 L17 0.511139640
K15_18 L15 L18 0.243938833
K15_19 L15 L19 0.954939723
K15_20 L15 L20 0.596150489
K15_21 L15 L21 0.515373642
K15_22 L15 L22 0.002726831
K15_23 L15 L23 0.995256371
K15_24 L15 L24 0.591887237
K15_25 L15 L25 0.510496437
K15_26 L15 L26 -0.000603916
K15_27 L15 L27 0.000595752
K15_28 L15 L28 0.000194484
K15_29 L15 L29 0.000048658
K16_17 L16 L17 0.850708397
K16_18 L16 L18 0.155151471
K16_19 L16 L19 0.604308064
K16_20 L16 L20 0.983353897
K16_21 L16 L21 0.857124649
K16_22 L16 L22 0.001850827
K16_23 L16 L23 0.591545147
K16_24 L16 L24 0.998194504
K16_25 L16 L25 0.849625505
K16_26 L16 L26 -0.000442824
K16_27 L16 L27 -0.006710325
K16_28 L16 L28 0.007248197
K16_29 L16 L29 0.000127681
K17_18 L17 L18 0.134329593
K17_19 L17 L19 0.522196824
K17_20 L17 L20 0.859893644
K17_21 L17 L21 0.987723443
K17_22 L17 L22 0.001620216
K17_23 L17 L23 0.510602629
K17_24 L17 L24 0.849208213
K17_25 L17 L25 0.998663404
K17_26 L17 L26 -0.000381619
K17_27 L17 L27 -0.005878628
K17_28 L17 L28 0.006000334
K17_29 L17 L29 0.000501042
K18_19 L18 L19 0.276534193
K18_20 L18 L20 0.161681350
K18_21 L18 L21 0.138883106
K18_22 L18 L22 0.021431866
K18_23 L18 L23 0.242837087
K18_24 L18 L24 0.155078329
K18_25 L18 L25 0.134160637
K18_26 L18 L26 -0.000317841
K19_20 L19 L20 0.610887032
K19_21 L19 L21 0.527920924
K19_22 L19 L22 0.002879157
K19_23 L19 L23 0.950994908
K19_24 L19 L24 0.603990773
K19_25 L19 L25 0.521539924
K19_26 L19 L26 -0.000621597
K19_27 L19 L27 0.000532159
K19_28 L19 L28 0.000199425
K19_29 L19 L29 0.000051386
K20_21 L20 L21 0.868777731
K20_22 L20 L22 0.001875873
K20_23 L20 L23 0.595495798
K20_24 L20 L24 0.981757051
K20_25 L20 L25 0.858800658
K20_26 L20 L26 -0.000445928
K20_27 L20 L27 -0.006762948
K20_28 L20 L28 0.007265869
K20_29 L20 L29 0.000129407
K21_22 L21 L22 0.001633553
K21_23 L21 L23 0.514832403
K21_24 L21 L24 0.855613284
K21_25 L21 L25 0.986560962
K21_26 L21 L26 -0.000384645
K21_27 L21 L27 -0.005929340
K21_28 L21 L28 0.006052574
K21_29 L21 L29 0.000462916
K22_23 L22 L23 0.002758724
K22_24 L22 L24 0.001855199
K22_25 L22 L25 0.001620710
K22_26 L22 L26 0.000029105
K22_27 L22 L27 -0.000105827
K22_28 L22 L28 -0.000026193
K22_29 L22 L29 -0.000012003
K23_24 L23 L24 0.591245623
K23_25 L23 L25 0.509960681
K23_26 L23 L26 -0.000612115
K23_27 L23 L27 0.000640715
K23_28 L23 L28 0.000158058
K23_29 L23 L29 0.000045768
K24_25 L24 L25 0.848128661
K24_26 L24 L26 -0.000444228
K24_27 L24 L27 -0.006729095
K24_28 L24 L28 0.007275319
K24_29 L24 L29 0.000120789
K25_26 L25 L26 -0.000381787
K25_27 L25 L27 -0.005872624
K25_28 L25 L28 0.005987098
K25_29 L25 L29 0.000500315
K26_27 L26 L27 0.000028949
K26_28 L26 L28 0.000011059
K27_28 L27 L28 0.000080882
K27_29 L27 L29 0.000011079
K28_29 L28 L29 0.000034609
.ends BB_PL_LOOP_dpt_swv1
.subckt SWNET n1 n2 n3 n4 nac
* AC block of BB_PL_LX_dpt_swv1, reference node n1 (QH_S_1), R matrix: dc
L0 n2 m0 40.2507172n
B0 m0 n1 V=0.00287937*I(L0)+0.00151088*I(L1)+0.00151011*I(L2)+0.00150987*I(L3)
L1 n3 m1 42.7302326n
B1 m1 n1 V=0.00151088*I(L0)+0.00289311*I(L1)+0.00153119*I(L2)+0.00152117*I(L3)
L2 n4 m2 59.7413784n
B2 m2 n1 V=0.00151011*I(L0)+0.00153119*I(L1)+0.00304927*I(L2)+0.00152146*I(L3)
L3 nac m3 29.5778622n
B3 m3 n1 V=0.00150987*I(L0)+0.00152117*I(L1)+0.00152146*I(L2)+0.00152416*I(L3)
K0_1 L0 L1 0.725461529
K0_2 L0 L2 0.583260439
K0_3 L0 L3 0.797867849
K1_2 L1 L2 0.615358684
K1_3 L1 L3 0.809643319
K2_3 L2 L3 0.710323706
.ends SWNET
XSW sw1 sw2 sw3 sw4 ACO SWNET
XCU CapN_1 CapN_2 CapN_3 CapN_4 CapNb_1 CapNb_2 CapNb_3 CapNb_4 CapP_1 CapP_2 CapP_3 CapP_4 CapPb_1 CapPb_2 CapPb_3 CapPb_4 QH_D_1 QH_D_2 QH_D_3 QH_D_4 QH_S_1 QH_S_2 QH_S_3 QH_S_4 QL_D_1 QL_D_2 QL_D_3 QL_D_4 QL_S_1 QL_S_2 QL_S_3 QL_S_4 RSI_1 RSI_2 RSI_3 RSI_4 RSN_1 RSN_2 RSN_3 RSN_4 BB_PL_LOOP_dpt_swv1
* supply, bank (20 x 22 uF, 127 uF eff.) behind L_b, load at the ac bolt
V1 VS 0 {VBUS}
Rchg VS BP 1k
Cbank BP BN 127u Rser=0.00014
Rgnd BN 0 1u
Lbp1 BP CapP_1 4n Rser=0.2m
Lbn1 BN CapN_1 4n Rser=0.2m
Lbp2 BP CapP_2 4n Rser=0.2m
Lbn2 BN CapN_2 4n Rser=0.2m
Lbp3 BP CapP_3 4n Rser=0.2m
Lbn3 BN CapN_3 4n Rser=0.2m
Lbp4 BP CapP_4 4n Rser=0.2m
Lbn4 BN CapN_4 4n Rser=0.2m
CCapP_1 CapP_1 CapN_1 1.068u Rser=0.0075 Lser=0.08n
CCapPb_1 CapPb_1 CapNb_1 0.712u Rser=0.01125 Lser=0.12n
Rsh1 RSI_1 rsx1 0.001
Lsh1 rsx1 RSN_1 0.12n
Lac1 QH_S_1 sw1 1p Rser=1u
CCapP_2 CapP_2 CapN_2 1.068u Rser=0.0075 Lser=0.08n
CCapPb_2 CapPb_2 CapNb_2 0.712u Rser=0.01125 Lser=0.12n
Rsh2 RSI_2 rsx2 0.001
Lsh2 rsx2 RSN_2 0.12n
Lac2 QH_S_2 sw2 1p Rser=1u
CCapP_3 CapP_3 CapN_3 1.068u Rser=0.0075 Lser=0.08n
CCapPb_3 CapPb_3 CapNb_3 0.712u Rser=0.01125 Lser=0.12n
Rsh3 RSI_3 rsx3 0.001
Lsh3 rsx3 RSN_3 0.12n
Lac3 QH_S_3 sw3 1p Rser=1u
CCapP_4 CapP_4 CapN_4 1.068u Rser=0.0075 Lser=0.08n
CCapPb_4 CapPb_4 CapNb_4 0.712u Rser=0.01125 Lser=0.12n
Rsh4 RSI_4 rsx4 0.001
Lsh4 rsx4 RSN_4 0.12n
Lac4 QH_S_4 sw4 1p Rser=1u
Lload ACO BP {LLOAD} Rser=2m Cpar=20p
VIH1 QH_D_1 dH1 0
VGH1 gH1 gH1i 0
XQH1 gH1i dH1 QH_S_1 EPC2361
VIL1 QL_D_1 dL1 0
VGL1 gL1 gL1i 0
XQL1 gL1i dL1 QL_S_1 EPC2361
VIH2 QH_D_2 dH2 0
VGH2 gH2 gH2i 0
XQH2 gH2i dH2 QH_S_2 EPC2361
VIL2 QL_D_2 dL2 0
VGL2 gL2 gL2i 0
XQL2 gL2i dL2 QL_S_2 EPC2361
VIH3 QH_D_3 dH3 0
VGH3 gH3 gH3i 0
XQH3 gH3i dH3 QH_S_3 EPC2361
VIL3 QL_D_3 dL3 0
VGL3 gL3 gL3i 0
XQL3 gL3i dL3 QL_S_3 EPC2361
VIH4 QH_D_4 dH4 0
VGH4 gH4 gH4i 0
XQH4 gH4i dH4 QH_S_4 EPC2361
VIL4 QL_D_4 dL4 0
VGL4 gL4 gL4i 0
XQL4 gL4i dL4 QL_S_4 EPC2361
VLOA loA KLA PWL(0 {VOFF} {TSTART} {VOFF} {TSTART+1n} {VDRV} {T1} {VDRV} {T1+1n} {VOFF} {T2} {VOFF} {T2+1n} {VDRV} {T2+TON2} {VDRV} {T2+TON2+1n} {VOFF})
RpuA loA loA1 {RPU}
DpuA loA1 DLA DID
DpdA DLA loA2 DID
RpdA loA2 loA {RPD}
VHOA hoA KHA {VOFF}
RphA hoA DHA {RPD}
* gate network A: extracted (gate_summary_dpt.json, bypass ESL 0.4 nH)
RonHA DHA stHAx 1.5
LconHA stHAx stHA 8.842n
DoffHA stHA stHAo DID
LcoffHA stHAo DHA 10.06n Rser=1m
RgH1 stHA grH1 0.5
LrgH1 grH1 gxH1 0.4n
LgbH1 gxH1 gH1 0.7644n
LkbH1 QH_S_1 kkH1 3.723n Rser=10m
BmH1 KHA kkH1 V=4.903e-11*ddt(I(VIL1))+-5.599e-11*ddt(I(VIL2))
RgH2 stHA grH2 0.5
LrgH2 grH2 gxH2 0.4n
LgbH2 gxH2 gH2 0.7999n
LkbH2 QH_S_2 kkH2 3.723n Rser=10m
BmH2 KHA kkH2 V=5.669e-11*ddt(I(VIL2))+-5.746e-11*ddt(I(VIL1))
RonLA DLA stLAx 1.5
LconLA stLAx stLA 5.469n
DoffLA stLA stLAo DID
LcoffLA stLAo DLA 6.846n Rser=1m
RgL1 stLA grL1 0.5
LrgL1 grL1 gxL1 0.4n
LgbL1 gxL1 gL1 3.505n
LkbL1 QL_S_1 kkL1 3.505n Rser=10m
KgkL1 LgbL1 LkbL1 -0.5800
BmL1 KLA kkL1 V=-1.082e-10*ddt(I(VIL1))+1.094e-10*ddt(I(VIL2))
RgL2 stLA grL2 0.5
LrgL2 grL2 gxL2 0.4n
LgbL2 gxL2 gL2 3.505n
LkbL2 QL_S_2 kkL2 3.505n Rser=10m
KgkL2 LgbL2 LkbL2 -0.5786
BmL2 KLA kkL2 V=-9.498e-11*ddt(I(VIL2))+9.882e-11*ddt(I(VIL1))
VLOB loB KLB PWL(0 {VOFF} {TSTART} {VOFF} {TSTART+1n} {VDRV} {T1} {VDRV} {T1+1n} {VOFF} {T2} {VOFF} {T2+1n} {VDRV} {T2+TON2} {VDRV} {T2+TON2+1n} {VOFF})
RpuB loB loB1 {RPU}
DpuB loB1 DLB DID
DpdB DLB loB2 DID
RpdB loB2 loB {RPD}
VHOB hoB KHB {VOFF}
RphB hoB DHB {RPD}
* gate network B: extracted (gate_summary_dpt.json, bypass ESL 0.4 nH)
RonHB DHB stHBx 1.5
LconHB stHBx stHB 8.842n
DoffHB stHB stHBo DID
LcoffHB stHBo DHB 10.06n Rser=1m
RgH3 stHB grH3 0.5
LrgH3 grH3 gxH3 0.4n
LgbH3 gxH3 gH3 0.7644n
LkbH3 QH_S_3 kkH3 3.723n Rser=10m
BmH3 KHB kkH3 V=4.903e-11*ddt(I(VIL3))+-5.599e-11*ddt(I(VIL4))
RgH4 stHB grH4 0.5
LrgH4 grH4 gxH4 0.4n
LgbH4 gxH4 gH4 0.7999n
LkbH4 QH_S_4 kkH4 3.723n Rser=10m
BmH4 KHB kkH4 V=5.669e-11*ddt(I(VIL4))+-5.746e-11*ddt(I(VIL3))
RonLB DLB stLBx 1.5
LconLB stLBx stLB 5.469n
DoffLB stLB stLBo DID
LcoffLB stLBo DLB 6.846n Rser=1m
RgL3 stLB grL3 0.5
LrgL3 grL3 gxL3 0.4n
LgbL3 gxL3 gL3 3.505n
LkbL3 QL_S_3 kkL3 3.505n Rser=10m
KgkL3 LgbL3 LkbL3 -0.5800
BmL3 KLB kkL3 V=-1.082e-10*ddt(I(VIL3))+1.094e-10*ddt(I(VIL4))
RgL4 stLB grL4 0.5
LrgL4 grL4 gxL4 0.4n
LgbL4 gxL4 gL4 3.505n
LkbL4 QL_S_4 kkL4 3.505n Rser=10m
KgkL4 LgbL4 LkbL4 -0.5786
BmL4 KLB kkL4 V=-9.498e-11*ddt(I(VIL4))+9.882e-11*ddt(I(VIL3))
.options plotwinsize=0
.tran 0 {TEND} 0 0.1n
.save I(Lload) I(VIL1) I(VIH1) V(QL_D_1) V(QL_S_1) V(QH_D_1) V(QH_S_1) V(dL1) V(dH1) V(gL1) V(gH1) I(VIL2) I(VIH2) V(QL_D_2) V(QL_S_2) V(QH_D_2) V(QH_S_2) V(dL2) V(dH2) V(gL2) V(gH2) I(VIL3) I(VIH3) V(QL_D_3) V(QL_S_3) V(QH_D_3) V(QH_S_3) V(dL3) V(dH3) V(gL3) V(gH3) I(VIL4) I(VIH4) V(QL_D_4) V(QL_S_4) V(QH_D_4) V(QH_S_4) V(dL4) V(dH4) V(gL4) V(gH4) V(BP) V(BN) V(CapP_1) V(CapP_2) V(CapP_3) V(CapP_4) V(CapN_1) V(CapN_2) V(CapN_3) V(CapN_4) I(Lac1) I(Lac2) I(Lac3) I(Lac4) V(RSI_1) V(RSI_2) V(RSI_3) V(RSI_4) I(VGH1) I(VGH2) I(VGH3) I(VGH4) I(VGL1) I(VGL2) I(VGL3) I(VGL4)
.meas TRAN Iload FIND I(Lload) AT {T1}
.meas TRAN I1 FIND I(VIL1) AT {T1}
.meas TRAN Vpk1 MAX V(dL1,QL_S_1) FROM {T1} TO {T1+150n}
.meas TRAN Eoff1 INTEG V(dL1,QL_S_1)*I(VIL1) FROM {T1} TO {T1+150n}
.meas TRAN Eon1 INTEG V(dL1,QL_S_1)*I(VIL1) FROM {T2} TO {T2+150n}
.meas TRAN Ionpk1 MAX I(VIL1) FROM {T2} TO {T2+150n}
.meas TRAN didton1 MAX D(I(VIL1)) FROM {T2} TO {T2+150n}
.meas TRAN didtoff1 MIN D(I(VIL1)) FROM {T1} TO {T1+150n}
.meas TRAN VHpk1 MAX V(dH1,QH_S_1) FROM {T2} TO {T2+150n}
.meas TRAN bump1 MAX V(gH1,QH_S_1) FROM {T2} TO {T2+150n}
.meas TRAN I2 FIND I(VIL2) AT {T1}
.meas TRAN Vpk2 MAX V(dL2,QL_S_2) FROM {T1} TO {T1+150n}
.meas TRAN Eoff2 INTEG V(dL2,QL_S_2)*I(VIL2) FROM {T1} TO {T1+150n}
.meas TRAN Eon2 INTEG V(dL2,QL_S_2)*I(VIL2) FROM {T2} TO {T2+150n}
.meas TRAN Ionpk2 MAX I(VIL2) FROM {T2} TO {T2+150n}
.meas TRAN didton2 MAX D(I(VIL2)) FROM {T2} TO {T2+150n}
.meas TRAN didtoff2 MIN D(I(VIL2)) FROM {T1} TO {T1+150n}
.meas TRAN VHpk2 MAX V(dH2,QH_S_2) FROM {T2} TO {T2+150n}
.meas TRAN bump2 MAX V(gH2,QH_S_2) FROM {T2} TO {T2+150n}
.meas TRAN I3 FIND I(VIL3) AT {T1}
.meas TRAN Vpk3 MAX V(dL3,QL_S_3) FROM {T1} TO {T1+150n}
.meas TRAN Eoff3 INTEG V(dL3,QL_S_3)*I(VIL3) FROM {T1} TO {T1+150n}
.meas TRAN Eon3 INTEG V(dL3,QL_S_3)*I(VIL3) FROM {T2} TO {T2+150n}
.meas TRAN Ionpk3 MAX I(VIL3) FROM {T2} TO {T2+150n}
.meas TRAN didton3 MAX D(I(VIL3)) FROM {T2} TO {T2+150n}
.meas TRAN didtoff3 MIN D(I(VIL3)) FROM {T1} TO {T1+150n}
.meas TRAN VHpk3 MAX V(dH3,QH_S_3) FROM {T2} TO {T2+150n}
.meas TRAN bump3 MAX V(gH3,QH_S_3) FROM {T2} TO {T2+150n}
.meas TRAN I4 FIND I(VIL4) AT {T1}
.meas TRAN Vpk4 MAX V(dL4,QL_S_4) FROM {T1} TO {T1+150n}
.meas TRAN Eoff4 INTEG V(dL4,QL_S_4)*I(VIL4) FROM {T1} TO {T1+150n}
.meas TRAN Eon4 INTEG V(dL4,QL_S_4)*I(VIL4) FROM {T2} TO {T2+150n}
.meas TRAN Ionpk4 MAX I(VIL4) FROM {T2} TO {T2+150n}
.meas TRAN didton4 MAX D(I(VIL4)) FROM {T2} TO {T2+150n}
.meas TRAN didtoff4 MIN D(I(VIL4)) FROM {T1} TO {T1+150n}
.meas TRAN VHpk4 MAX V(dH4,QH_S_4) FROM {T2} TO {T2+150n}
.meas TRAN bump4 MAX V(gH4,QH_S_4) FROM {T2} TO {T2+150n}
.end
