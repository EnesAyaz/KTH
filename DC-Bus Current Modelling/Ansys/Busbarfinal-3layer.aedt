# Ansys Electronics Desktop project, version 2024.2
materials:
  vacuum: permittivity=1
  copper: permeability=0.999991 conductivity=58000000
  polyethylene: permittivity=2.25 dielectric_loss_tangent=0.001
  aluminum: permeability=1.000021 conductivity=38000000
  steel_1008: permeability{HUnit=A_per_meter BUnit=tesla curve (0, 0) (159.2, 0.2402) (318.3, 0.8654) (477.5, 1.1106) (636.6, 1.2458) (795.8, 1.331) (1591.5, 1.5) (3183.1, 1.6) (4774.6, 1.683) (6366.2, 1.741) (7957.7, 1.78) (15915.5, 1.905) (31831, 2.025) (47746.5, 2.085) (63662, 2.13) (79577.5, 2.165) (159155, 2.28) (318310, 2.485) (397887, 2.5851)} conductivity=2000000
  steel_stainless: conductivity=1100000

design busbar1 (Q3D Extractor, model units mm)
options: SParamCalcMethod=EqTransLine Calculate_Lossy_Dielectrics
variables:
  MaterialIndex = index ArrayVarName='MaterialArray' into 0
  MaterialArray = ["copper", "aluminum", "steel_stainless"]
geometry:
  Circle1 [copper] = circle(normal=Z, centre=(31mm, 53mm, 0mm), radius=5mm)
  Circle1_1, Circle1_2 [copper] = Circle1.duplicate_along_line(step=(62mm, 0mm, 0mm), total=3)
  Circle2 [copper] = circle(normal=Z, centre=(50mm, 156mm, 0mm), radius=5mm)
  Circle2_1 [copper] = Circle2.duplicate_along_line(step=(0mm, 86mm, 0mm), total=2)
  Circle2_1_1 [copper] = Circle2_1.duplicate_along_line(step=(86mm, -32mm, 0mm), total=2)
  Circle2_2 [copper] = Circle2.duplicate_along_line(step=(86mm, -32mm, 0mm), total=2)
  Circle3 [copper] = circle(normal=Z, centre=(155mm, 25mm, 0mm), radius=5mm)
  Circle3.move_faces(MoveAlongNormalFlag=true OffsetDistance=0.6mm FacesToMove=Circle3.face(at (155, 25, 0.6)))
  Circle3_1, Circle3_2 [copper] = Circle3.duplicate_along_line(step=(-62mm, 0mm, 0mm), total=3)
  Circle3_3 [copper] = Circle3.duplicate_along_line(step=(-19mm, 131mm, 0mm), total=2)
  Circle3_3_1 [copper] = Circle3_3.duplicate_along_line(step=(0mm, 86mm, 0mm), total=2)
  Circle3_3_1_1 [copper] = Circle3_3_1.duplicate_along_line(step=(-86mm, -32mm, 0mm), total=2)
  Circle3_3_2 [copper] = Circle3_3.duplicate_along_line(step=(-86mm, -32mm, 0mm), total=2)
  Region [polyethylene] = region(percentage_offset=10 on all sides)
  BASBARNEG = imported_body()
  BASBARPOS [MaterialArray[MaterialIndex]] = imported_body()
  BASBARPOS.simplify(ObjectID=BASBARPOS Type="Polygon Fit" ExtrusionAxis=Auto Generate_Primitive_History NumberPointsCurve=10 LengthThresholdCurve=5)
  BASBARNEG.simplify(ObjectID=BASBARNEG Type="Primitive Fit" ExtrusionAxis=Auto Generate_Primitive_History NumberPointsCurve=10 LengthThresholdCurve=5)
  BASBARPOS_1 = BASBARPOS.duplicate_along_line(step=(0mm, 0mm, -0.6mm), total=2)
  BASBARNEG.intersect(BASBARPOS_1)
  BASBARNEG_1 = BASBARNEG.duplicate_along_line(step=(0mm, 0mm, 1.2mm), total=2)
  BASBARNEG_1.simplify(ObjectID=BASBARNEG_1 Type="Polygon Fit" ExtrusionAxis=Auto Cleanup Splitting Generate_Primitive_History NumberPointsCurve=3 LengthThresholdCurve=20)
  Cylinder1 = cylinder(axis=Z, base_centre=(50mm, 242mm, 0mm), radius=6mm, height=1.7mm)
  Cylinder1_1 = Cylinder1.duplicate_along_line(step=(86mm, -32mm, 0mm), total=2)
  Cylinder1_2 = Cylinder1.duplicate_along_line(step=(0mm, -86mm, 0mm), total=2)
  Cylinder1_3 = Cylinder1.duplicate_along_line(step=(86mm, -118mm, 0mm), total=2)
  Cylinder1_4 = Cylinder1.duplicate_along_line(step=(-19mm, -189mm, 0mm), total=2)
  Cylinder1_5 = Cylinder1.duplicate_along_line(step=(43mm, -189mm, 0mm), total=2)
  BUSBARNEG [MaterialArray[MaterialIndex]] = Cylinder1.duplicate_along_line(step=(105mm, -189mm, 0mm), total=2)
  Cylinder1_7 = Cylinder1.copy()
  Cylinder1_1_1 = Cylinder1_1.copy()
  Cylinder1_2_1 = Cylinder1_2.copy()
  Cylinder1_3_1 = Cylinder1_3.copy()
  Cylinder1_4_1 = Cylinder1_4.copy()
  Cylinder1_5_1 = Cylinder1_5.copy()
  Cylinder1_6_1 = BUSBARNEG.copy()
  BASBARPOS.subtract(Cylinder1_7, Cylinder1_1_1, Cylinder1_2_1, Cylinder1_3_1, Cylinder1_4_1, Cylinder1_5_1, Cylinder1_6_1)  # suppressed
  BUSBARNEG.unite(Cylinder1_5, Cylinder1_3, Cylinder1_4, Cylinder1_2, Cylinder1_1, Cylinder1, BASBARNEG_1, BASBARNEG)
  Cylinder2 = cylinder(axis=Z, base_centre=(31mm, 53mm, 0mm), radius=6.1mm, height=1.7mm)
  Cylinder2_1, Cylinder2_2 = Cylinder2.duplicate_along_line(step=(62mm, 0mm, 0mm), total=3)
  Cylinder2_3 = Cylinder2.duplicate_along_line(step=(19mm, 103mm, 0mm), total=2)
  Cylinder2_3_1 = Cylinder2_3.duplicate_along_line(step=(0mm, 86mm, 0mm), total=2)
  Cylinder2_3_2 = Cylinder2_3.duplicate_along_line(step=(86mm, -32mm, 0mm), total=2)
  Cylinder2_3_1_1 = Cylinder2_3_1.duplicate_along_line(step=(86mm, -32mm, 0mm), total=2)
  BASBARPOS.subtract(Cylinder2, Cylinder2_1, Cylinder2_2, Cylinder2_3, Cylinder2_3_1, Cylinder2_3_1_1, Cylinder2_3_2)
  group NegMos = Circle1, Circle1_1, Circle1_2
  group NegCap = Circle2, Circle2_1, Circle2_1_1, Circle2_2
  group PosMos = Circle3, Circle3_1, Circle3_2
  group PosCap = Circle3_3, Circle3_3_1, Circle3_3_1_1, Circle3_3_2
boundaries and excitations:
  BASBARPOS: SignalNet Objects=BASBARPOS
  BUSBARNEG: SignalNet Objects=BUSBARNEG
  PosSink_M1: Sink Faces=Circle3.face(at (155, 25, 0.6)) TerminalType=ConstantVoltage Net=BASBARPOS
  PosSource_C1: Source Faces=Circle3_3.face(at (136, 156, 0.6)) TerminalType=ConstantVoltage Net=BASBARPOS
  PosSource_C2: Source Faces=Circle3_3_2.face TerminalType=ConstantVoltage Net=BASBARPOS
  PosSource_C4: Source Faces=Circle3_3_1_1.face TerminalType=ConstantVoltage Net=BASBARPOS
  PosSource_C3: Source Faces=Circle3_3_1.face TerminalType=ConstantVoltage Net=BASBARPOS
  NegSource_C1: Source Faces=Circle2_2.face TerminalType=ConstantVoltage Net=BUSBARNEG
  NegSource_C2: Source Faces=Circle2.face(at (50, 156, 0)) TerminalType=ConstantVoltage Net=BUSBARNEG
  NegSource_C3: Source Faces=Circle2_1_1.face TerminalType=ConstantVoltage Net=BUSBARNEG
  NegSource_C4: Source Faces=Circle2_1.face TerminalType=ConstantVoltage Net=BUSBARNEG
  NegSink_M1: Sink Faces=Circle1_2.face TerminalType=ConstantVoltage Net=BUSBARNEG
mesh:
  initial mesh: GlobalSurfApproximation{CurvedSurfaceApproxChoice=UseSlider SliderMeshSettings=7}
setups:
  Setup1: Matrix AdaptiveFreq=1MHz SaveFields DC{Cond{MaxPass=10 MinPass=1 MinConvPass=1 PerError=1 PerRefine=30} Mult{MaxPass=1 MinPass=1 MinConvPass=1 PerError=1 PerRefine=30} AccuracyLevel=Normal} AC{MaxPass=10 MinPass=1 MinConvPass=1 PerError=1 PerRefine=30 ACRLSolverType=ACA} ConstantDelta=0s ErrorValue=0.1
    sweep Sweep1: 1Hz to 100000Hz, log, 100 per decade; Type=Discrete SaveFields
source amplitudes:
  BASBARPOS:PosSource_C1: AC R/L Fields 1A
  BASBARPOS:PosSource_C2, BASBARPOS:PosSource_C3, BASBARPOS:PosSource_C4, BUSBARNEG:NegSource_C1..BUSBARNEG:NegSource_C4: AC R/L Fields 0A
  BASBARPOS: CG Fields 1V 0deg
  BUSBARNEG: CG Fields 0V 0deg
  BASBARPOS:PosSource_C1: DC R/L Fields 1A
  BASBARPOS:PosSource_C2, BASBARPOS:PosSource_C3, BASBARPOS:PosSource_C4, BUSBARNEG:NegSource_C1..BUSBARNEG:NegSource_C4: DC R/L Fields 0A
optimetrics:
  ParametricSetup1: Parametric Sim._Setups=[Setup1]
    sweep MaterialIndex: LIN 0 2 1
output variables:
  Loop_ind_3layer = ACL(BASBARPOS:CapPos,BASBARPOS:CapPos)+ACL(BUSBARNEG:Mosfetneg,BUSBARNEG:Mosfetneg)+ACL(BUSBARNEG:Mosfetneg,BASBARPOS:CapPos)+ACL(BASBARPOS:CapPos,BUSBARNEG:Mosfetneg)
  ACR_Loop = ACR(BASBARPOS:CapPos,BASBARPOS:CapPos)+ACR(BUSBARNEG:Mosfetneg,BUSBARNEG:Mosfetneg)
field plots:
  Mag_SurfaceJac1: JAC over BASBARPOS.face(at (130.051, 20.2881, 0.85), at (130.253, 18.8801, 0.85), at (130.654, 17.515, 0.85), at (131.245, 16.2208, 0.85), at (132.014, 15.0233, 0.85), at (132.947, 13.9468, 0.85), at (134.024, 13.014, 0.85), at (135.221, 12.2446, 0.85), at (136.516, 11.6537, 0.85), at (137.881, 11.2531, 0.85), at (139.289, 11.0508, 0.85), at (155, 11, 0.85)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) on Setup1 : LastAdaptive at Freq=0.001GHz
  Mag_SurfaceJac2: JAC over BUSBARNEG.face(at (155, 11, 0.25), at (31.4175, 11, 0.25), at (93.2088, 11, 0.25), at (6.41751, 66.7072, 0.25), at (136, 252.926, 0.25), at (50, 252.926, 0.25), at (180, 66.7072, 0.25), at (93.2088, 131.963, 0.5), at (130, 56.9059, 0.25), at (129.974, 93.1681, 0.25), at (129.873, 93.8721, 0.25), at (129.673, 94.5547, 0.25)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) on Setup1 : LastAdaptive at Freq=0.001GHz
