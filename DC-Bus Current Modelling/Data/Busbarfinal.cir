* BEGIN ANSOFT HEADER
* node 1    BASBARNEG:Cap1Neg
* node 2    BASBARNEG:Cap2Neg
* node 3    BASBARNEG:Cap3Neg
* node 4    BASBARNEG:Cap4Neg
* node 5    BASBARPOS:Cap1Pos
* node 6    BASBARPOS:Cap2Pos
* node 7    BASBARPOS:Cap3Pos
* node 8    BASBARPOS:Cap4Pos
* node 9    BASBARNEG:PhANeg
* node 10   BASBARPOS:PhAPos
*  Project: Busbarfinal
*   Design: busbar-PhACaps
*   Format: Ansys Nexxim
*   Topckt: Busbarfinal
*  Creator: Ansys Electronics Desktop 2024.2.0
*     Date: Thu Nov 14 13:46:35 2024
* END ANSOFT HEADER

.subckt Busbarfinal 1 2 3 4 5 6 7 8 9 10
X1 1 2 3 4 5 6 7 8 9 9 9 9 10 10 10 10 Busbarfinal_series

.subckt Busbarfinal_series 1 2 3 4 5 6 7 8 9 10 11 12 13 14 15 16
V1 1 17 dc 0.0
V2 2 18 dc 0.0
V3 3 19 dc 0.0
V4 4 20 dc 0.0
V5 5 21 dc 0.0
V6 6 22 dc 0.0
V7 7 23 dc 0.0
V8 8 24 dc 0.0
R1 17 25 0.000173292990355
R2 18 26 0.000515629092596
R3 19 27 0.000826536666036
R4 20 28 0.000449981704834
R5 21 29 0.000440599425125
R6 22 30 0.000581975367987
R7 23 31 0.000898219627841
R8 24 32 0.00079369216521
F1_2 25 17 V2 1.05933
F1_3 25 17 V3 1.14823
F1_4 25 17 V4 1.14342
F1_5 25 17 V5 0.72947
F1_6 25 17 V6 0.692906
F1_7 25 17 V7 0.802781
F1_8 25 17 V8 0.862926
F2_1 26 18 V1 0.356021
F2_3 26 18 V3 1.06445
F2_4 26 18 V4 0.434399
F2_5 26 18 V5 0.296627
F2_6 26 18 V6 0.529082
F2_7 26 18 V7 0.682682
F2_8 26 18 V8 0.353867
F3_1 27 19 V1 0.240739
F3_2 27 19 V2 0.664052
F3_4 27 19 V4 0.324211
F3_5 27 19 V5 0.224176
F3_6 27 19 V6 0.361713
F3_7 27 19 V7 0.583124
F3_8 27 19 V8 0.299217
F4_1 28 20 V1 0.440343
F4_2 28 20 V2 0.497773
F4_3 28 20 V3 0.595518
F4_5 28 20 V5 0.483933
F4_6 28 20 V6 0.348379
F4_7 28 20 V7 0.461226
F4_8 28 20 V8 0.742878
F5_1 29 21 V1 0.286909
F5_2 29 21 V2 0.34714
F5_3 29 21 V3 0.42054
F5_4 29 21 V4 0.494238
F5_6 29 21 V6 0.780678
F5_7 29 21 V7 0.87166
F5_8 29 21 V8 1.1061
F6_1 30 22 V1 0.206324
F6_2 30 22 V2 0.468766
F6_3 30 22 V3 0.513714
F6_4 30 22 V4 0.269366
F6_5 30 22 V5 0.591033
F6_7 30 22 V7 1.04405
F6_8 30 22 V8 0.637478
F7_1 31 23 V1 0.15488
F7_2 31 23 V2 0.391898
F7_3 31 23 V3 0.536587
F7_4 31 23 V4 0.231061
F7_5 31 23 V5 0.427571
F7_6 31 23 V6 0.676462
F7_8 31 23 V8 0.493259
F8_1 32 24 V1 0.188409
F8_2 32 24 V2 0.229893
F8_3 32 24 V3 0.311599
F8_4 32 24 V4 0.421173
F8_5 32 24 V5 0.614028
F8_6 32 24 V6 0.467431
F8_7 32 24 V7 0.55822
L1 25 9 1.86420629624e-08
L2 26 10 4.57897261381e-08
L3 27 11 6.96731118302e-08
L4 28 12 4.23240540509e-08
L5 29 13 3.22429295585e-08
L6 30 14 4.63856623601e-08
L7 31 15 6.77705398417e-08
L8 32 16 5.79228368568e-08
K1_2 L1 L2 0.628312
K1_3 L1 L3 0.544448
K1_4 L1 L4 0.752029
K1_5 L1 L5 0.846421
K1_6 L1 L6 0.634264
K1_7 L1 L7 0.571307
K1_8 L1 L8 0.686588
K2_3 L2 L3 0.853739
K2_4 L2 L4 0.510787
K2_5 L2 L5 0.557106
K2_6 L2 L6 0.901542
K2_7 L2 L7 0.869635
K2_8 L2 L8 0.467566
K3_4 L3 L4 0.482626
K3_5 L3 L5 0.498287
K3_6 L3 L6 0.75556
K3_7 L3 L7 0.930893
K3_8 L3 L8 0.454677
K4_5 L4 L5 0.798885
K4_6 L4 L6 0.503272
K4_7 L4 L7 0.496654
K4_8 L4 L8 0.915741
K5_6 L5 L6 0.659908
K5_7 L5 L7 0.606713
K5_8 L5 L8 0.824182
K6_7 L6 L7 0.849876
K6_8 L6 L8 0.536394
K7_8 L7 L8 0.528406
.ends Busbarfinal_series
.ends Busbarfinal
